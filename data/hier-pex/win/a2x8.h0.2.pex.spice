* A2x8 - parasitic extraction by OpenLayout (openlayout pex, mode rc)
* layout: /tmp/xs/a2x8.gds
* C: FasterCap 3D field solver (k = 4.6 front end, 3.23 above z = 0.074 um); R: KLayout RNetExtractor, reference sheet / via resistances
* 160 transistors, 446 resistors, 4317 capacitors
* total capacitance per net (fF): BLB_0 0.2366, BLB_1 0.2361, BLB_2 0.2361, BLB_3 0.2361, BLB_4 0.2361, BLB_5 0.2361, BLB_6 0.2361, BLB_7 0.2326, BL_0 0.1695, BL_1 0.1759, BL_2 0.1759, BL_3 0.1759, BL_4 0.1759, BL_5 0.1759, BL_6 0.1759, BL_7 0.1761, P_0_0 0.1915, P_0_1 0.1914, P_0_2 0.1914, P_0_3 0.1914, P_0_4 0.1914, P_0_5 0.1914, P_0_6 0.1914, P_0_7 0.1914, P_1_0 0.1922, P_1_1 0.1926, P_1_2 0.1926, P_1_3 0.1926, P_1_4 0.1926, P_1_5 0.1926, P_1_6 0.1926, P_1_7 0.1918, VDD_1 2.3720, VSS_0 6.2903, VSS_2 1.6176, WL_0 2.7058, WL_1 2.7031, XB_0_0 0.1717, XB_0_1 0.1716, XB_0_2 0.1716, XB_0_3 0.1716, XB_0_4 0.1716, XB_0_5 0.1716, XB_0_6 0.1716, XB_0_7 0.1702, XB_1_0 0.1701, XB_1_1 0.1704, XB_1_2 0.1704, XB_1_3 0.1704, XB_1_4 0.1704, XB_1_5 0.1704, XB_1_6 0.1704, XB_1_7 0.1692, net10 0.2581, net11 0.4700, net13 0.2581, net133 0.4673, net134 0.4690, net136 0.4690, net137 0.4690, net139 0.4690, net14 0.4700, net141 0.4690, net142 0.4690, net144 0.4679, net16 0.2581, net17 0.4700, net20 0.2581, net21 0.4700, net23 0.2581, net24 0.4700, net27 0.2582, net28 0.4693, net3 0.2576, net4 0.4690, net6 0.2581, net67 0.0587, net68 0.0586, net69 0.0586, net7 0.4700, net70 0.0586, net71 0.0586, net72 0.0586, net73 0.0586, net74 0.0584, net76 0.2571, net78 0.0580, net79 0.2573, net81 0.0580, net82 0.2572, net84 0.0580, net85 0.2572, net87 0.0580, net88 0.2572, net90 0.0580, net91 0.2572, net93 0.0580, net94 0.2572, net96 0.0580, net97 0.2570, net99 0.0578

.subckt A2x8 BLB_0 BLB_1 BLB_2 BLB_3 BLB_4 BLB_5 BLB_6 BLB_7 BL_0 BL_1 BL_2 BL_3 BL_4 BL_5 BL_6 BL_7 P_0_0 P_0_1 P_0_2 P_0_3 P_0_4 P_0_5 P_0_6 P_0_7 P_1_0 P_1_1 P_1_2 P_1_3 P_1_4 P_1_5 P_1_6 P_1_7 VDD_1 VSS_0 VSS_2 WL_0 WL_1 XB_0_0 XB_0_1 XB_0_2 XB_0_3 XB_0_4 XB_0_5 XB_0_6 XB_0_7 XB_1_0 XB_1_1 XB_1_2 XB_1_3 XB_1_4 XB_1_5 XB_1_6 XB_1_7
N1 net3_4 WL_0_16 BL_0_1 VSS_0 nmos_sram l=20n nfin=2
N2 VSS_0 net4_5 net3_4 VSS_0 nmos_sram l=20n nfin=2
N3 net4_9 net3_2 VSS_0 VSS_0 nmos_sram l=20n nfin=2
N4 BLB_0_1 WL_0_17 net4_9 VSS_0 nmos_sram l=20n nfin=2
N5 VSS_0 net4_7 P_0_0_3 VSS_0 nmos_sram l=20n nfin=1
N6 P_0_0_4 XB_0_0_2 VSS_0 VSS_0 nmos_sram l=20n nfin=1
N7 net6_4 WL_0_18 BL_1_1 VSS_0 nmos_sram l=20n nfin=2
N8 VSS_0 net7_5 net6_4 VSS_0 nmos_sram l=20n nfin=2
N9 net7_9 net6_2 VSS_0 VSS_0 nmos_sram l=20n nfin=2
N10 BLB_1_1 WL_0_19 net7_9 VSS_0 nmos_sram l=20n nfin=2
N11 VSS_0 net7_7 P_0_1_3 VSS_0 nmos_sram l=20n nfin=1
N12 P_0_1_4 XB_0_1_2 VSS_0 VSS_0 nmos_sram l=20n nfin=1
N13 net10_4 WL_0_20 BL_2_1 VSS_0 nmos_sram l=20n nfin=2
N14 VSS_0 net11_5 net10_4 VSS_0 nmos_sram l=20n nfin=2
N15 net11_9 net10_2 VSS_0 VSS_0 nmos_sram l=20n nfin=2
N16 BLB_2_1 WL_0_21 net11_9 VSS_0 nmos_sram l=20n nfin=2
N17 VSS_0 net11_7 P_0_2_3 VSS_0 nmos_sram l=20n nfin=1
N18 P_0_2_4 XB_0_2_2 VSS_0 VSS_0 nmos_sram l=20n nfin=1
N19 net13_4 WL_0_22 BL_3_1 VSS_0 nmos_sram l=20n nfin=2
N20 VSS_0 net14_5 net13_4 VSS_0 nmos_sram l=20n nfin=2
N21 net14_9 net13_2 VSS_0 VSS_0 nmos_sram l=20n nfin=2
N22 BLB_3_1 WL_0_23 net14_9 VSS_0 nmos_sram l=20n nfin=2
N23 VSS_0 net14_7 P_0_3_3 VSS_0 nmos_sram l=20n nfin=1
N24 P_0_3_4 XB_0_3_2 VSS_0 VSS_0 nmos_sram l=20n nfin=1
N25 net16_4 WL_0_24 BL_4_1 VSS_0 nmos_sram l=20n nfin=2
N26 VSS_0 net17_5 net16_4 VSS_0 nmos_sram l=20n nfin=2
N27 net17_9 net16_2 VSS_0 VSS_0 nmos_sram l=20n nfin=2
N28 BLB_4_1 WL_0_25 net17_9 VSS_0 nmos_sram l=20n nfin=2
N29 VSS_0 net17_7 P_0_4_3 VSS_0 nmos_sram l=20n nfin=1
N30 P_0_4_4 XB_0_4_2 VSS_0 VSS_0 nmos_sram l=20n nfin=1
N31 net20_4 WL_0_26 BL_5_1 VSS_0 nmos_sram l=20n nfin=2
N32 VSS_0 net21_5 net20_4 VSS_0 nmos_sram l=20n nfin=2
N33 net21_9 net20_2 VSS_0 VSS_0 nmos_sram l=20n nfin=2
N34 BLB_5_1 WL_0_27 net21_9 VSS_0 nmos_sram l=20n nfin=2
N35 VSS_0 net21_7 P_0_5_3 VSS_0 nmos_sram l=20n nfin=1
N36 P_0_5_4 XB_0_5_2 VSS_0 VSS_0 nmos_sram l=20n nfin=1
N37 net23_4 WL_0_28 BL_6_1 VSS_0 nmos_sram l=20n nfin=2
N38 VSS_0 net24_5 net23_4 VSS_0 nmos_sram l=20n nfin=2
N39 net24_9 net23_2 VSS_0 VSS_0 nmos_sram l=20n nfin=2
N40 BLB_6_1 WL_0_29 net24_9 VSS_0 nmos_sram l=20n nfin=2
N41 VSS_0 net24_7 P_0_6_3 VSS_0 nmos_sram l=20n nfin=1
N42 P_0_6_4 XB_0_6_2 VSS_0 VSS_0 nmos_sram l=20n nfin=1
N43 net27_4 WL_0_30 BL_7_1 VSS_0 nmos_sram l=20n nfin=2
N44 VSS_0 net28_5 net27_4 VSS_0 nmos_sram l=20n nfin=2
N45 net28_9 net27_2 VSS_0 VSS_0 nmos_sram l=20n nfin=2
N46 BLB_7_1 WL_0_31 net28_9 VSS_0 nmos_sram l=20n nfin=2
N47 VSS_0 net28_7 P_0_7_3 VSS_0 nmos_sram l=20n nfin=1
N48 P_0_7_4 XB_0_7_2 VSS_0 VSS_0 nmos_sram l=20n nfin=1
N49 net76_5 WL_1_16 BL_0_2 VSS_0 nmos_sram l=20n nfin=2
N50 VSS_2 net133_5 net76_5 VSS_0 nmos_sram l=20n nfin=2
N51 net133_10 net76_2 VSS_2 VSS_0 nmos_sram l=20n nfin=2
N52 BLB_0_2 WL_1_17 net133_10 VSS_0 nmos_sram l=20n nfin=2
N53 net79_5 WL_1_18 BL_1_2 VSS_0 nmos_sram l=20n nfin=2
N54 VSS_2 net134_5 net79_5 VSS_0 nmos_sram l=20n nfin=2
N55 net134_10 net79_2 VSS_2 VSS_0 nmos_sram l=20n nfin=2
N56 BLB_1_2 WL_1_19 net134_10 VSS_0 nmos_sram l=20n nfin=2
N57 net82_5 WL_1_20 BL_2_2 VSS_0 nmos_sram l=20n nfin=2
N58 VSS_2 net136_5 net82_5 VSS_0 nmos_sram l=20n nfin=2
N59 net136_10 net82_2 VSS_2 VSS_0 nmos_sram l=20n nfin=2
N60 BLB_2_2 WL_1_21 net136_10 VSS_0 nmos_sram l=20n nfin=2
N61 net85_5 WL_1_22 BL_3_2 VSS_0 nmos_sram l=20n nfin=2
N62 VSS_2 net137_5 net85_5 VSS_0 nmos_sram l=20n nfin=2
N63 net137_10 net85_2 VSS_2 VSS_0 nmos_sram l=20n nfin=2
N64 BLB_3_2 WL_1_23 net137_10 VSS_0 nmos_sram l=20n nfin=2
N65 net88_5 WL_1_24 BL_4_2 VSS_0 nmos_sram l=20n nfin=2
N66 VSS_2 net139_5 net88_5 VSS_0 nmos_sram l=20n nfin=2
N67 net139_10 net88_2 VSS_2 VSS_0 nmos_sram l=20n nfin=2
N68 BLB_4_2 WL_1_25 net139_10 VSS_0 nmos_sram l=20n nfin=2
N69 net91_5 WL_1_26 BL_5_2 VSS_0 nmos_sram l=20n nfin=2
N70 VSS_2 net141_5 net91_5 VSS_0 nmos_sram l=20n nfin=2
N71 net141_10 net91_2 VSS_2 VSS_0 nmos_sram l=20n nfin=2
N72 BLB_5_2 WL_1_27 net141_10 VSS_0 nmos_sram l=20n nfin=2
N73 net94_5 WL_1_28 BL_6_2 VSS_0 nmos_sram l=20n nfin=2
N74 VSS_2 net142_5 net94_5 VSS_0 nmos_sram l=20n nfin=2
N75 net142_10 net94_2 VSS_2 VSS_0 nmos_sram l=20n nfin=2
N76 BLB_6_2 WL_1_29 net142_10 VSS_0 nmos_sram l=20n nfin=2
N77 net97_5 WL_1_30 BL_7_2 VSS_0 nmos_sram l=20n nfin=2
N78 VSS_2 net144_5 net97_5 VSS_0 nmos_sram l=20n nfin=2
N79 net144_10 net97_2 VSS_2 VSS_0 nmos_sram l=20n nfin=2
N80 BLB_7_2 WL_1_31 net144_10 VSS_0 nmos_sram l=20n nfin=2
N81 VSS_2 net133_7 P_1_0_4 VSS_0 nmos_sram l=20n nfin=1
N82 P_1_0_5 XB_1_0_2 VSS_2 VSS_0 nmos_sram l=20n nfin=1
N83 VSS_2 net134_7 P_1_1_4 VSS_0 nmos_sram l=20n nfin=1
N84 P_1_1_5 XB_1_1_2 VSS_2 VSS_0 nmos_sram l=20n nfin=1
N85 VSS_2 net136_7 P_1_2_4 VSS_0 nmos_sram l=20n nfin=1
N86 P_1_2_5 XB_1_2_2 VSS_2 VSS_0 nmos_sram l=20n nfin=1
N87 VSS_2 net137_7 P_1_3_4 VSS_0 nmos_sram l=20n nfin=1
N88 P_1_3_5 XB_1_3_2 VSS_2 VSS_0 nmos_sram l=20n nfin=1
N89 VSS_2 net139_7 P_1_4_4 VSS_0 nmos_sram l=20n nfin=1
N90 P_1_4_5 XB_1_4_2 VSS_2 VSS_0 nmos_sram l=20n nfin=1
N91 VSS_2 net141_7 P_1_5_4 VSS_0 nmos_sram l=20n nfin=1
N92 P_1_5_5 XB_1_5_2 VSS_2 VSS_0 nmos_sram l=20n nfin=1
N93 VSS_2 net142_7 P_1_6_4 VSS_0 nmos_sram l=20n nfin=1
N94 P_1_6_5 XB_1_6_2 VSS_2 VSS_0 nmos_sram l=20n nfin=1
N95 VSS_2 net144_7 P_1_7_4 VSS_0 nmos_sram l=20n nfin=1
N96 P_1_7_5 XB_1_7_2 VSS_2 VSS_0 nmos_sram l=20n nfin=1
N97 VDD_1 net4_6 net3_6 VDD_1 pmos_sram l=20n nfin=1
N98 net4_11 net3_3 VDD_1 VDD_1 pmos_sram l=20n nfin=1
N99 net67 net4_8 P_0_0_5 VDD_1 pmos_sram l=20n nfin=2
N100 VDD_1 XB_0_0_3 net67 VDD_1 pmos_sram l=20n nfin=2
N101 VDD_1 net7_6 net6_6 VDD_1 pmos_sram l=20n nfin=1
N102 net7_11 net6_3 VDD_1 VDD_1 pmos_sram l=20n nfin=1
N103 net68 net7_8 P_0_1_5 VDD_1 pmos_sram l=20n nfin=2
N104 VDD_1 XB_0_1_3 net68 VDD_1 pmos_sram l=20n nfin=2
N105 VDD_1 net11_6 net10_6 VDD_1 pmos_sram l=20n nfin=1
N106 net11_11 net10_3 VDD_1 VDD_1 pmos_sram l=20n nfin=1
N107 net69 net11_8 P_0_2_5 VDD_1 pmos_sram l=20n nfin=2
N108 VDD_1 XB_0_2_3 net69 VDD_1 pmos_sram l=20n nfin=2
N109 VDD_1 net14_6 net13_6 VDD_1 pmos_sram l=20n nfin=1
N110 net14_11 net13_3 VDD_1 VDD_1 pmos_sram l=20n nfin=1
N111 net70 net14_8 P_0_3_5 VDD_1 pmos_sram l=20n nfin=2
N112 VDD_1 XB_0_3_3 net70 VDD_1 pmos_sram l=20n nfin=2
N113 VDD_1 net17_6 net16_6 VDD_1 pmos_sram l=20n nfin=1
N114 net17_11 net16_3 VDD_1 VDD_1 pmos_sram l=20n nfin=1
N115 net71 net17_8 P_0_4_5 VDD_1 pmos_sram l=20n nfin=2
N116 VDD_1 XB_0_4_3 net71 VDD_1 pmos_sram l=20n nfin=2
N117 VDD_1 net21_6 net20_6 VDD_1 pmos_sram l=20n nfin=1
N118 net21_11 net20_3 VDD_1 VDD_1 pmos_sram l=20n nfin=1
N119 net72 net21_8 P_0_5_5 VDD_1 pmos_sram l=20n nfin=2
N120 VDD_1 XB_0_5_3 net72 VDD_1 pmos_sram l=20n nfin=2
N121 VDD_1 net24_6 net23_6 VDD_1 pmos_sram l=20n nfin=1
N122 net24_11 net23_3 VDD_1 VDD_1 pmos_sram l=20n nfin=1
N123 net73 net24_8 P_0_6_5 VDD_1 pmos_sram l=20n nfin=2
N124 VDD_1 XB_0_6_3 net73 VDD_1 pmos_sram l=20n nfin=2
N125 VDD_1 net28_6 net27_6 VDD_1 pmos_sram l=20n nfin=1
N126 net28_11 net27_3 VDD_1 VDD_1 pmos_sram l=20n nfin=1
N127 net74 net28_8 P_0_7_5 VDD_1 pmos_sram l=20n nfin=2
N128 VDD_1 XB_0_7_3 net74 VDD_1 pmos_sram l=20n nfin=2
N129 VDD_1 net133_6 net76_4 VDD_1 pmos_sram l=20n nfin=1
N130 net133_9 net76_3 VDD_1 VDD_1 pmos_sram l=20n nfin=1
N131 net78 net133_8 P_1_0_3 VDD_1 pmos_sram l=20n nfin=2
N132 VDD_1 XB_1_0_3 net78 VDD_1 pmos_sram l=20n nfin=2
N133 VDD_1 net134_6 net79_4 VDD_1 pmos_sram l=20n nfin=1
N134 net134_9 net79_3 VDD_1 VDD_1 pmos_sram l=20n nfin=1
N135 net81 net134_8 P_1_1_3 VDD_1 pmos_sram l=20n nfin=2
N136 VDD_1 XB_1_1_3 net81 VDD_1 pmos_sram l=20n nfin=2
N137 VDD_1 net136_6 net82_4 VDD_1 pmos_sram l=20n nfin=1
N138 net136_9 net82_3 VDD_1 VDD_1 pmos_sram l=20n nfin=1
N139 net84 net136_8 P_1_2_3 VDD_1 pmos_sram l=20n nfin=2
N140 VDD_1 XB_1_2_3 net84 VDD_1 pmos_sram l=20n nfin=2
N141 VDD_1 net137_6 net85_4 VDD_1 pmos_sram l=20n nfin=1
N142 net137_9 net85_3 VDD_1 VDD_1 pmos_sram l=20n nfin=1
N143 net87 net137_8 P_1_3_3 VDD_1 pmos_sram l=20n nfin=2
N144 VDD_1 XB_1_3_3 net87 VDD_1 pmos_sram l=20n nfin=2
N145 VDD_1 net139_6 net88_4 VDD_1 pmos_sram l=20n nfin=1
N146 net139_9 net88_3 VDD_1 VDD_1 pmos_sram l=20n nfin=1
N147 net90 net139_8 P_1_4_3 VDD_1 pmos_sram l=20n nfin=2
N148 VDD_1 XB_1_4_3 net90 VDD_1 pmos_sram l=20n nfin=2
N149 VDD_1 net141_6 net91_4 VDD_1 pmos_sram l=20n nfin=1
N150 net141_9 net91_3 VDD_1 VDD_1 pmos_sram l=20n nfin=1
N151 net93 net141_8 P_1_5_3 VDD_1 pmos_sram l=20n nfin=2
N152 VDD_1 XB_1_5_3 net93 VDD_1 pmos_sram l=20n nfin=2
N153 VDD_1 net142_6 net94_4 VDD_1 pmos_sram l=20n nfin=1
N154 net142_9 net94_3 VDD_1 VDD_1 pmos_sram l=20n nfin=1
N155 net96 net142_8 P_1_6_3 VDD_1 pmos_sram l=20n nfin=2
N156 VDD_1 XB_1_6_3 net96 VDD_1 pmos_sram l=20n nfin=2
N157 VDD_1 net144_6 net97_4 VDD_1 pmos_sram l=20n nfin=1
N158 net144_9 net97_3 VDD_1 VDD_1 pmos_sram l=20n nfin=1
N159 net99 net144_8 P_1_7_3 VDD_1 pmos_sram l=20n nfin=2
N160 VDD_1 XB_1_7_3 net99 VDD_1 pmos_sram l=20n nfin=2
R1 BL_0 BL_0_1 68.2426
R2 BL_0 BL_0_2 149.381
R3 net3_3 net3 34.1846
R4 net3 net3_2 25.5109
R5 net3_4 net3_7 39.8169
R6 net3_6 net3_7 43.642
R7 net3_7 net3 44.6984
R8 net4_6 net4 34.1846
R9 net4 net4_5 25.5109
R10 net4_8 net4_2 29.5926
R11 net4_2 net4_7 30.1028
R12 net4_4 net4_3 6.2952
R13 net4 net4_4 127.497
R14 net4_2 net4_3 90.749
R15 net4_9 net4_4 98.7906
R16 net4_3 net4_11 70.7246
R17 BLB_0_1 BLB_0 151.187
R18 BLB_0_2 BLB_0 174.968
R19 net6_3 net6 34.1846
R20 net6 net6_2 25.5109
R21 net6_4 net6_7 39.8169
R22 net6_6 net6_7 43.642
R23 net6_7 net6 44.6984
R24 net7_6 net7 34.1846
R25 net7 net7_5 25.5109
R26 net7_8 net7_2 29.5926
R27 net7_2 net7_7 30.1028
R28 net7_4 net7_3 6.2952
R29 net7 net7_4 127.497
R30 net7_2 net7_3 90.749
R31 net7_9 net7_4 98.7906
R32 net7_3 net7_11 70.7246
R33 BLB_1_1 BLB_1 151.187
R34 BLB_1_2 BLB_1 174.968
R35 BL_2 BL_2_1 68.2426
R36 BL_2 BL_2_2 149.381
R37 net10_3 net10 34.1846
R38 net10 net10_2 25.5109
R39 net10_4 net10_7 39.8169
R40 net10_6 net10_7 43.642
R41 net10_7 net10 44.6984
R42 net11_6 net11 34.1846
R43 net11 net11_5 25.5109
R44 net11_8 net11_2 29.5926
R45 net11_2 net11_7 30.1028
R46 net11_4 net11_3 6.2952
R47 net11 net11_4 127.497
R48 net11_2 net11_3 90.749
R49 net11_9 net11_4 98.7906
R50 net11_3 net11_11 70.7246
R51 BLB_2_1 BLB_2 151.187
R52 BLB_2_2 BLB_2 174.968
R53 net13_3 net13 34.1846
R54 net13 net13_2 25.5109
R55 net13_4 net13_7 39.8169
R56 net13_6 net13_7 43.642
R57 net13_7 net13 44.6984
R58 net14_6 net14 34.1846
R59 net14 net14_5 25.5109
R60 net14_8 net14_2 29.5926
R61 net14_2 net14_7 30.1028
R62 net14_4 net14_3 6.2952
R63 net14 net14_4 127.497
R64 net14_2 net14_3 90.749
R65 net14_9 net14_4 98.7906
R66 net14_3 net14_11 70.7246
R67 BLB_3_1 BLB_3 151.187
R68 BLB_3_2 BLB_3 174.968
R69 net16_3 net16 34.1846
R70 net16 net16_2 25.5109
R71 net16_4 net16_7 39.8169
R72 net16_6 net16_7 43.642
R73 net16_7 net16 44.6984
R74 net17_6 net17 34.1846
R75 net17 net17_5 25.5109
R76 net17_8 net17_2 29.5926
R77 net17_2 net17_7 30.1028
R78 net17_4 net17_3 6.2952
R79 net17 net17_4 127.497
R80 net17_2 net17_3 90.749
R81 net17_9 net17_4 98.7906
R82 net17_3 net17_11 70.7246
R83 BLB_4_1 BLB_4 151.187
R84 BLB_4_2 BLB_4 174.968
R85 BL_5 BL_5_1 68.2426
R86 BL_5 BL_5_2 149.381
R87 net20_3 net20 34.1846
R88 net20 net20_2 25.5109
R89 net20_4 net20_7 39.8169
R90 net20_6 net20_7 43.642
R91 net20_7 net20 44.6984
R92 net21_6 net21 34.1846
R93 net21 net21_5 25.5109
R94 net21_8 net21_2 29.5926
R95 net21_2 net21_7 30.1028
R96 net21_4 net21_3 6.2952
R97 net21 net21_4 127.497
R98 net21_2 net21_3 90.749
R99 net21_9 net21_4 98.7906
R100 net21_3 net21_11 70.7246
R101 BLB_5_1 BLB_5 151.187
R102 BLB_5_2 BLB_5 174.968
R103 net23_3 net23 34.1846
R104 net23 net23_2 25.5109
R105 net23_4 net23_7 39.8169
R106 net23_6 net23_7 43.642
R107 net23_7 net23 44.6984
R108 net24_6 net24 34.1846
R109 net24 net24_5 25.5109
R110 net24_8 net24_2 29.5926
R111 net24_2 net24_7 30.1028
R112 net24_4 net24_3 6.2952
R113 net24 net24_4 127.497
R114 net24_2 net24_3 90.749
R115 net24_9 net24_4 98.7906
R116 net24_3 net24_11 70.7246
R117 BLB_6_1 BLB_6 151.187
R118 BLB_6_2 BLB_6 174.968
R119 BL_7 BL_7_1 68.2426
R120 BL_7 BL_7_2 149.381
R121 net27_3 net27 34.1846
R122 net27 net27_2 25.5109
R123 net27_4 net27_7 39.8169
R124 net27_6 net27_7 43.642
R125 net27_7 net27 44.6984
R126 net28_6 net28 34.1846
R127 net28 net28_5 25.5109
R128 net28_8 net28_2 29.5926
R129 net28_2 net28_7 30.1028
R130 net28_4 net28_3 6.2952
R131 net28 net28_4 127.497
R132 net28_2 net28_3 90.749
R133 net28_9 net28_4 98.7906
R134 net28_3 net28_11 70.7246
R135 BLB_7_1 BLB_7 151.187
R136 BLB_7_2 BLB_7 174.968
R137 P_0_0_1 P_0_0_2 27.5015
R138 P_0_0_1 P_0_0_3 20.424
R139 P_0_0_4 P_0_0_1 45.6048
R140 P_0_0_5 P_0_0_2 68.5329
R141 P_0_0 P_0_0_2 43.5
R142 XB_0_0_3 XB_0_0_1 36.7357
R143 XB_0_0_1 XB_0_0_2 22.9598
R144 XB_0_0 XB_0_0_1 109.677
R145 BL_1 BL_1_1 68.2426
R146 BL_1 BL_1_2 149.381
R147 P_0_1_1 P_0_1_2 27.5015
R148 P_0_1_1 P_0_1_3 20.424
R149 P_0_1_4 P_0_1_1 45.6048
R150 P_0_1_5 P_0_1_2 68.5329
R151 P_0_1 P_0_1_2 43.5
R152 XB_0_1_3 XB_0_1_1 36.7357
R153 XB_0_1_1 XB_0_1_2 22.9598
R154 XB_0_1 XB_0_1_1 109.677
R155 P_0_2_1 P_0_2_2 27.5015
R156 P_0_2_1 P_0_2_3 20.424
R157 P_0_2_4 P_0_2_1 45.6048
R158 P_0_2_5 P_0_2_2 68.5329
R159 P_0_2 P_0_2_2 43.5
R160 XB_0_2_3 XB_0_2_1 36.7357
R161 XB_0_2_1 XB_0_2_2 22.9598
R162 XB_0_2 XB_0_2_1 109.677
R163 BL_3 BL_3_1 68.2426
R164 BL_3 BL_3_2 149.381
R165 P_0_3_1 P_0_3_2 27.5015
R166 P_0_3_1 P_0_3_3 20.424
R167 P_0_3_4 P_0_3_1 45.6048
R168 P_0_3_5 P_0_3_2 68.5329
R169 P_0_3 P_0_3_2 43.5
R170 XB_0_3_3 XB_0_3_1 36.7357
R171 XB_0_3_1 XB_0_3_2 22.9598
R172 XB_0_3 XB_0_3_1 109.677
R173 BL_4 BL_4_1 68.2426
R174 BL_4 BL_4_2 149.381
R175 P_0_4_1 P_0_4_2 27.5015
R176 P_0_4_1 P_0_4_3 20.424
R177 P_0_4_4 P_0_4_1 45.6048
R178 P_0_4_5 P_0_4_2 68.5329
R179 P_0_4 P_0_4_2 43.5
R180 XB_0_4_3 XB_0_4_1 36.7357
R181 XB_0_4_1 XB_0_4_2 22.9598
R182 XB_0_4 XB_0_4_1 109.677
R183 P_0_5_1 P_0_5_2 27.5015
R184 P_0_5_1 P_0_5_3 20.424
R185 P_0_5_4 P_0_5_1 45.6048
R186 P_0_5_5 P_0_5_2 68.5329
R187 P_0_5 P_0_5_2 43.5
R188 XB_0_5_3 XB_0_5_1 36.7357
R189 XB_0_5_1 XB_0_5_2 22.9598
R190 XB_0_5 XB_0_5_1 109.677
R191 BL_6 BL_6_1 68.2426
R192 BL_6 BL_6_2 149.381
R193 P_0_6_1 P_0_6_2 27.5015
R194 P_0_6_1 P_0_6_3 20.424
R195 P_0_6_4 P_0_6_1 45.6048
R196 P_0_6_5 P_0_6_2 68.5329
R197 P_0_6 P_0_6_2 43.5
R198 XB_0_6_3 XB_0_6_1 36.7357
R199 XB_0_6_1 XB_0_6_2 22.9598
R200 XB_0_6 XB_0_6_1 109.677
R201 P_0_7_1 P_0_7_2 27.5015
R202 P_0_7_1 P_0_7_3 20.424
R203 P_0_7_4 P_0_7_1 45.6048
R204 P_0_7_5 P_0_7_2 68.5329
R205 P_0_7 P_0_7_2 43.5
R206 XB_0_7_3 XB_0_7_1 36.7357
R207 XB_0_7_1 XB_0_7_2 22.9598
R208 XB_0_7 XB_0_7_1 109.677
R209 WL_0 WL_0_9 35.4396
R210 WL_0_9 WL_0_10 125.904
R211 WL_0_10 WL_0_11 125.904
R212 WL_0_11 WL_0_12 125.904
R213 WL_0_12 WL_0_13 125.904
R214 WL_0_13 WL_0_14 125.904
R215 WL_0_14 WL_0_15 125.904
R216 WL_0_1 WL_0_9 38.915
R217 WL_0_2 WL_0_10 38.915
R218 WL_0_3 WL_0_11 38.915
R219 WL_0_4 WL_0_12 38.915
R220 WL_0_5 WL_0_13 38.915
R221 WL_0_6 WL_0_14 38.915
R222 WL_0_7 WL_0_15 38.915
R223 WL_0_16 WL_0_1 83.7722
R224 WL_0_17 WL_0_1 84.6073
R225 WL_0_18 WL_0_2 83.7722
R226 WL_0_19 WL_0_2 84.6073
R227 WL_0_20 WL_0_3 83.7722
R228 WL_0_21 WL_0_3 84.6073
R229 WL_0_22 WL_0_4 83.7722
R230 WL_0_23 WL_0_4 84.6073
R231 WL_0_24 WL_0_5 83.7722
R232 WL_0_25 WL_0_5 84.6073
R233 WL_0_26 WL_0_6 83.7722
R234 WL_0_27 WL_0_6 84.6073
R235 WL_0_28 WL_0_7 83.7722
R236 WL_0_29 WL_0_7 84.6073
R237 WL_0_30 WL_0_8 83.7722
R238 WL_0_31 WL_0_8 84.6073
R239 WL_0_15 WL_0_8 164.819
R240 net76_2 net76 25.5109
R241 net76 net76_3 34.1846
R242 net76_4 net76_7 43.642
R243 net76_5 net76_7 39.8169
R244 net76_7 net76 44.6984
R245 P_1_0_2 P_1_0_1 27.5015
R246 P_1_0_3 P_1_0_2 68.5329
R247 P_1_0_1 P_1_0_4 20.424
R248 P_1_0_5 P_1_0_1 45.6048
R249 P_1_0 P_1_0_2 43.5
R250 net79_2 net79 25.5109
R251 net79 net79_3 34.1846
R252 net79_4 net79_7 43.642
R253 net79_5 net79_7 39.8169
R254 net79_7 net79 44.6984
R255 P_1_1_2 P_1_1_1 27.5015
R256 P_1_1_3 P_1_1_2 68.5329
R257 P_1_1_1 P_1_1_4 20.424
R258 P_1_1_5 P_1_1_1 45.6048
R259 P_1_1 P_1_1_2 43.5
R260 net82_2 net82 25.5109
R261 net82 net82_3 34.1846
R262 net82_4 net82_7 43.642
R263 net82_5 net82_7 39.8169
R264 net82_7 net82 44.6984
R265 P_1_2_2 P_1_2_1 27.5015
R266 P_1_2_3 P_1_2_2 68.5329
R267 P_1_2_1 P_1_2_4 20.424
R268 P_1_2_5 P_1_2_1 45.6048
R269 P_1_2 P_1_2_2 43.5
R270 net85_2 net85 25.5109
R271 net85 net85_3 34.1846
R272 net85_4 net85_7 43.642
R273 net85_5 net85_7 39.8169
R274 net85_7 net85 44.6984
R275 P_1_3_2 P_1_3_1 27.5015
R276 P_1_3_3 P_1_3_2 68.5329
R277 P_1_3_1 P_1_3_4 20.424
R278 P_1_3_5 P_1_3_1 45.6048
R279 P_1_3 P_1_3_2 43.5
R280 net88_2 net88 25.5109
R281 net88 net88_3 34.1846
R282 net88_4 net88_7 43.642
R283 net88_5 net88_7 39.8169
R284 net88_7 net88 44.6984
R285 P_1_4_1 P_1_4_2 27.5015
R286 P_1_4_3 P_1_4_2 68.5329
R287 P_1_4_1 P_1_4_4 20.424
R288 P_1_4_5 P_1_4_1 45.6048
R289 P_1_4 P_1_4_2 43.5
R290 net91_2 net91 25.5109
R291 net91 net91_3 34.1846
R292 net91_4 net91_7 43.642
R293 net91_5 net91_7 39.8169
R294 net91_7 net91 44.6984
R295 P_1_5_2 P_1_5_1 27.5015
R296 P_1_5_3 P_1_5_2 68.5329
R297 P_1_5_1 P_1_5_4 20.424
R298 P_1_5_5 P_1_5_1 45.6048
R299 P_1_5 P_1_5_2 43.5
R300 net94_2 net94 25.5109
R301 net94 net94_3 34.1846
R302 net94_4 net94_7 43.642
R303 net94_5 net94_7 39.8169
R304 net94_7 net94 44.6984
R305 P_1_6_2 P_1_6_1 27.5015
R306 P_1_6_3 P_1_6_2 68.5329
R307 P_1_6_1 P_1_6_4 20.424
R308 P_1_6_5 P_1_6_1 45.6048
R309 P_1_6 P_1_6_2 43.5
R310 net97_2 net97 25.5109
R311 net97 net97_3 34.1846
R312 net97_4 net97_7 43.642
R313 net97_5 net97_7 39.8169
R314 net97_7 net97 44.6984
R315 P_1_7_2 P_1_7_1 27.5015
R316 P_1_7_3 P_1_7_2 68.5329
R317 P_1_7_1 P_1_7_4 20.424
R318 P_1_7_5 P_1_7_1 45.6048
R319 P_1_7 P_1_7_2 43.5
R320 WL_1 WL_1_9 35.4396
R321 WL_1_9 WL_1_10 125.904
R322 WL_1_10 WL_1_11 125.904
R323 WL_1_11 WL_1_12 125.904
R324 WL_1_12 WL_1_13 125.904
R325 WL_1_13 WL_1_14 125.904
R326 WL_1_14 WL_1_15 125.904
R327 WL_1_1 WL_1_9 38.915
R328 WL_1_2 WL_1_10 38.915
R329 WL_1_3 WL_1_11 38.915
R330 WL_1_4 WL_1_12 38.915
R331 WL_1_5 WL_1_13 38.915
R332 WL_1_6 WL_1_14 38.915
R333 WL_1_7 WL_1_15 38.915
R334 WL_1_16 WL_1_1 83.7722
R335 WL_1_17 WL_1_1 84.6073
R336 WL_1_18 WL_1_2 83.7722
R337 WL_1_19 WL_1_2 84.6073
R338 WL_1_20 WL_1_3 83.7722
R339 WL_1_21 WL_1_3 84.6073
R340 WL_1_22 WL_1_4 83.7722
R341 WL_1_23 WL_1_4 84.6073
R342 WL_1_24 WL_1_5 83.7722
R343 WL_1_25 WL_1_5 84.6073
R344 WL_1_26 WL_1_6 83.7722
R345 WL_1_27 WL_1_6 84.6073
R346 WL_1_28 WL_1_7 83.7722
R347 WL_1_29 WL_1_7 84.6073
R348 WL_1_30 WL_1_8 83.7722
R349 WL_1_31 WL_1_8 84.6073
R350 WL_1_15 WL_1_8 164.819
R351 net133_5 net133 25.5109
R352 net133 net133_6 34.1846
R353 net133_7 net133_2 30.1028
R354 net133_2 net133_8 29.5926
R355 net133_4 net133_3 6.2952
R356 net133 net133_4 127.497
R357 net133_2 net133_3 90.749
R358 net133_3 net133_9 70.7246
R359 net133_10 net133_4 98.7906
R360 net134_5 net134 25.5109
R361 net134 net134_6 34.1846
R362 net134_7 net134_2 30.1028
R363 net134_2 net134_8 29.5926
R364 net134_4 net134_3 6.2952
R365 net134 net134_4 127.497
R366 net134_2 net134_3 90.749
R367 net134_3 net134_9 70.7246
R368 net134_10 net134_4 98.7906
R369 XB_1_1_2 XB_1_1_1 22.9598
R370 XB_1_1_1 XB_1_1_3 36.7357
R371 XB_1_1 XB_1_1_1 109.677
R372 net136_5 net136 25.5109
R373 net136 net136_6 34.1846
R374 net136_7 net136_2 30.1028
R375 net136_2 net136_8 29.5926
R376 net136_4 net136_3 6.2952
R377 net136 net136_4 127.497
R378 net136_2 net136_3 90.749
R379 net136_3 net136_9 70.7246
R380 net136_10 net136_4 98.7906
R381 net137_5 net137 25.5109
R382 net137 net137_6 34.1846
R383 net137_7 net137_2 30.1028
R384 net137_2 net137_8 29.5926
R385 net137_4 net137_3 6.2952
R386 net137 net137_4 127.497
R387 net137_2 net137_3 90.749
R388 net137_3 net137_9 70.7246
R389 net137_10 net137_4 98.7906
R390 XB_1_3_2 XB_1_3_1 22.9598
R391 XB_1_3_1 XB_1_3_3 36.7357
R392 XB_1_3 XB_1_3_1 109.677
R393 net139_5 net139 25.5109
R394 net139 net139_6 34.1846
R395 net139_7 net139_2 30.1028
R396 net139_2 net139_8 29.5926
R397 net139_4 net139_3 6.2952
R398 net139 net139_4 127.497
R399 net139_2 net139_3 90.749
R400 net139_3 net139_9 70.7246
R401 net139_10 net139_4 98.7906
R402 XB_1_4_2 XB_1_4_1 22.9598
R403 XB_1_4_1 XB_1_4_3 36.7357
R404 XB_1_4 XB_1_4_1 109.677
R405 net141_5 net141 25.5109
R406 net141 net141_6 34.1846
R407 net141_7 net141_2 30.1028
R408 net141_2 net141_8 29.5926
R409 net141_4 net141_3 6.2952
R410 net141 net141_4 127.497
R411 net141_2 net141_3 90.749
R412 net141_3 net141_9 70.7246
R413 net141_10 net141_4 98.7906
R414 net142_5 net142 25.5109
R415 net142 net142_6 34.1846
R416 net142_7 net142_2 30.1028
R417 net142_2 net142_8 29.5926
R418 net142_4 net142_3 6.2952
R419 net142 net142_4 127.497
R420 net142_2 net142_3 90.749
R421 net142_3 net142_9 70.7246
R422 net142_10 net142_4 98.7906
R423 XB_1_6_2 XB_1_6_1 22.9598
R424 XB_1_6_1 XB_1_6_3 36.7357
R425 XB_1_6 XB_1_6_1 109.677
R426 net144_5 net144 25.5109
R427 net144 net144_6 34.1846
R428 net144_7 net144_2 30.1028
R429 net144_2 net144_8 29.5926
R430 net144_4 net144_3 6.2952
R431 net144 net144_4 127.497
R432 net144_2 net144_3 90.749
R433 net144_3 net144_9 70.7246
R434 net144_10 net144_4 98.7906
R435 XB_1_7_2 XB_1_7_1 22.9598
R436 XB_1_7_1 XB_1_7_3 36.7357
R437 XB_1_7 XB_1_7_1 109.677
R438 XB_1_0_2 XB_1_0_1 22.9598
R439 XB_1_0_1 XB_1_0_3 36.7357
R440 XB_1_0 XB_1_0_1 109.677
R441 XB_1_2_2 XB_1_2_1 22.9598
R442 XB_1_2_1 XB_1_2_3 36.7357
R443 XB_1_2 XB_1_2_1 109.677
R444 XB_1_5_2 XB_1_5_1 22.9598
R445 XB_1_5_1 XB_1_5_3 36.7357
R446 XB_1_5 XB_1_5_1 109.677
C1 BLB_0 BL_0 0.000224223f
C2 BLB_0 BL_1 0.00398113f
C3 BLB_0 BL_1_1 0.000806601f
C4 BLB_0 BL_1_2 0.00328815f
C5 BLB_0 P_0_0_4 0.00157158f
C6 BLB_0 P_0_0_5 0.0030866f
C7 BLB_0 P_1_0_3 5.36365e-05f
C8 BLB_0 VDD_1 0.000409551f
C9 BLB_0 VSS_0 0.0255854f
C10 BLB_0 VSS_2 0.000377343f
C11 BLB_0 WL_0_10 0.000136823f
C12 BLB_0 WL_0_18 6.29023e-05f
C13 BLB_0 WL_0_19 6.29023e-05f
C14 BLB_0 WL_0_2 8.26079e-05f
C15 BLB_0 WL_1_1 0.000185304f
C16 BLB_0 WL_1_10 0.000130253f
C17 BLB_0 WL_1_18 5.98821e-05f
C18 BLB_0 WL_1_19 5.98821e-05f
C19 BLB_0 WL_1_2 7.86416e-05f
C20 BLB_0 XB_0_0 0.00217855f
C21 BLB_0 XB_0_0_1 0.00910718f
C22 BLB_0 XB_0_0_2 0.00128719f
C23 BLB_0 XB_0_0_3 0.00257439f
C24 BLB_0 XB_1_0_3 2.06067e-05f
C25 BLB_0 net133_9 2.18404e-05f
C26 BLB_0 net4_2 0.00137171f
C27 BLB_0 net4_8 0.000599048f
C28 BLB_0_1 BL_0 0.000265774f
C29 BLB_0_1 BL_0_1 0.000239579f
C30 BLB_0_1 BL_1 0.00113937f
C31 BLB_0_1 P_0_0 0.00180317f
C32 BLB_0_1 P_0_0_1 0.00386266f
C33 BLB_0_1 P_0_0_2 0.00702704f
C34 BLB_0_1 P_0_0_3 0.000779604f
C35 BLB_0_1 P_1_0_3 3.35865e-05f
C36 BLB_0_1 VDD_1 0.000152657f
C37 BLB_0_1 VSS_0 0.0146163f
C38 BLB_0_1 WL_0 0.00260417f
C39 BLB_0_1 WL_0_1 0.00625024f
C40 BLB_0_1 WL_0_16 0.00518178f
C41 BLB_0_1 WL_0_17 0.00518178f
C42 BLB_0_1 WL_0_9 0.00717259f
C43 BLB_0_1 WL_1_1 0.000116035f
C44 BLB_0_1 XB_1_0_3 1.29037e-05f
C45 BLB_0_1 net133_9 1.36762e-05f
C46 BLB_0_1 net4 0.00158112f
C47 BLB_0_1 net4_11 0.000926901f
C48 BLB_0_1 net4_3 0.00148901f
C49 BLB_0_1 net4_4 0.00149994f
C50 BLB_0_1 net4_5 0.000599048f
C51 BLB_0_1 net4_6 0.000599048f
C52 BLB_0_1 net4_7 0.000299524f
C53 BLB_0_1 net4_9 0.0014403f
C54 BLB_0_2 BL_0_2 0.000783417f
C55 BLB_0_2 BL_1_2 0.00328757f
C56 BLB_0_2 P_0_0_5 0.000106291f
C57 BLB_0_2 P_1_0 0.00179923f
C58 BLB_0_2 P_1_0_1 0.00385424f
C59 BLB_0_2 P_1_0_2 0.00701172f
C60 BLB_0_2 P_1_0_3 0.00307986f
C61 BLB_0_2 P_1_0_4 0.000777904f
C62 BLB_0_2 P_1_0_5 0.00156816f
C63 BLB_0_2 VDD_1 0.00112792f
C64 BLB_0_2 VSS_0 0.0237583f
C65 BLB_0_2 VSS_2 0.0144208f
C66 BLB_0_2 WL_0_1 0.00049932f
C67 BLB_0_2 WL_1 0.00262315f
C68 BLB_0_2 WL_1_1 0.00629578f
C69 BLB_0_2 WL_1_16 0.00521954f
C70 BLB_0_2 WL_1_17 0.00521954f
C71 BLB_0_2 WL_1_9 0.00722485f
C72 BLB_0_2 XB_0_0_3 0.000105089f
C73 BLB_0_2 XB_1_0 0.00218548f
C74 BLB_0_2 XB_1_0_1 0.00913616f
C75 BLB_0_2 XB_1_0_2 0.00129129f
C76 BLB_0_2 XB_1_0_3 0.00258258f
C77 BLB_0_2 net133 0.00155827f
C78 BLB_0_2 net133_10 0.00141948f
C79 BLB_0_2 net133_2 0.00135189f
C80 BLB_0_2 net133_3 0.00146749f
C81 BLB_0_2 net133_4 0.00147826f
C82 BLB_0_2 net133_5 0.000590391f
C83 BLB_0_2 net133_6 0.000590391f
C84 BLB_0_2 net133_7 0.000295195f
C85 BLB_0_2 net133_8 0.000590391f
C86 BLB_0_2 net133_9 0.000913505f
C87 BLB_0_2 net4_11 6.4422e-05f
C88 BLB_1 BL_1 0.000195305f
C89 BLB_1 BL_2 0.00398722f
C90 BLB_1 BL_2_1 0.000806601f
C91 BLB_1 BL_2_2 0.00328815f
C92 BLB_1 P_0_1_4 0.00157124f
C93 BLB_1 P_0_1_5 0.00308591f
C94 BLB_1 P_1_1_3 5.33385e-05f
C95 BLB_1 VDD_1 0.000413355f
C96 BLB_1 VSS_0 0.0256397f
C97 BLB_1 VSS_2 0.000379786f
C98 BLB_1 WL_0_11 0.000129033f
C99 BLB_1 WL_0_20 6.52533e-05f
C100 BLB_1 WL_0_21 6.52533e-05f
C101 BLB_1 WL_0_3 8.56954e-05f
C102 BLB_1 WL_1_11 0.000122838f
C103 BLB_1 WL_1_2 0.00017898f
C104 BLB_1 WL_1_20 6.21202e-05f
C105 BLB_1 WL_1_21 6.21202e-05f
C106 BLB_1 WL_1_3 8.15809e-05f
C107 BLB_1 XB_0_1 0.00218806f
C108 BLB_1 XB_0_1_1 0.00914694f
C109 BLB_1 XB_0_1_2 0.00129281f
C110 BLB_1 XB_0_1_3 0.00258563f
C111 BLB_1 XB_1_1_3 2.71768e-05f
C112 BLB_1 net134_9 1.97777e-05f
C113 BLB_1 net7_2 0.00134941f
C114 BLB_1 net7_8 0.000589306f
C115 BLB_1_1 BL_1 0.000232629f
C116 BLB_1_1 BL_1_1 0.000209103f
C117 BLB_1_1 BL_2 0.00114318f
C118 BLB_1_1 P_0_1 0.00180277f
C119 BLB_1_1 P_0_1_1 0.00386181f
C120 BLB_1_1 P_0_1_2 0.00702549f
C121 BLB_1_1 P_0_1_3 0.000779432f
C122 BLB_1_1 P_1_1_3 3.34e-05f
C123 BLB_1_1 VDD_1 0.000155039f
C124 BLB_1_1 VSS_0 0.0146639f
C125 BLB_1_1 WL_0_10 0.0104033f
C126 BLB_1_1 WL_0_18 0.00478276f
C127 BLB_1_1 WL_0_19 0.00478276f
C128 BLB_1_1 WL_0_2 0.00628108f
C129 BLB_1_1 WL_1_2 0.000112075f
C130 BLB_1_1 XB_1_1_3 1.70178e-05f
C131 BLB_1_1 net134_9 1.23846e-05f
C132 BLB_1_1 net7 0.0015554f
C133 BLB_1_1 net7_11 0.000911827f
C134 BLB_1_1 net7_3 0.00146479f
C135 BLB_1_1 net7_4 0.00147555f
C136 BLB_1_1 net7_5 0.000589306f
C137 BLB_1_1 net7_6 0.000589306f
C138 BLB_1_1 net7_7 0.000294653f
C139 BLB_1_1 net7_9 0.00141688f
C140 BLB_1_2 BL_1_2 0.000670241f
C141 BLB_1_2 BL_2_2 0.003283f
C142 BLB_1_2 P_0_1_5 0.000111547f
C143 BLB_1_2 P_1_1 0.00180189f
C144 BLB_1_2 P_1_1_1 0.00385993f
C145 BLB_1_2 P_1_1_2 0.00702207f
C146 BLB_1_2 P_1_1_3 0.00308441f
C147 BLB_1_2 P_1_1_4 0.000779053f
C148 BLB_1_2 P_1_1_5 0.00157047f
C149 BLB_1_2 VDD_1 0.00110719f
C150 BLB_1_2 VSS_0 0.0236284f
C151 BLB_1_2 VSS_2 0.0146562f
C152 BLB_1_2 WL_0_2 0.00050559f
C153 BLB_1_2 WL_1_10 0.0104566f
C154 BLB_1_2 WL_1_18 0.00480728f
C155 BLB_1_2 WL_1_19 0.00480728f
C156 BLB_1_2 WL_1_2 0.00631328f
C157 BLB_1_2 XB_0_1_3 0.000101017f
C158 BLB_1_2 XB_1_1 0.00219755f
C159 BLB_1_2 XB_1_1_1 0.00918663f
C160 BLB_1_2 XB_1_1_2 0.00129842f
C161 BLB_1_2 XB_1_1_3 0.00259684f
C162 BLB_1_2 net134 0.00154463f
C163 BLB_1_2 net134_10 0.00140707f
C164 BLB_1_2 net134_2 0.00134006f
C165 BLB_1_2 net134_3 0.00145465f
C166 BLB_1_2 net134_4 0.00146533f
C167 BLB_1_2 net134_5 0.000585226f
C168 BLB_1_2 net134_6 0.000585226f
C169 BLB_1_2 net134_7 0.000292613f
C170 BLB_1_2 net134_8 0.000585226f
C171 BLB_1_2 net134_9 0.000905514f
C172 BLB_1_2 net7_11 6.87425e-05f
C173 BLB_2 BL_2 0.000195305f
C174 BLB_2 BL_3 0.00398722f
C175 BLB_2 BL_3_1 0.000806601f
C176 BLB_2 BL_3_2 0.00328815f
C177 BLB_2 P_0_2_4 0.00157124f
C178 BLB_2 P_0_2_5 0.00308591f
C179 BLB_2 P_1_2_3 5.33385e-05f
C180 BLB_2 VDD_1 0.000413355f
C181 BLB_2 VSS_0 0.0256397f
C182 BLB_2 VSS_2 0.000379786f
C183 BLB_2 WL_0_12 0.000136823f
C184 BLB_2 WL_0_22 6.29023e-05f
C185 BLB_2 WL_0_23 6.29023e-05f
C186 BLB_2 WL_0_4 8.26079e-05f
C187 BLB_2 WL_1_12 0.000130253f
C188 BLB_2 WL_1_22 5.98821e-05f
C189 BLB_2 WL_1_23 5.98821e-05f
C190 BLB_2 WL_1_3 0.00017898f
C191 BLB_2 WL_1_4 7.86416e-05f
C192 BLB_2 XB_0_2 0.00218806f
C193 BLB_2 XB_0_2_1 0.00914694f
C194 BLB_2 XB_0_2_2 0.00129281f
C195 BLB_2 XB_0_2_3 0.00258563f
C196 BLB_2 XB_1_2_3 2.71768e-05f
C197 BLB_2 net11_2 0.00134941f
C198 BLB_2 net11_8 0.000589306f
C199 BLB_2 net136_9 1.97777e-05f
C200 BLB_2_1 BL_2 0.000232629f
C201 BLB_2_1 BL_2_1 0.000209103f
C202 BLB_2_1 BL_3 0.00114318f
C203 BLB_2_1 P_0_2 0.00180277f
C204 BLB_2_1 P_0_2_1 0.00386181f
C205 BLB_2_1 P_0_2_2 0.00702549f
C206 BLB_2_1 P_0_2_3 0.000779432f
C207 BLB_2_1 P_1_2_3 3.34e-05f
C208 BLB_2_1 VDD_1 0.000155039f
C209 BLB_2_1 VSS_0 0.0146639f
C210 BLB_2_1 WL_0_11 0.009811f
C211 BLB_2_1 WL_0_20 0.00496152f
C212 BLB_2_1 WL_0_21 0.00496152f
C213 BLB_2_1 WL_0_3 0.00651584f
C214 BLB_2_1 WL_1_3 0.000112075f
C215 BLB_2_1 XB_1_2_3 1.70178e-05f
C216 BLB_2_1 net11 0.0015554f
C217 BLB_2_1 net11_11 0.000911827f
C218 BLB_2_1 net11_3 0.00146479f
C219 BLB_2_1 net11_4 0.00147555f
C220 BLB_2_1 net11_5 0.000589306f
C221 BLB_2_1 net11_6 0.000589306f
C222 BLB_2_1 net11_7 0.000294653f
C223 BLB_2_1 net11_9 0.00141688f
C224 BLB_2_1 net136_9 1.23846e-05f
C225 BLB_2_2 BL_2_2 0.000670241f
C226 BLB_2_2 BL_3_2 0.003283f
C227 BLB_2_2 P_0_2_5 0.000111547f
C228 BLB_2_2 P_1_2 0.00180189f
C229 BLB_2_2 P_1_2_1 0.00385993f
C230 BLB_2_2 P_1_2_2 0.00702207f
C231 BLB_2_2 P_1_2_3 0.00308441f
C232 BLB_2_2 P_1_2_4 0.000779053f
C233 BLB_2_2 P_1_2_5 0.00157047f
C234 BLB_2_2 VDD_1 0.00110719f
C235 BLB_2_2 VSS_0 0.0236284f
C236 BLB_2_2 VSS_2 0.0146562f
C237 BLB_2_2 WL_0_3 0.00050559f
C238 BLB_2_2 WL_1_11 0.0098613f
C239 BLB_2_2 WL_1_20 0.00498696f
C240 BLB_2_2 WL_1_21 0.00498696f
C241 BLB_2_2 WL_1_3 0.00654924f
C242 BLB_2_2 XB_0_2_3 0.000101017f
C243 BLB_2_2 XB_1_2 0.00219755f
C244 BLB_2_2 XB_1_2_1 0.00918663f
C245 BLB_2_2 XB_1_2_2 0.00129842f
C246 BLB_2_2 XB_1_2_3 0.00259684f
C247 BLB_2_2 net11_11 6.87425e-05f
C248 BLB_2_2 net136 0.00154463f
C249 BLB_2_2 net136_10 0.00140707f
C250 BLB_2_2 net136_2 0.00134006f
C251 BLB_2_2 net136_3 0.00145465f
C252 BLB_2_2 net136_4 0.00146533f
C253 BLB_2_2 net136_5 0.000585226f
C254 BLB_2_2 net136_6 0.000585226f
C255 BLB_2_2 net136_7 0.000292613f
C256 BLB_2_2 net136_8 0.000585226f
C257 BLB_2_2 net136_9 0.000905514f
C258 BLB_3 BL_3 0.000195305f
C259 BLB_3 BL_4 0.00398722f
C260 BLB_3 BL_4_1 0.000806601f
C261 BLB_3 BL_4_2 0.00328815f
C262 BLB_3 P_0_3_4 0.00157124f
C263 BLB_3 P_0_3_5 0.00308591f
C264 BLB_3 P_1_3_3 5.33385e-05f
C265 BLB_3 VDD_1 0.000413355f
C266 BLB_3 VSS_0 0.0256397f
C267 BLB_3 VSS_2 0.000379786f
C268 BLB_3 WL_0_13 0.000136823f
C269 BLB_3 WL_0_24 6.29023e-05f
C270 BLB_3 WL_0_25 6.29023e-05f
C271 BLB_3 WL_0_5 8.26079e-05f
C272 BLB_3 WL_1_13 0.000130253f
C273 BLB_3 WL_1_24 5.98821e-05f
C274 BLB_3 WL_1_25 5.98821e-05f
C275 BLB_3 WL_1_4 0.00017898f
C276 BLB_3 WL_1_5 7.86416e-05f
C277 BLB_3 XB_0_3 0.00218806f
C278 BLB_3 XB_0_3_1 0.00914694f
C279 BLB_3 XB_0_3_2 0.00129281f
C280 BLB_3 XB_0_3_3 0.00258563f
C281 BLB_3 XB_1_3_3 2.71768e-05f
C282 BLB_3 net137_9 1.97777e-05f
C283 BLB_3 net14_2 0.00134941f
C284 BLB_3 net14_8 0.000589306f
C285 BLB_3_1 BL_3 0.000232629f
C286 BLB_3_1 BL_3_1 0.000209103f
C287 BLB_3_1 BL_4 0.00114318f
C288 BLB_3_1 P_0_3 0.00180277f
C289 BLB_3_1 P_0_3_1 0.00386181f
C290 BLB_3_1 P_0_3_2 0.00702549f
C291 BLB_3_1 P_0_3_3 0.000779432f
C292 BLB_3_1 P_1_3_3 3.34e-05f
C293 BLB_3_1 VDD_1 0.000155039f
C294 BLB_3_1 VSS_0 0.0146639f
C295 BLB_3_1 WL_0_12 0.0104033f
C296 BLB_3_1 WL_0_22 0.00478276f
C297 BLB_3_1 WL_0_23 0.00478276f
C298 BLB_3_1 WL_0_4 0.00628108f
C299 BLB_3_1 WL_1_4 0.000112075f
C300 BLB_3_1 XB_1_3_3 1.70178e-05f
C301 BLB_3_1 net137_9 1.23846e-05f
C302 BLB_3_1 net14 0.0015554f
C303 BLB_3_1 net14_11 0.000911827f
C304 BLB_3_1 net14_3 0.00146479f
C305 BLB_3_1 net14_4 0.00147555f
C306 BLB_3_1 net14_5 0.000589306f
C307 BLB_3_1 net14_6 0.000589306f
C308 BLB_3_1 net14_7 0.000294653f
C309 BLB_3_1 net14_9 0.00141688f
C310 BLB_3_2 BL_3_2 0.000670241f
C311 BLB_3_2 BL_4_2 0.003283f
C312 BLB_3_2 P_0_3_5 0.000111547f
C313 BLB_3_2 P_1_3 0.00180189f
C314 BLB_3_2 P_1_3_1 0.00385993f
C315 BLB_3_2 P_1_3_2 0.00702207f
C316 BLB_3_2 P_1_3_3 0.00308441f
C317 BLB_3_2 P_1_3_4 0.000779053f
C318 BLB_3_2 P_1_3_5 0.00157047f
C319 BLB_3_2 VDD_1 0.00110719f
C320 BLB_3_2 VSS_0 0.0236284f
C321 BLB_3_2 VSS_2 0.0146562f
C322 BLB_3_2 WL_0_4 0.00050559f
C323 BLB_3_2 WL_1_12 0.0104566f
C324 BLB_3_2 WL_1_22 0.00480728f
C325 BLB_3_2 WL_1_23 0.00480728f
C326 BLB_3_2 WL_1_4 0.00631328f
C327 BLB_3_2 XB_0_3_3 0.000101017f
C328 BLB_3_2 XB_1_3 0.00219755f
C329 BLB_3_2 XB_1_3_1 0.00918663f
C330 BLB_3_2 XB_1_3_2 0.00129842f
C331 BLB_3_2 XB_1_3_3 0.00259684f
C332 BLB_3_2 net137 0.00154463f
C333 BLB_3_2 net137_10 0.00140707f
C334 BLB_3_2 net137_2 0.00134006f
C335 BLB_3_2 net137_3 0.00145465f
C336 BLB_3_2 net137_4 0.00146533f
C337 BLB_3_2 net137_5 0.000585226f
C338 BLB_3_2 net137_6 0.000585226f
C339 BLB_3_2 net137_7 0.000292613f
C340 BLB_3_2 net137_8 0.000585226f
C341 BLB_3_2 net137_9 0.000905514f
C342 BLB_3_2 net14_11 6.87425e-05f
C343 BLB_4 BL_4 0.000195305f
C344 BLB_4 BL_5 0.00398722f
C345 BLB_4 BL_5_1 0.000806601f
C346 BLB_4 BL_5_2 0.00328815f
C347 BLB_4 P_0_4_4 0.00157124f
C348 BLB_4 P_0_4_5 0.00308591f
C349 BLB_4 P_1_4_3 5.33385e-05f
C350 BLB_4 VDD_1 0.000413355f
C351 BLB_4 VSS_0 0.0256397f
C352 BLB_4 VSS_2 0.000379786f
C353 BLB_4 WL_0_14 0.000136823f
C354 BLB_4 WL_0_26 6.29023e-05f
C355 BLB_4 WL_0_27 6.29023e-05f
C356 BLB_4 WL_0_6 8.26079e-05f
C357 BLB_4 WL_1_14 0.000130253f
C358 BLB_4 WL_1_26 5.98821e-05f
C359 BLB_4 WL_1_27 5.98821e-05f
C360 BLB_4 WL_1_5 0.00017898f
C361 BLB_4 WL_1_6 7.86416e-05f
C362 BLB_4 XB_0_4 0.00218806f
C363 BLB_4 XB_0_4_1 0.00914694f
C364 BLB_4 XB_0_4_2 0.00129281f
C365 BLB_4 XB_0_4_3 0.00258563f
C366 BLB_4 XB_1_4_3 2.71768e-05f
C367 BLB_4 net139_9 1.97777e-05f
C368 BLB_4 net17_2 0.00134941f
C369 BLB_4 net17_8 0.000589306f
C370 BLB_4_1 BL_4 0.000232629f
C371 BLB_4_1 BL_4_1 0.000209103f
C372 BLB_4_1 BL_5 0.00114318f
C373 BLB_4_1 P_0_4 0.00180277f
C374 BLB_4_1 P_0_4_1 0.00386181f
C375 BLB_4_1 P_0_4_2 0.00702549f
C376 BLB_4_1 P_0_4_3 0.000779432f
C377 BLB_4_1 P_1_4_3 3.34e-05f
C378 BLB_4_1 VDD_1 0.000155039f
C379 BLB_4_1 VSS_0 0.0146639f
C380 BLB_4_1 WL_0_13 0.0104033f
C381 BLB_4_1 WL_0_24 0.00478276f
C382 BLB_4_1 WL_0_25 0.00478276f
C383 BLB_4_1 WL_0_5 0.00628108f
C384 BLB_4_1 WL_1_5 0.000112075f
C385 BLB_4_1 XB_1_4_3 1.70178e-05f
C386 BLB_4_1 net139_9 1.23846e-05f
C387 BLB_4_1 net17 0.0015554f
C388 BLB_4_1 net17_11 0.000911827f
C389 BLB_4_1 net17_3 0.00146479f
C390 BLB_4_1 net17_4 0.00147555f
C391 BLB_4_1 net17_5 0.000589306f
C392 BLB_4_1 net17_6 0.000589306f
C393 BLB_4_1 net17_7 0.000294653f
C394 BLB_4_1 net17_9 0.00141688f
C395 BLB_4_2 BL_4_2 0.000670241f
C396 BLB_4_2 BL_5_2 0.003283f
C397 BLB_4_2 P_0_4_5 0.000111547f
C398 BLB_4_2 P_1_4 0.00180189f
C399 BLB_4_2 P_1_4_1 0.00385993f
C400 BLB_4_2 P_1_4_2 0.00702207f
C401 BLB_4_2 P_1_4_3 0.00308441f
C402 BLB_4_2 P_1_4_4 0.000779053f
C403 BLB_4_2 P_1_4_5 0.00157047f
C404 BLB_4_2 VDD_1 0.00110719f
C405 BLB_4_2 VSS_0 0.0236284f
C406 BLB_4_2 VSS_2 0.0146562f
C407 BLB_4_2 WL_0_5 0.00050559f
C408 BLB_4_2 WL_1_13 0.0104566f
C409 BLB_4_2 WL_1_24 0.00480728f
C410 BLB_4_2 WL_1_25 0.00480728f
C411 BLB_4_2 WL_1_5 0.00631328f
C412 BLB_4_2 XB_0_4_3 0.000101017f
C413 BLB_4_2 XB_1_4 0.00219755f
C414 BLB_4_2 XB_1_4_1 0.00918663f
C415 BLB_4_2 XB_1_4_2 0.00129842f
C416 BLB_4_2 XB_1_4_3 0.00259684f
C417 BLB_4_2 net139 0.00154463f
C418 BLB_4_2 net139_10 0.00140707f
C419 BLB_4_2 net139_2 0.00134006f
C420 BLB_4_2 net139_3 0.00145465f
C421 BLB_4_2 net139_4 0.00146533f
C422 BLB_4_2 net139_5 0.000585226f
C423 BLB_4_2 net139_6 0.000585226f
C424 BLB_4_2 net139_7 0.000292613f
C425 BLB_4_2 net139_8 0.000585226f
C426 BLB_4_2 net139_9 0.000905514f
C427 BLB_4_2 net17_11 6.87425e-05f
C428 BLB_5 BL_5 0.000195305f
C429 BLB_5 BL_6 0.00398722f
C430 BLB_5 BL_6_1 0.000806601f
C431 BLB_5 BL_6_2 0.00328815f
C432 BLB_5 P_0_5_4 0.00157124f
C433 BLB_5 P_0_5_5 0.00308591f
C434 BLB_5 P_1_5_3 5.33385e-05f
C435 BLB_5 VDD_1 0.000413355f
C436 BLB_5 VSS_0 0.0256397f
C437 BLB_5 VSS_2 0.000379786f
C438 BLB_5 WL_0_15 0.000203301f
C439 BLB_5 WL_0_28 4.2838e-05f
C440 BLB_5 WL_0_29 4.2838e-05f
C441 BLB_5 WL_0_7 5.62581e-05f
C442 BLB_5 WL_1_15 0.00019354f
C443 BLB_5 WL_1_28 4.07812e-05f
C444 BLB_5 WL_1_29 4.07812e-05f
C445 BLB_5 WL_1_6 0.00017898f
C446 BLB_5 WL_1_7 5.35569e-05f
C447 BLB_5 XB_0_5 0.00218806f
C448 BLB_5 XB_0_5_1 0.00914694f
C449 BLB_5 XB_0_5_2 0.00129281f
C450 BLB_5 XB_0_5_3 0.00258563f
C451 BLB_5 XB_1_5_3 2.71768e-05f
C452 BLB_5 net141_9 1.97777e-05f
C453 BLB_5 net21_2 0.00134941f
C454 BLB_5 net21_8 0.000589306f
C455 BLB_5_1 BL_5 0.000232629f
C456 BLB_5_1 BL_5_1 0.000209103f
C457 BLB_5_1 BL_6 0.00114318f
C458 BLB_5_1 P_0_5 0.00180277f
C459 BLB_5_1 P_0_5_1 0.00386181f
C460 BLB_5_1 P_0_5_2 0.00702549f
C461 BLB_5_1 P_0_5_3 0.000779432f
C462 BLB_5_1 P_1_5_3 3.34e-05f
C463 BLB_5_1 VDD_1 0.000155039f
C464 BLB_5_1 VSS_0 0.0146639f
C465 BLB_5_1 WL_0_14 0.0104033f
C466 BLB_5_1 WL_0_26 0.00478276f
C467 BLB_5_1 WL_0_27 0.00478276f
C468 BLB_5_1 WL_0_6 0.00628108f
C469 BLB_5_1 WL_1_6 0.000112075f
C470 BLB_5_1 XB_1_5_3 1.70178e-05f
C471 BLB_5_1 net141_9 1.23846e-05f
C472 BLB_5_1 net21 0.0015554f
C473 BLB_5_1 net21_11 0.000911827f
C474 BLB_5_1 net21_3 0.00146479f
C475 BLB_5_1 net21_4 0.00147555f
C476 BLB_5_1 net21_5 0.000589306f
C477 BLB_5_1 net21_6 0.000589306f
C478 BLB_5_1 net21_7 0.000294653f
C479 BLB_5_1 net21_9 0.00141688f
C480 BLB_5_2 BL_5_2 0.000670241f
C481 BLB_5_2 BL_6_2 0.003283f
C482 BLB_5_2 P_0_5_5 0.000111547f
C483 BLB_5_2 P_1_5 0.00180189f
C484 BLB_5_2 P_1_5_1 0.00385993f
C485 BLB_5_2 P_1_5_2 0.00702207f
C486 BLB_5_2 P_1_5_3 0.00308441f
C487 BLB_5_2 P_1_5_4 0.000779053f
C488 BLB_5_2 P_1_5_5 0.00157047f
C489 BLB_5_2 VDD_1 0.00110719f
C490 BLB_5_2 VSS_0 0.0236284f
C491 BLB_5_2 VSS_2 0.0146562f
C492 BLB_5_2 WL_0_6 0.00050559f
C493 BLB_5_2 WL_1_14 0.0104566f
C494 BLB_5_2 WL_1_26 0.00480728f
C495 BLB_5_2 WL_1_27 0.00480728f
C496 BLB_5_2 WL_1_6 0.00631328f
C497 BLB_5_2 XB_0_5_3 0.000101017f
C498 BLB_5_2 XB_1_5 0.00219755f
C499 BLB_5_2 XB_1_5_1 0.00918663f
C500 BLB_5_2 XB_1_5_2 0.00129842f
C501 BLB_5_2 XB_1_5_3 0.00259684f
C502 BLB_5_2 net141 0.00154463f
C503 BLB_5_2 net141_10 0.00140707f
C504 BLB_5_2 net141_2 0.00134006f
C505 BLB_5_2 net141_3 0.00145465f
C506 BLB_5_2 net141_4 0.00146533f
C507 BLB_5_2 net141_5 0.000585226f
C508 BLB_5_2 net141_6 0.000585226f
C509 BLB_5_2 net141_7 0.000292613f
C510 BLB_5_2 net141_8 0.000585226f
C511 BLB_5_2 net141_9 0.000905514f
C512 BLB_5_2 net21_11 6.87425e-05f
C513 BLB_6 BL_6 0.000195305f
C514 BLB_6 BL_7 0.00399059f
C515 BLB_6 BL_7_1 0.000807857f
C516 BLB_6 BL_7_2 0.00329269f
C517 BLB_6 P_0_6_4 0.00157124f
C518 BLB_6 P_0_6_5 0.00308591f
C519 BLB_6 P_1_6_3 5.33385e-05f
C520 BLB_6 VDD_1 0.000406044f
C521 BLB_6 VSS_0 0.0257787f
C522 BLB_6 VSS_2 0.000380637f
C523 BLB_6 WL_0_30 9.66957e-05f
C524 BLB_6 WL_0_31 9.66957e-05f
C525 BLB_6 WL_0_8 0.000126988f
C526 BLB_6 WL_1_30 9.77512e-05f
C527 BLB_6 WL_1_31 9.77512e-05f
C528 BLB_6 WL_1_7 0.00017898f
C529 BLB_6 WL_1_8 0.000128374f
C530 BLB_6 XB_0_6 0.00218806f
C531 BLB_6 XB_0_6_1 0.00914694f
C532 BLB_6 XB_0_6_2 0.00129281f
C533 BLB_6 XB_0_6_3 0.00258563f
C534 BLB_6 XB_1_6_3 2.71768e-05f
C535 BLB_6 net142_9 1.97777e-05f
C536 BLB_6 net24_2 0.00134941f
C537 BLB_6 net24_8 0.000589306f
C538 BLB_6_1 BL_6 0.000232629f
C539 BLB_6_1 BL_6_1 0.000209103f
C540 BLB_6_1 BL_7 0.00114318f
C541 BLB_6_1 P_0_6 0.00180277f
C542 BLB_6_1 P_0_6_1 0.00386181f
C543 BLB_6_1 P_0_6_2 0.00702549f
C544 BLB_6_1 P_0_6_3 0.000779432f
C545 BLB_6_1 P_1_6_3 3.34e-05f
C546 BLB_6_1 VDD_1 0.000155039f
C547 BLB_6_1 VSS_0 0.014628f
C548 BLB_6_1 WL_0_15 0.0154579f
C549 BLB_6_1 WL_0_28 0.00325718f
C550 BLB_6_1 WL_0_29 0.00325718f
C551 BLB_6_1 WL_0_7 0.00427757f
C552 BLB_6_1 WL_1_7 0.000112075f
C553 BLB_6_1 XB_1_6_3 1.70178e-05f
C554 BLB_6_1 net142_9 1.23846e-05f
C555 BLB_6_1 net24 0.0015554f
C556 BLB_6_1 net24_11 0.000911827f
C557 BLB_6_1 net24_3 0.00146479f
C558 BLB_6_1 net24_4 0.00147555f
C559 BLB_6_1 net24_5 0.000589306f
C560 BLB_6_1 net24_6 0.000589306f
C561 BLB_6_1 net24_7 0.000294653f
C562 BLB_6_1 net24_9 0.00141688f
C563 BLB_6_2 BL_6_2 0.000670241f
C564 BLB_6_2 BL_7_2 0.003283f
C565 BLB_6_2 P_0_6_5 0.000111547f
C566 BLB_6_2 P_1_6 0.00180189f
C567 BLB_6_2 P_1_6_1 0.00385993f
C568 BLB_6_2 P_1_6_2 0.00702207f
C569 BLB_6_2 P_1_6_3 0.00308441f
C570 BLB_6_2 P_1_6_4 0.000779053f
C571 BLB_6_2 P_1_6_5 0.00157047f
C572 BLB_6_2 VDD_1 0.00110719f
C573 BLB_6_2 VSS_0 0.0235523f
C574 BLB_6_2 VSS_2 0.0146562f
C575 BLB_6_2 WL_0_7 0.00050559f
C576 BLB_6_2 WL_1_15 0.0155372f
C577 BLB_6_2 WL_1_28 0.00327388f
C578 BLB_6_2 WL_1_29 0.00327388f
C579 BLB_6_2 WL_1_7 0.0042995f
C580 BLB_6_2 XB_0_6_3 0.000101017f
C581 BLB_6_2 XB_1_6 0.00219755f
C582 BLB_6_2 XB_1_6_1 0.00918663f
C583 BLB_6_2 XB_1_6_2 0.00129842f
C584 BLB_6_2 XB_1_6_3 0.00259684f
C585 BLB_6_2 net142 0.00154463f
C586 BLB_6_2 net142_10 0.00140707f
C587 BLB_6_2 net142_2 0.00134006f
C588 BLB_6_2 net142_3 0.00145465f
C589 BLB_6_2 net142_4 0.00146533f
C590 BLB_6_2 net142_5 0.000585226f
C591 BLB_6_2 net142_6 0.000585226f
C592 BLB_6_2 net142_7 0.000292613f
C593 BLB_6_2 net142_8 0.000585226f
C594 BLB_6_2 net142_9 0.000905514f
C595 BLB_6_2 net24_11 6.87425e-05f
C596 BLB_7 BL_7 0.000215756f
C597 BLB_7 P_0_7_4 0.00158296f
C598 BLB_7 P_0_7_5 0.00310894f
C599 BLB_7 P_1_7_3 7.59829e-05f
C600 BLB_7 VDD_1 0.000345969f
C601 BLB_7 VSS_0 0.0259224f
C602 BLB_7 VSS_2 1.47743e-05f
C603 BLB_7 WL_1_8 0.000200305f
C604 BLB_7 XB_0_7 0.0022943f
C605 BLB_7 XB_0_7_1 0.00959106f
C606 BLB_7 XB_0_7_2 0.00135558f
C607 BLB_7 XB_0_7_3 0.00271117f
C608 BLB_7 XB_1_7_3 6.396e-05f
C609 BLB_7 net144_9 2.98026e-05f
C610 BLB_7 net28_2 0.0013554f
C611 BLB_7 net28_8 0.000591921f
C612 BLB_7_1 BL_7 0.000256514f
C613 BLB_7_1 BL_7_1 0.000230822f
C614 BLB_7_1 P_0_7 0.00181622f
C615 BLB_7_1 P_0_7_1 0.00389063f
C616 BLB_7_1 P_0_7_2 0.00707791f
C617 BLB_7_1 P_0_7_3 0.000785248f
C618 BLB_7_1 P_1_7_3 4.75796e-05f
C619 BLB_7_1 VDD_1 0.000216642f
C620 BLB_7_1 VSS_0 0.0162323f
C621 BLB_7_1 WL_0_30 0.00806306f
C622 BLB_7_1 WL_0_31 0.00806306f
C623 BLB_7_1 WL_0_8 0.010589f
C624 BLB_7_1 WL_1_8 0.000125429f
C625 BLB_7_1 XB_1_7_3 4.0051e-05f
C626 BLB_7_1 net144_9 1.8662e-05f
C627 BLB_7_1 net28 0.00156231f
C628 BLB_7_1 net28_11 0.000915874f
C629 BLB_7_1 net28_3 0.00147129f
C630 BLB_7_1 net28_4 0.0014821f
C631 BLB_7_1 net28_5 0.000591921f
C632 BLB_7_1 net28_6 0.000591921f
C633 BLB_7_1 net28_7 0.000295961f
C634 BLB_7_1 net28_9 0.00142317f
C635 BLB_7_2 BL_7_2 0.000735173f
C636 BLB_7_2 P_0_7_5 0.000142911f
C637 BLB_7_2 P_1_7 0.00181679f
C638 BLB_7_2 P_1_7_1 0.00389184f
C639 BLB_7_2 P_1_7_2 0.00708012f
C640 BLB_7_2 P_1_7_3 0.00310991f
C641 BLB_7_2 P_1_7_4 0.000785493f
C642 BLB_7_2 P_1_7_5 0.00158345f
C643 BLB_7_2 VDD_1 0.00153154f
C644 BLB_7_2 VSS_0 0.0279059f
C645 BLB_7_2 VSS_2 0.0147574f
C646 BLB_7_2 WL_0_8 0.000527785f
C647 BLB_7_2 WL_1_30 0.00811885f
C648 BLB_7_2 WL_1_31 0.00811885f
C649 BLB_7_2 WL_1_8 0.0106623f
C650 BLB_7_2 XB_0_7_3 0.000178309f
C651 BLB_7_2 XB_1_7 0.00230464f
C652 BLB_7_2 XB_1_7_1 0.00963431f
C653 BLB_7_2 XB_1_7_2 0.0013617f
C654 BLB_7_2 XB_1_7_3 0.0027234f
C655 BLB_7_2 net144 0.00155735f
C656 BLB_7_2 net144_10 0.00141865f
C657 BLB_7_2 net144_2 0.0013511f
C658 BLB_7_2 net144_3 0.00146662f
C659 BLB_7_2 net144_4 0.00147739f
C660 BLB_7_2 net144_5 0.000590044f
C661 BLB_7_2 net144_6 0.000590044f
C662 BLB_7_2 net144_7 0.000295022f
C663 BLB_7_2 net144_8 0.000590044f
C664 BLB_7_2 net144_9 0.000912969f
C665 BLB_7_2 net28_11 9.72485e-05f
C666 BL_0 VDD_1 0.000341181f
C667 BL_0 VSS_0 0.0283951f
C668 BL_0 WL_0 0.00260084f
C669 BL_0 WL_0_1 0.00624224f
C670 BL_0 WL_0_9 0.0071634f
C671 BL_0 WL_1_1 0.000247088f
C672 BL_0 net133_9 0.000112095f
C673 BL_0 net3 0.00055226f
C674 BL_0 net3_3 0.00071937f
C675 BL_0 net3_6 0.000521026f
C676 BL_0 net3_7 0.00186209f
C677 BL_0 net4 0.00163874f
C678 BL_0 net4_11 0.000960679f
C679 BL_0 net4_2 0.0014217f
C680 BL_0 net4_3 0.00154327f
C681 BL_0 net4_4 0.0015546f
C682 BL_0 net4_6 0.000620879f
C683 BL_0 net4_8 0.000620879f
C684 BL_0 net76_3 2.41412e-05f
C685 BL_0_1 VDD_1 0.000127311f
C686 BL_0_1 VSS_0 0.0105956f
C687 BL_0_1 WL_0_16 0.00517515f
C688 BL_0_1 WL_0_17 0.00517515f
C689 BL_0_1 WL_1_1 9.22003e-05f
C690 BL_0_1 net133_9 4.18279e-05f
C691 BL_0_1 net3_2 0.00071937f
C692 BL_0_1 net3_4 0.00122468f
C693 BL_0_1 net4_5 0.000620879f
C694 BL_0_1 net4_7 0.000310439f
C695 BL_0_1 net4_9 0.00149279f
C696 BL_0_2 VDD_1 0.00147361f
C697 BL_0_2 VSS_0 0.0277021f
C698 BL_0_2 VSS_2 0.0118989f
C699 BL_0_2 WL_0_1 0.00055346f
C700 BL_0_2 WL_1 0.0026192f
C701 BL_0_2 WL_1_1 0.00628631f
C702 BL_0_2 WL_1_16 0.00521169f
C703 BL_0_2 WL_1_17 0.00521169f
C704 BL_0_2 WL_1_9 0.00721398f
C705 BL_0_2 net133 0.0017134f
C706 BL_0_2 net133_10 0.0015608f
C707 BL_0_2 net133_2 0.00148647f
C708 BL_0_2 net133_3 0.00161358f
C709 BL_0_2 net133_4 0.00162543f
C710 BL_0_2 net133_5 0.000649166f
C711 BL_0_2 net133_6 0.000649166f
C712 BL_0_2 net133_7 0.000324583f
C713 BL_0_2 net133_8 0.000649166f
C714 BL_0_2 net133_9 0.00100445f
C715 BL_0_2 net3_3 5.46245e-05f
C716 BL_0_2 net4_11 0.000207292f
C717 BL_0_2 net76 0.000545227f
C718 BL_0_2 net76_2 0.000710209f
C719 BL_0_2 net76_3 0.000710209f
C720 BL_0_2 net76_4 0.000514391f
C721 BL_0_2 net76_5 0.00120908f
C722 BL_0_2 net76_7 0.00183837f
C723 BL_1 VDD_1 0.000325801f
C724 BL_1 VSS_0 0.0261132f
C725 BL_1 WL_0 5.00866e-05f
C726 BL_1 WL_0_1 0.000120212f
C727 BL_1 WL_0_10 0.0102708f
C728 BL_1 WL_0_16 9.96623e-05f
C729 BL_1 WL_0_17 9.96623e-05f
C730 BL_1 WL_0_2 0.00620107f
C731 BL_1 WL_0_9 0.000137952f
C732 BL_1 WL_1_2 0.000225729f
C733 BL_1 XB_0_0 0.00017244f
C734 BL_1 XB_0_0_1 0.00154635f
C735 BL_1 XB_0_0_2 0.000101886f
C736 BL_1 XB_0_0_3 0.000203772f
C737 BL_1 XB_1_0_3 1.54132e-05f
C738 BL_1 net134_9 2.49146e-05f
C739 BL_1 net6 0.000536419f
C740 BL_1 net6_3 0.000698736f
C741 BL_1 net6_6 0.000506081f
C742 BL_1 net6_7 0.00180868f
C743 BL_1 net7 0.00150045f
C744 BL_1 net79_3 2.46218e-05f
C745 BL_1 net7_11 0.000879613f
C746 BL_1 net7_2 0.00130173f
C747 BL_1 net7_3 0.00141304f
C748 BL_1 net7_4 0.00142342f
C749 BL_1 net7_6 0.000568487f
C750 BL_1 net7_8 0.000568487f
C751 BL_1_1 VDD_1 0.000117142f
C752 BL_1_1 VSS_0 0.00911226f
C753 BL_1_1 WL_0_18 0.00472184f
C754 BL_1_1 WL_0_19 0.00472184f
C755 BL_1_1 WL_1_2 8.42304e-05f
C756 BL_1_1 XB_0_0_1 0.000308026f
C757 BL_1_1 net6_2 0.000698736f
C758 BL_1_1 net6_4 0.00118955f
C759 BL_1_1 net7_5 0.000568487f
C760 BL_1_1 net7_7 0.000284243f
C761 BL_1_1 net7_9 0.00136682f
C762 BL_1_2 VDD_1 0.0012602f
C763 BL_1_2 VSS_0 0.0234149f
C764 BL_1_2 VSS_2 0.0118999f
C765 BL_1_2 WL_0_2 0.000508355f
C766 BL_1_2 WL_1 4.87323e-05f
C767 BL_1_2 WL_1_1 0.000116962f
C768 BL_1_2 WL_1_10 0.0102304f
C769 BL_1_2 WL_1_16 9.69676e-05f
C770 BL_1_2 WL_1_17 9.69676e-05f
C771 BL_1_2 WL_1_18 0.00470329f
C772 BL_1_2 WL_1_19 0.00470329f
C773 BL_1_2 WL_1_2 0.00617671f
C774 BL_1_2 WL_1_9 0.000134222f
C775 BL_1_2 XB_0_0_3 3.24346e-05f
C776 BL_1_2 XB_1_0 0.000175166f
C777 BL_1_2 XB_1_0_1 0.00189245f
C778 BL_1_2 XB_1_0_2 0.000103497f
C779 BL_1_2 XB_1_0_3 0.000206994f
C780 BL_1_2 net134 0.00159615f
C781 BL_1_2 net134_10 0.00145399f
C782 BL_1_2 net134_2 0.00138475f
C783 BL_1_2 net134_3 0.00150316f
C784 BL_1_2 net134_4 0.0015142f
C785 BL_1_2 net134_5 0.000604743f
C786 BL_1_2 net134_6 0.000604743f
C787 BL_1_2 net134_7 0.000302371f
C788 BL_1_2 net134_8 0.000604743f
C789 BL_1_2 net134_9 0.000935713f
C790 BL_1_2 net6_3 5.74015e-05f
C791 BL_1_2 net79 0.000556699f
C792 BL_1_2 net79_2 0.000725153f
C793 BL_1_2 net79_3 0.000725153f
C794 BL_1_2 net79_4 0.000525215f
C795 BL_1_2 net79_5 0.00123453f
C796 BL_1_2 net79_7 0.00187706f
C797 BL_1_2 net7_11 0.000141804f
C798 BL_2 VDD_1 0.000335886f
C799 BL_2 VSS_0 0.0260591f
C800 BL_2 WL_0_10 0.00020165f
C801 BL_2 WL_0_11 0.00968603f
C802 BL_2 WL_0_18 9.27059e-05f
C803 BL_2 WL_0_19 9.27059e-05f
C804 BL_2 WL_0_2 0.000121748f
C805 BL_2 WL_0_3 0.00643284f
C806 BL_2 WL_1_3 0.000225729f
C807 BL_2 XB_0_1 0.00017124f
C808 BL_2 XB_0_1_1 0.00154133f
C809 BL_2 XB_0_1_2 0.000101177f
C810 BL_2 XB_0_1_3 0.000202355f
C811 BL_2 XB_1_1_3 1.54132e-05f
C812 BL_2 net10 0.000536419f
C813 BL_2 net10_3 0.000698736f
C814 BL_2 net10_6 0.000506081f
C815 BL_2 net10_7 0.00180868f
C816 BL_2 net11 0.00150045f
C817 BL_2 net11_11 0.000879613f
C818 BL_2 net11_2 0.00130173f
C819 BL_2 net11_3 0.00141304f
C820 BL_2 net11_4 0.00142342f
C821 BL_2 net11_6 0.000568487f
C822 BL_2 net11_8 0.000568487f
C823 BL_2 net136_9 2.49146e-05f
C824 BL_2 net82_3 2.46218e-05f
C825 BL_2_1 VDD_1 0.000117142f
C826 BL_2_1 VSS_0 0.00913604f
C827 BL_2_1 WL_0_20 0.00489832f
C828 BL_2_1 WL_0_21 0.00489832f
C829 BL_2_1 WL_1_3 8.42304e-05f
C830 BL_2_1 XB_0_1_1 0.000308026f
C831 BL_2_1 net10_2 0.000698736f
C832 BL_2_1 net10_4 0.00118955f
C833 BL_2_1 net11_5 0.000568487f
C834 BL_2_1 net11_7 0.000284243f
C835 BL_2_1 net11_9 0.00136682f
C836 BL_2_2 VDD_1 0.00126632f
C837 BL_2_2 VSS_0 0.0234919f
C838 BL_2_2 VSS_2 0.0118792f
C839 BL_2_2 WL_0_3 0.000508355f
C840 BL_2_2 WL_1_10 0.000206394f
C841 BL_2_2 WL_1_11 0.00964798f
C842 BL_2_2 WL_1_18 9.48868e-05f
C843 BL_2_2 WL_1_19 9.48868e-05f
C844 BL_2_2 WL_1_2 0.000124612f
C845 BL_2_2 WL_1_20 0.00487908f
C846 BL_2_2 WL_1_21 0.00487908f
C847 BL_2_2 WL_1_3 0.00640757f
C848 BL_2_2 XB_0_1_3 3.24346e-05f
C849 BL_2_2 XB_1_1 0.000166764f
C850 BL_2_2 XB_1_1_1 0.00185733f
C851 BL_2_2 XB_1_1_2 9.85324e-05f
C852 BL_2_2 XB_1_1_3 0.000197065f
C853 BL_2_2 net10_3 5.74015e-05f
C854 BL_2_2 net11_11 0.000141804f
C855 BL_2_2 net136 0.00159615f
C856 BL_2_2 net136_10 0.00145399f
C857 BL_2_2 net136_2 0.00138475f
C858 BL_2_2 net136_3 0.00150316f
C859 BL_2_2 net136_4 0.0015142f
C860 BL_2_2 net136_5 0.000604743f
C861 BL_2_2 net136_6 0.000604743f
C862 BL_2_2 net136_7 0.000302371f
C863 BL_2_2 net136_8 0.000604743f
C864 BL_2_2 net136_9 0.000935713f
C865 BL_2_2 net82 0.000556699f
C866 BL_2_2 net82_2 0.000725153f
C867 BL_2_2 net82_3 0.000725153f
C868 BL_2_2 net82_4 0.000525215f
C869 BL_2_2 net82_5 0.00123453f
C870 BL_2_2 net82_7 0.00187706f
C871 BL_3 VDD_1 0.000335886f
C872 BL_3 VSS_0 0.0260591f
C873 BL_3 WL_0_11 0.00019017f
C874 BL_3 WL_0_12 0.0102708f
C875 BL_3 WL_0_20 9.61708e-05f
C876 BL_3 WL_0_21 9.61708e-05f
C877 BL_3 WL_0_3 0.000126299f
C878 BL_3 WL_0_4 0.00620107f
C879 BL_3 WL_1_4 0.000225729f
C880 BL_3 XB_0_2 0.00017124f
C881 BL_3 XB_0_2_1 0.00154133f
C882 BL_3 XB_0_2_2 0.000101177f
C883 BL_3 XB_0_2_3 0.000202355f
C884 BL_3 XB_1_2_3 1.54132e-05f
C885 BL_3 net13 0.000536419f
C886 BL_3 net137_9 2.49146e-05f
C887 BL_3 net13_3 0.000698736f
C888 BL_3 net13_6 0.000506081f
C889 BL_3 net13_7 0.00180868f
C890 BL_3 net14 0.00150045f
C891 BL_3 net14_11 0.000879613f
C892 BL_3 net14_2 0.00130173f
C893 BL_3 net14_3 0.00141304f
C894 BL_3 net14_4 0.00142342f
C895 BL_3 net14_6 0.000568487f
C896 BL_3 net14_8 0.000568487f
C897 BL_3 net85_3 2.46218e-05f
C898 BL_3_1 VDD_1 0.000117142f
C899 BL_3_1 VSS_0 0.00913604f
C900 BL_3_1 WL_0_22 0.00472184f
C901 BL_3_1 WL_0_23 0.00472184f
C902 BL_3_1 WL_1_4 8.42304e-05f
C903 BL_3_1 XB_0_2_1 0.000308026f
C904 BL_3_1 net13_2 0.000698736f
C905 BL_3_1 net13_4 0.00118955f
C906 BL_3_1 net14_5 0.000568487f
C907 BL_3_1 net14_7 0.000284243f
C908 BL_3_1 net14_9 0.00136682f
C909 BL_3_2 VDD_1 0.00126632f
C910 BL_3_2 VSS_0 0.0234919f
C911 BL_3_2 VSS_2 0.0118792f
C912 BL_3_2 WL_0_4 0.000508355f
C913 BL_3_2 WL_1_11 0.000194644f
C914 BL_3_2 WL_1_12 0.0102304f
C915 BL_3_2 WL_1_20 9.84332e-05f
C916 BL_3_2 WL_1_21 9.84332e-05f
C917 BL_3_2 WL_1_22 0.00470329f
C918 BL_3_2 WL_1_23 0.00470329f
C919 BL_3_2 WL_1_3 0.00012927f
C920 BL_3_2 WL_1_4 0.00617671f
C921 BL_3_2 XB_0_2_3 3.24346e-05f
C922 BL_3_2 XB_1_2 0.000166764f
C923 BL_3_2 XB_1_2_1 0.00185733f
C924 BL_3_2 XB_1_2_2 9.85324e-05f
C925 BL_3_2 XB_1_2_3 0.000197065f
C926 BL_3_2 net137 0.00159615f
C927 BL_3_2 net137_10 0.00145399f
C928 BL_3_2 net137_2 0.00138475f
C929 BL_3_2 net137_3 0.00150316f
C930 BL_3_2 net137_4 0.0015142f
C931 BL_3_2 net137_5 0.000604743f
C932 BL_3_2 net137_6 0.000604743f
C933 BL_3_2 net137_7 0.000302371f
C934 BL_3_2 net137_8 0.000604743f
C935 BL_3_2 net137_9 0.000935713f
C936 BL_3_2 net13_3 5.74015e-05f
C937 BL_3_2 net14_11 0.000141804f
C938 BL_3_2 net85 0.000556699f
C939 BL_3_2 net85_2 0.000725153f
C940 BL_3_2 net85_3 0.000725153f
C941 BL_3_2 net85_4 0.000525215f
C942 BL_3_2 net85_5 0.00123453f
C943 BL_3_2 net85_7 0.00187706f
C944 BL_4 VDD_1 0.000335886f
C945 BL_4 VSS_0 0.0260591f
C946 BL_4 WL_0_12 0.00020165f
C947 BL_4 WL_0_13 0.0102708f
C948 BL_4 WL_0_22 9.27059e-05f
C949 BL_4 WL_0_23 9.27059e-05f
C950 BL_4 WL_0_4 0.000121748f
C951 BL_4 WL_0_5 0.00620107f
C952 BL_4 WL_1_5 0.000225729f
C953 BL_4 XB_0_3 0.00017124f
C954 BL_4 XB_0_3_1 0.00154133f
C955 BL_4 XB_0_3_2 0.000101177f
C956 BL_4 XB_0_3_3 0.000202355f
C957 BL_4 XB_1_3_3 1.54132e-05f
C958 BL_4 net139_9 2.49146e-05f
C959 BL_4 net16 0.000536419f
C960 BL_4 net16_3 0.000698736f
C961 BL_4 net16_6 0.000506081f
C962 BL_4 net16_7 0.00180868f
C963 BL_4 net17 0.00150045f
C964 BL_4 net17_11 0.000879613f
C965 BL_4 net17_2 0.00130173f
C966 BL_4 net17_3 0.00141304f
C967 BL_4 net17_4 0.00142342f
C968 BL_4 net17_6 0.000568487f
C969 BL_4 net17_8 0.000568487f
C970 BL_4 net88_3 2.46218e-05f
C971 BL_4_1 VDD_1 0.000117142f
C972 BL_4_1 VSS_0 0.00913604f
C973 BL_4_1 WL_0_24 0.00472184f
C974 BL_4_1 WL_0_25 0.00472184f
C975 BL_4_1 WL_1_5 8.42304e-05f
C976 BL_4_1 XB_0_3_1 0.000308026f
C977 BL_4_1 net16_2 0.000698736f
C978 BL_4_1 net16_4 0.00118955f
C979 BL_4_1 net17_5 0.000568487f
C980 BL_4_1 net17_7 0.000284243f
C981 BL_4_1 net17_9 0.00136682f
C982 BL_4_2 VDD_1 0.00126632f
C983 BL_4_2 VSS_0 0.0234919f
C984 BL_4_2 VSS_2 0.0118792f
C985 BL_4_2 WL_0_5 0.000508355f
C986 BL_4_2 WL_1_12 0.000206394f
C987 BL_4_2 WL_1_13 0.0102304f
C988 BL_4_2 WL_1_22 9.48868e-05f
C989 BL_4_2 WL_1_23 9.48868e-05f
C990 BL_4_2 WL_1_24 0.00470329f
C991 BL_4_2 WL_1_25 0.00470329f
C992 BL_4_2 WL_1_4 0.000124612f
C993 BL_4_2 WL_1_5 0.00617671f
C994 BL_4_2 XB_0_3_3 3.24346e-05f
C995 BL_4_2 XB_1_3 0.000166764f
C996 BL_4_2 XB_1_3_1 0.00185733f
C997 BL_4_2 XB_1_3_2 9.85324e-05f
C998 BL_4_2 XB_1_3_3 0.000197065f
C999 BL_4_2 net139 0.00159615f
C1000 BL_4_2 net139_10 0.00145399f
C1001 BL_4_2 net139_2 0.00138475f
C1002 BL_4_2 net139_3 0.00150316f
C1003 BL_4_2 net139_4 0.0015142f
C1004 BL_4_2 net139_5 0.000604743f
C1005 BL_4_2 net139_6 0.000604743f
C1006 BL_4_2 net139_7 0.000302371f
C1007 BL_4_2 net139_8 0.000604743f
C1008 BL_4_2 net139_9 0.000935713f
C1009 BL_4_2 net16_3 5.74015e-05f
C1010 BL_4_2 net17_11 0.000141804f
C1011 BL_4_2 net88 0.000556699f
C1012 BL_4_2 net88_2 0.000725153f
C1013 BL_4_2 net88_3 0.000725153f
C1014 BL_4_2 net88_4 0.000525215f
C1015 BL_4_2 net88_5 0.00123453f
C1016 BL_4_2 net88_7 0.00187706f
C1017 BL_5 VDD_1 0.000335886f
C1018 BL_5 VSS_0 0.0260591f
C1019 BL_5 WL_0_13 0.00020165f
C1020 BL_5 WL_0_14 0.0102708f
C1021 BL_5 WL_0_24 9.27059e-05f
C1022 BL_5 WL_0_25 9.27059e-05f
C1023 BL_5 WL_0_5 0.000121748f
C1024 BL_5 WL_0_6 0.00620107f
C1025 BL_5 WL_1_6 0.000225729f
C1026 BL_5 XB_0_4 0.00017124f
C1027 BL_5 XB_0_4_1 0.00154133f
C1028 BL_5 XB_0_4_2 0.000101177f
C1029 BL_5 XB_0_4_3 0.000202355f
C1030 BL_5 XB_1_4_3 1.54132e-05f
C1031 BL_5 net141_9 2.49146e-05f
C1032 BL_5 net20 0.000536419f
C1033 BL_5 net20_3 0.000698736f
C1034 BL_5 net20_6 0.000506081f
C1035 BL_5 net20_7 0.00180868f
C1036 BL_5 net21 0.00150045f
C1037 BL_5 net21_11 0.000879613f
C1038 BL_5 net21_2 0.00130173f
C1039 BL_5 net21_3 0.00141304f
C1040 BL_5 net21_4 0.00142342f
C1041 BL_5 net21_6 0.000568487f
C1042 BL_5 net21_8 0.000568487f
C1043 BL_5 net91_3 2.46218e-05f
C1044 BL_5_1 VDD_1 0.000117142f
C1045 BL_5_1 VSS_0 0.00913604f
C1046 BL_5_1 WL_0_26 0.00472184f
C1047 BL_5_1 WL_0_27 0.00472184f
C1048 BL_5_1 WL_1_6 8.42304e-05f
C1049 BL_5_1 XB_0_4_1 0.000308026f
C1050 BL_5_1 net20_2 0.000698736f
C1051 BL_5_1 net20_4 0.00118955f
C1052 BL_5_1 net21_5 0.000568487f
C1053 BL_5_1 net21_7 0.000284243f
C1054 BL_5_1 net21_9 0.00136682f
C1055 BL_5_2 VDD_1 0.00126632f
C1056 BL_5_2 VSS_0 0.0234919f
C1057 BL_5_2 VSS_2 0.0118792f
C1058 BL_5_2 WL_0_6 0.000508355f
C1059 BL_5_2 WL_1_13 0.000206394f
C1060 BL_5_2 WL_1_14 0.0102304f
C1061 BL_5_2 WL_1_24 9.48868e-05f
C1062 BL_5_2 WL_1_25 9.48868e-05f
C1063 BL_5_2 WL_1_26 0.00470329f
C1064 BL_5_2 WL_1_27 0.00470329f
C1065 BL_5_2 WL_1_5 0.000124612f
C1066 BL_5_2 WL_1_6 0.00617671f
C1067 BL_5_2 XB_0_4_3 3.24346e-05f
C1068 BL_5_2 XB_1_4 0.000166764f
C1069 BL_5_2 XB_1_4_1 0.00185733f
C1070 BL_5_2 XB_1_4_2 9.85324e-05f
C1071 BL_5_2 XB_1_4_3 0.000197065f
C1072 BL_5_2 net141 0.00159615f
C1073 BL_5_2 net141_10 0.00145399f
C1074 BL_5_2 net141_2 0.00138475f
C1075 BL_5_2 net141_3 0.00150316f
C1076 BL_5_2 net141_4 0.0015142f
C1077 BL_5_2 net141_5 0.000604743f
C1078 BL_5_2 net141_6 0.000604743f
C1079 BL_5_2 net141_7 0.000302371f
C1080 BL_5_2 net141_8 0.000604743f
C1081 BL_5_2 net141_9 0.000935713f
C1082 BL_5_2 net20_3 5.74015e-05f
C1083 BL_5_2 net21_11 0.000141804f
C1084 BL_5_2 net91 0.000556699f
C1085 BL_5_2 net91_2 0.000725153f
C1086 BL_5_2 net91_3 0.000725153f
C1087 BL_5_2 net91_4 0.000525215f
C1088 BL_5_2 net91_5 0.00123453f
C1089 BL_5_2 net91_7 0.00187706f
C1090 BL_6 VDD_1 0.000335886f
C1091 BL_6 VSS_0 0.0260591f
C1092 BL_6 WL_0_14 0.00020165f
C1093 BL_6 WL_0_15 0.015261f
C1094 BL_6 WL_0_26 9.27059e-05f
C1095 BL_6 WL_0_27 9.27059e-05f
C1096 BL_6 WL_0_6 0.000121748f
C1097 BL_6 WL_0_7 0.00422308f
C1098 BL_6 WL_1_7 0.000225729f
C1099 BL_6 XB_0_5 0.00017124f
C1100 BL_6 XB_0_5_1 0.00154133f
C1101 BL_6 XB_0_5_2 0.000101177f
C1102 BL_6 XB_0_5_3 0.000202355f
C1103 BL_6 XB_1_5_3 1.54132e-05f
C1104 BL_6 net142_9 2.49146e-05f
C1105 BL_6 net23 0.000536419f
C1106 BL_6 net23_3 0.000698736f
C1107 BL_6 net23_6 0.000506081f
C1108 BL_6 net23_7 0.00180868f
C1109 BL_6 net24 0.00150045f
C1110 BL_6 net24_11 0.000879613f
C1111 BL_6 net24_2 0.00130173f
C1112 BL_6 net24_3 0.00141304f
C1113 BL_6 net24_4 0.00142342f
C1114 BL_6 net24_6 0.000568487f
C1115 BL_6 net24_8 0.000568487f
C1116 BL_6 net94_3 2.46218e-05f
C1117 BL_6_1 VDD_1 0.000117142f
C1118 BL_6_1 VSS_0 0.00913604f
C1119 BL_6_1 WL_0_28 0.00321569f
C1120 BL_6_1 WL_0_29 0.00321569f
C1121 BL_6_1 WL_1_7 8.42304e-05f
C1122 BL_6_1 XB_0_5_1 0.000308026f
C1123 BL_6_1 net23_2 0.000698736f
C1124 BL_6_1 net23_4 0.00118955f
C1125 BL_6_1 net24_5 0.000568487f
C1126 BL_6_1 net24_7 0.000284243f
C1127 BL_6_1 net24_9 0.00136682f
C1128 BL_6_2 VDD_1 0.00126632f
C1129 BL_6_2 VSS_0 0.0234919f
C1130 BL_6_2 VSS_2 0.0118792f
C1131 BL_6_2 WL_0_7 0.000508355f
C1132 BL_6_2 WL_1_14 0.000206394f
C1133 BL_6_2 WL_1_15 0.0152011f
C1134 BL_6_2 WL_1_26 9.48868e-05f
C1135 BL_6_2 WL_1_27 9.48868e-05f
C1136 BL_6_2 WL_1_28 0.00320306f
C1137 BL_6_2 WL_1_29 0.00320306f
C1138 BL_6_2 WL_1_6 0.000124612f
C1139 BL_6_2 WL_1_7 0.00420649f
C1140 BL_6_2 XB_0_5_3 3.24346e-05f
C1141 BL_6_2 XB_1_5 0.000166764f
C1142 BL_6_2 XB_1_5_1 0.00185733f
C1143 BL_6_2 XB_1_5_2 9.85324e-05f
C1144 BL_6_2 XB_1_5_3 0.000197065f
C1145 BL_6_2 net142 0.00159615f
C1146 BL_6_2 net142_10 0.00145399f
C1147 BL_6_2 net142_2 0.00138475f
C1148 BL_6_2 net142_3 0.00150316f
C1149 BL_6_2 net142_4 0.0015142f
C1150 BL_6_2 net142_5 0.000604743f
C1151 BL_6_2 net142_6 0.000604743f
C1152 BL_6_2 net142_7 0.000302371f
C1153 BL_6_2 net142_8 0.000604743f
C1154 BL_6_2 net142_9 0.000935713f
C1155 BL_6_2 net23_3 5.74015e-05f
C1156 BL_6_2 net24_11 0.000141804f
C1157 BL_6_2 net94 0.000556699f
C1158 BL_6_2 net94_2 0.000725153f
C1159 BL_6_2 net94_3 0.000725153f
C1160 BL_6_2 net94_4 0.000525215f
C1161 BL_6_2 net94_5 0.00123453f
C1162 BL_6_2 net94_7 0.00187706f
C1163 BL_7 VDD_1 0.000306464f
C1164 BL_7 VSS_0 0.026031f
C1165 BL_7 WL_0_15 0.000299626f
C1166 BL_7 WL_0_28 6.3135e-05f
C1167 BL_7 WL_0_29 6.3135e-05f
C1168 BL_7 WL_0_7 8.29136e-05f
C1169 BL_7 WL_0_8 0.0103249f
C1170 BL_7 WL_1_8 0.000214419f
C1171 BL_7 XB_0_6 0.00017124f
C1172 BL_7 XB_0_6_1 0.00154823f
C1173 BL_7 XB_0_6_2 0.000101177f
C1174 BL_7 XB_0_6_3 0.000202355f
C1175 BL_7 XB_1_6_3 1.78683e-05f
C1176 BL_7 net144_9 6.35631e-05f
C1177 BL_7 net27 0.00054002f
C1178 BL_7 net27_3 0.000703427f
C1179 BL_7 net27_6 0.000509479f
C1180 BL_7 net27_7 0.00182082f
C1181 BL_7 net28 0.00148523f
C1182 BL_7 net28_11 0.000870692f
C1183 BL_7 net28_2 0.00128853f
C1184 BL_7 net28_3 0.00139871f
C1185 BL_7 net28_4 0.00140898f
C1186 BL_7 net28_6 0.000562721f
C1187 BL_7 net28_8 0.000562721f
C1188 BL_7 net97_3 1.38403e-05f
C1189 BL_7_1 VDD_1 0.000106163f
C1190 BL_7_1 VSS_0 0.00912555f
C1191 BL_7_1 WL_0_30 0.00786195f
C1192 BL_7_1 WL_0_31 0.00786195f
C1193 BL_7_1 WL_1_8 8.00102e-05f
C1194 BL_7_1 XB_0_6_1 0.000310601f
C1195 BL_7_1 net144_9 2.37184e-05f
C1196 BL_7_1 net27_2 0.000703427f
C1197 BL_7_1 net27_4 0.00119754f
C1198 BL_7_1 net28_5 0.000562721f
C1199 BL_7_1 net28_7 0.00028136f
C1200 BL_7_1 net28_9 0.00135296f
C1201 BL_7_2 VDD_1 0.0012579f
C1202 BL_7_2 VSS_0 0.0234543f
C1203 BL_7_2 VSS_2 0.0119436f
C1204 BL_7_2 WL_0_8 0.000500175f
C1205 BL_7_2 WL_1_15 0.000306675f
C1206 BL_7_2 WL_1_28 6.46203e-05f
C1207 BL_7_2 WL_1_29 6.46203e-05f
C1208 BL_7_2 WL_1_30 0.00783948f
C1209 BL_7_2 WL_1_31 0.00783948f
C1210 BL_7_2 WL_1_7 8.48642e-05f
C1211 BL_7_2 WL_1_8 0.0102954f
C1212 BL_7_2 XB_0_6_3 3.94945e-05f
C1213 BL_7_2 XB_1_6 0.000166764f
C1214 BL_7_2 XB_1_6_1 0.0018946f
C1215 BL_7_2 XB_1_6_2 9.85324e-05f
C1216 BL_7_2 XB_1_6_3 0.000197065f
C1217 BL_7_2 net144 0.00158158f
C1218 BL_7_2 net144_10 0.00144072f
C1219 BL_7_2 net144_2 0.00137212f
C1220 BL_7_2 net144_3 0.00148944f
C1221 BL_7_2 net144_4 0.00150038f
C1222 BL_7_2 net144_5 0.000599223f
C1223 BL_7_2 net144_6 0.000599223f
C1224 BL_7_2 net144_7 0.000299612f
C1225 BL_7_2 net144_8 0.000599223f
C1226 BL_7_2 net144_9 0.000927172f
C1227 BL_7_2 net27_3 2.53018e-05f
C1228 BL_7_2 net28_11 0.000151076f
C1229 BL_7_2 net97 0.000534975f
C1230 BL_7_2 net97_2 0.000696855f
C1231 BL_7_2 net97_3 0.000696855f
C1232 BL_7_2 net97_4 0.000504719f
C1233 BL_7_2 net97_5 0.00118635f
C1234 BL_7_2 net97_7 0.00180381f
C1235 P_0_0 VDD_1 0.000524246f
C1236 P_0_0 VSS_0 0.00784908f
C1237 P_0_0 WL_0_17 0.000623861f
C1238 P_0_0 XB_0_0 0.00182788f
C1239 P_0_0 net4 0.00860146f
C1240 P_0_0 net4_11 0.00504245f
C1241 P_0_0 net4_3 0.00810037f
C1242 P_0_0 net4_4 0.00815985f
C1243 P_0_0 net4_6 0.00325889f
C1244 P_0_0 net67 0.000305866f
C1245 P_0_0_1 VDD_1 0.00112302f
C1246 P_0_0_1 VSS_0 0.016814f
C1247 P_0_0_1 WL_0_17 0.00133641f
C1248 P_0_0_1 XB_0_0 0.00391562f
C1249 P_0_0_1 net4_2 0.00746229f
C1250 P_0_0_1 net67 0.000655213f
C1251 P_0_0_2 VDD_1 0.00204302f
C1252 P_0_0_2 VSS_0 0.0305883f
C1253 P_0_0_2 WL_0_17 0.00243122f
C1254 P_0_0_2 XB_0_0 0.00712337f
C1255 P_0_0_2 net4_5 0.00325889f
C1256 P_0_0_2 net4_9 0.0078354f
C1257 P_0_0_2 net67 0.00119198f
C1258 P_0_0_3 VDD_1 0.000226659f
C1259 P_0_0_3 VSS_0 0.00339357f
C1260 P_0_0_3 WL_0_17 0.000269728f
C1261 P_0_0_3 XB_0_0 0.000790291f
C1262 P_0_0_3 net4_7 0.00162945f
C1263 P_0_0_3 net67 0.000132242f
C1264 P_0_0_4 VDD_1 0.000456916f
C1265 P_0_0_4 VSS_0 0.00751128f
C1266 P_0_0_4 WL_0_17 0.000543737f
C1267 P_0_0_4 XB_0_0_2 0.00159313f
C1268 P_0_0_4 net67 0.000266583f
C1269 P_0_0_5 VDD_1 0.00592267f
C1270 P_0_0_5 VSS_0 0.0140139f
C1271 P_0_0_5 WL_0_17 0.0010679f
C1272 P_0_0_5 XB_0_0_3 0.00312891f
C1273 P_0_0_5 net4_8 0.00325889f
C1274 P_0_0_5 net67 0.000523571f
C1275 P_0_1 VDD_1 0.000513378f
C1276 P_0_1 VSS_0 0.00783022f
C1277 P_0_1 WL_0_19 0.000639215f
C1278 P_0_1 XB_0_1 0.00182559f
C1279 P_0_1 net68 0.000304434f
C1280 P_0_1 net7 0.00860398f
C1281 P_0_1 net7_11 0.00504393f
C1282 P_0_1 net7_3 0.00810274f
C1283 P_0_1 net7_4 0.00816224f
C1284 P_0_1 net7_6 0.00325985f
C1285 P_0_1_1 VDD_1 0.00109974f
C1286 P_0_1_1 VSS_0 0.0167736f
C1287 P_0_1_1 WL_0_19 0.0013693f
C1288 P_0_1_1 XB_0_1 0.00391069f
C1289 P_0_1_1 net68 0.000652145f
C1290 P_0_1_1 net7_2 0.00746448f
C1291 P_0_1_2 VDD_1 0.00200067f
C1292 P_0_1_2 VSS_0 0.0305148f
C1293 P_0_1_2 WL_0_19 0.00249106f
C1294 P_0_1_2 XB_0_1 0.00711442f
C1295 P_0_1_2 net68 0.0011864f
C1296 P_0_1_2 net7_5 0.00325985f
C1297 P_0_1_2 net7_9 0.0078377f
C1298 P_0_1_3 VDD_1 0.000221961f
C1299 P_0_1_3 VSS_0 0.00338542f
C1300 P_0_1_3 WL_0_19 0.000276366f
C1301 P_0_1_3 XB_0_1 0.000789298f
C1302 P_0_1_3 net68 0.000131623f
C1303 P_0_1_3 net7_7 0.00162992f
C1304 P_0_1_4 VDD_1 0.000447444f
C1305 P_0_1_4 VSS_0 0.00749484f
C1306 P_0_1_4 WL_0_19 0.00055712f
C1307 P_0_1_4 XB_0_1_2 0.00159112f
C1308 P_0_1_4 net68 0.000265335f
C1309 P_0_1_5 VDD_1 0.00586068f
C1310 P_0_1_5 VSS_0 0.0139633f
C1311 P_0_1_5 WL_0_19 0.00109419f
C1312 P_0_1_5 XB_0_1_3 0.00312498f
C1313 P_0_1_5 net68 0.000521119f
C1314 P_0_1_5 net7_8 0.00325985f
C1315 P_0_2 VDD_1 0.000513378f
C1316 P_0_2 VSS_0 0.00783022f
C1317 P_0_2 WL_0_21 0.000639215f
C1318 P_0_2 XB_0_2 0.00182559f
C1319 P_0_2 net11 0.00860398f
C1320 P_0_2 net11_11 0.00504393f
C1321 P_0_2 net11_3 0.00810274f
C1322 P_0_2 net11_4 0.00816224f
C1323 P_0_2 net11_6 0.00325985f
C1324 P_0_2 net69 0.000304434f
C1325 P_0_2_1 VDD_1 0.00109974f
C1326 P_0_2_1 VSS_0 0.0167736f
C1327 P_0_2_1 WL_0_21 0.0013693f
C1328 P_0_2_1 XB_0_2 0.00391069f
C1329 P_0_2_1 net11_2 0.00746448f
C1330 P_0_2_1 net69 0.000652145f
C1331 P_0_2_2 VDD_1 0.00200067f
C1332 P_0_2_2 VSS_0 0.0305148f
C1333 P_0_2_2 WL_0_21 0.00249106f
C1334 P_0_2_2 XB_0_2 0.00711442f
C1335 P_0_2_2 net11_5 0.00325985f
C1336 P_0_2_2 net11_9 0.0078377f
C1337 P_0_2_2 net69 0.0011864f
C1338 P_0_2_3 VDD_1 0.000221961f
C1339 P_0_2_3 VSS_0 0.00338542f
C1340 P_0_2_3 WL_0_21 0.000276366f
C1341 P_0_2_3 XB_0_2 0.000789298f
C1342 P_0_2_3 net11_7 0.00162992f
C1343 P_0_2_3 net69 0.000131623f
C1344 P_0_2_4 VDD_1 0.000447444f
C1345 P_0_2_4 VSS_0 0.00749484f
C1346 P_0_2_4 WL_0_21 0.00055712f
C1347 P_0_2_4 XB_0_2_2 0.00159112f
C1348 P_0_2_4 net69 0.000265335f
C1349 P_0_2_5 VDD_1 0.00586068f
C1350 P_0_2_5 VSS_0 0.0139633f
C1351 P_0_2_5 WL_0_21 0.00109419f
C1352 P_0_2_5 XB_0_2_3 0.00312498f
C1353 P_0_2_5 net11_8 0.00325985f
C1354 P_0_2_5 net69 0.000521119f
C1355 P_0_3 VDD_1 0.000513378f
C1356 P_0_3 VSS_0 0.00783022f
C1357 P_0_3 WL_0_23 0.000639215f
C1358 P_0_3 XB_0_3 0.00182559f
C1359 P_0_3 net14 0.00860398f
C1360 P_0_3 net14_11 0.00504393f
C1361 P_0_3 net14_3 0.00810274f
C1362 P_0_3 net14_4 0.00816224f
C1363 P_0_3 net14_6 0.00325985f
C1364 P_0_3 net70 0.000304434f
C1365 P_0_3_1 VDD_1 0.00109974f
C1366 P_0_3_1 VSS_0 0.0167736f
C1367 P_0_3_1 WL_0_23 0.0013693f
C1368 P_0_3_1 XB_0_3 0.00391069f
C1369 P_0_3_1 net14_2 0.00746448f
C1370 P_0_3_1 net70 0.000652145f
C1371 P_0_3_2 VDD_1 0.00200067f
C1372 P_0_3_2 VSS_0 0.0305148f
C1373 P_0_3_2 WL_0_23 0.00249106f
C1374 P_0_3_2 XB_0_3 0.00711442f
C1375 P_0_3_2 net14_5 0.00325985f
C1376 P_0_3_2 net14_9 0.0078377f
C1377 P_0_3_2 net70 0.0011864f
C1378 P_0_3_3 VDD_1 0.000221961f
C1379 P_0_3_3 VSS_0 0.00338542f
C1380 P_0_3_3 WL_0_23 0.000276366f
C1381 P_0_3_3 XB_0_3 0.000789298f
C1382 P_0_3_3 net14_7 0.00162992f
C1383 P_0_3_3 net70 0.000131623f
C1384 P_0_3_4 VDD_1 0.000447444f
C1385 P_0_3_4 VSS_0 0.00749484f
C1386 P_0_3_4 WL_0_23 0.00055712f
C1387 P_0_3_4 XB_0_3_2 0.00159112f
C1388 P_0_3_4 net70 0.000265335f
C1389 P_0_3_5 VDD_1 0.00586068f
C1390 P_0_3_5 VSS_0 0.0139633f
C1391 P_0_3_5 WL_0_23 0.00109419f
C1392 P_0_3_5 XB_0_3_3 0.00312498f
C1393 P_0_3_5 net14_8 0.00325985f
C1394 P_0_3_5 net70 0.000521119f
C1395 P_0_4 VDD_1 0.000513378f
C1396 P_0_4 VSS_0 0.00783022f
C1397 P_0_4 WL_0_25 0.000639215f
C1398 P_0_4 XB_0_4 0.00182559f
C1399 P_0_4 net17 0.00860398f
C1400 P_0_4 net17_11 0.00504393f
C1401 P_0_4 net17_3 0.00810274f
C1402 P_0_4 net17_4 0.00816224f
C1403 P_0_4 net17_6 0.00325985f
C1404 P_0_4 net71 0.000304434f
C1405 P_0_4_1 VDD_1 0.00109974f
C1406 P_0_4_1 VSS_0 0.0167736f
C1407 P_0_4_1 WL_0_25 0.0013693f
C1408 P_0_4_1 XB_0_4 0.00391069f
C1409 P_0_4_1 net17_2 0.00746448f
C1410 P_0_4_1 net71 0.000652145f
C1411 P_0_4_2 VDD_1 0.00200067f
C1412 P_0_4_2 VSS_0 0.0305148f
C1413 P_0_4_2 WL_0_25 0.00249106f
C1414 P_0_4_2 XB_0_4 0.00711442f
C1415 P_0_4_2 net17_5 0.00325985f
C1416 P_0_4_2 net17_9 0.0078377f
C1417 P_0_4_2 net71 0.0011864f
C1418 P_0_4_3 VDD_1 0.000221961f
C1419 P_0_4_3 VSS_0 0.00338542f
C1420 P_0_4_3 WL_0_25 0.000276366f
C1421 P_0_4_3 XB_0_4 0.000789298f
C1422 P_0_4_3 net17_7 0.00162992f
C1423 P_0_4_3 net71 0.000131623f
C1424 P_0_4_4 VDD_1 0.000447444f
C1425 P_0_4_4 VSS_0 0.00749484f
C1426 P_0_4_4 WL_0_25 0.00055712f
C1427 P_0_4_4 XB_0_4_2 0.00159112f
C1428 P_0_4_4 net71 0.000265335f
C1429 P_0_4_5 VDD_1 0.00586068f
C1430 P_0_4_5 VSS_0 0.0139633f
C1431 P_0_4_5 WL_0_25 0.00109419f
C1432 P_0_4_5 XB_0_4_3 0.00312498f
C1433 P_0_4_5 net17_8 0.00325985f
C1434 P_0_4_5 net71 0.000521119f
C1435 P_0_5 VDD_1 0.000513378f
C1436 P_0_5 VSS_0 0.00783022f
C1437 P_0_5 WL_0_27 0.000639215f
C1438 P_0_5 XB_0_5 0.00182559f
C1439 P_0_5 net21 0.00860398f
C1440 P_0_5 net21_11 0.00504393f
C1441 P_0_5 net21_3 0.00810274f
C1442 P_0_5 net21_4 0.00816224f
C1443 P_0_5 net21_6 0.00325985f
C1444 P_0_5 net72 0.000304434f
C1445 P_0_5_1 VDD_1 0.00109974f
C1446 P_0_5_1 VSS_0 0.0167736f
C1447 P_0_5_1 WL_0_27 0.0013693f
C1448 P_0_5_1 XB_0_5 0.00391069f
C1449 P_0_5_1 net21_2 0.00746448f
C1450 P_0_5_1 net72 0.000652145f
C1451 P_0_5_2 VDD_1 0.00200067f
C1452 P_0_5_2 VSS_0 0.0305148f
C1453 P_0_5_2 WL_0_27 0.00249106f
C1454 P_0_5_2 XB_0_5 0.00711442f
C1455 P_0_5_2 net21_5 0.00325985f
C1456 P_0_5_2 net21_9 0.0078377f
C1457 P_0_5_2 net72 0.0011864f
C1458 P_0_5_3 VDD_1 0.000221961f
C1459 P_0_5_3 VSS_0 0.00338542f
C1460 P_0_5_3 WL_0_27 0.000276366f
C1461 P_0_5_3 XB_0_5 0.000789298f
C1462 P_0_5_3 net21_7 0.00162992f
C1463 P_0_5_3 net72 0.000131623f
C1464 P_0_5_4 VDD_1 0.000447444f
C1465 P_0_5_4 VSS_0 0.00749484f
C1466 P_0_5_4 WL_0_27 0.00055712f
C1467 P_0_5_4 XB_0_5_2 0.00159112f
C1468 P_0_5_4 net72 0.000265335f
C1469 P_0_5_5 VDD_1 0.00586068f
C1470 P_0_5_5 VSS_0 0.0139633f
C1471 P_0_5_5 WL_0_27 0.00109419f
C1472 P_0_5_5 XB_0_5_3 0.00312498f
C1473 P_0_5_5 net21_8 0.00325985f
C1474 P_0_5_5 net72 0.000521119f
C1475 P_0_6 VDD_1 0.000513378f
C1476 P_0_6 VSS_0 0.00782693f
C1477 P_0_6 WL_0_29 0.000639215f
C1478 P_0_6 XB_0_6 0.00182559f
C1479 P_0_6 net24 0.00860398f
C1480 P_0_6 net24_11 0.00504393f
C1481 P_0_6 net24_3 0.00810274f
C1482 P_0_6 net24_4 0.00816224f
C1483 P_0_6 net24_6 0.00325985f
C1484 P_0_6 net73 0.000304434f
C1485 P_0_6_1 VDD_1 0.00109974f
C1486 P_0_6_1 VSS_0 0.0167665f
C1487 P_0_6_1 WL_0_29 0.0013693f
C1488 P_0_6_1 XB_0_6 0.00391069f
C1489 P_0_6_1 net24_2 0.00746448f
C1490 P_0_6_1 net73 0.000652145f
C1491 P_0_6_2 VDD_1 0.00200067f
C1492 P_0_6_2 VSS_0 0.030502f
C1493 P_0_6_2 WL_0_29 0.00249106f
C1494 P_0_6_2 XB_0_6 0.00711442f
C1495 P_0_6_2 net24_5 0.00325985f
C1496 P_0_6_2 net24_9 0.0078377f
C1497 P_0_6_2 net73 0.0011864f
C1498 P_0_6_3 VDD_1 0.000221961f
C1499 P_0_6_3 VSS_0 0.003384f
C1500 P_0_6_3 WL_0_29 0.000276366f
C1501 P_0_6_3 XB_0_6 0.000789298f
C1502 P_0_6_3 net24_7 0.00162992f
C1503 P_0_6_3 net73 0.000131623f
C1504 P_0_6_4 VDD_1 0.000447444f
C1505 P_0_6_4 VSS_0 0.00752078f
C1506 P_0_6_4 WL_0_29 0.00055712f
C1507 P_0_6_4 XB_0_6_2 0.00159112f
C1508 P_0_6_4 net73 0.000265335f
C1509 P_0_6_5 VDD_1 0.00583258f
C1510 P_0_6_5 VSS_0 0.0140268f
C1511 P_0_6_5 WL_0_29 0.00109419f
C1512 P_0_6_5 XB_0_6_3 0.00312498f
C1513 P_0_6_5 net24_8 0.00325985f
C1514 P_0_6_5 net73 0.000521119f
C1515 P_0_7 VDD_1 0.000519975f
C1516 P_0_7 VSS_0 0.00779668f
C1517 P_0_7 WL_0_31 0.000627227f
C1518 P_0_7 XB_0_7 0.00185002f
C1519 P_0_7 net28 0.00862064f
C1520 P_0_7 net28_11 0.0050537f
C1521 P_0_7 net28_3 0.00811843f
C1522 P_0_7 net28_4 0.00817805f
C1523 P_0_7 net28_6 0.00326616f
C1524 P_0_7 net74 0.00031029f
C1525 P_0_7_1 VDD_1 0.00111387f
C1526 P_0_7_1 VSS_0 0.0167017f
C1527 P_0_7_1 WL_0_31 0.00134362f
C1528 P_0_7_1 XB_0_7 0.00396303f
C1529 P_0_7_1 net28_2 0.00747893f
C1530 P_0_7_1 net74 0.000664691f
C1531 P_0_7_2 VDD_1 0.00202637f
C1532 P_0_7_2 VSS_0 0.0303841f
C1533 P_0_7_2 WL_0_31 0.00244434f
C1534 P_0_7_2 XB_0_7 0.00720963f
C1535 P_0_7_2 net28_5 0.00326616f
C1536 P_0_7_2 net28_9 0.00785288f
C1537 P_0_7_2 net74 0.00120922f
C1538 P_0_7_3 VDD_1 0.000224813f
C1539 P_0_7_3 VSS_0 0.00337092f
C1540 P_0_7_3 WL_0_31 0.000271183f
C1541 P_0_7_3 XB_0_7 0.000799861f
C1542 P_0_7_3 net28_7 0.00163308f
C1543 P_0_7_3 net74 0.000134155f
C1544 P_0_7_4 VDD_1 0.000453194f
C1545 P_0_7_4 VSS_0 0.00679534f
C1546 P_0_7_4 WL_0_31 0.000546671f
C1547 P_0_7_4 XB_0_7_2 0.00161242f
C1548 P_0_7_4 net74 0.000270439f
C1549 P_0_7_5 VDD_1 0.00589077f
C1550 P_0_7_5 VSS_0 0.013833f
C1551 P_0_7_5 WL_0_31 0.00107366f
C1552 P_0_7_5 XB_0_7_3 0.0031668f
C1553 P_0_7_5 net28_8 0.00326616f
C1554 P_0_7_5 net74 0.000531144f
C1555 P_1_0 VDD_1 0.00102316f
C1556 P_1_0 VSS_0 0.0048111f
C1557 P_1_0 VSS_2 0.00298571f
C1558 P_1_0 WL_1_17 0.000633931f
C1559 P_1_0 XB_1_0 0.00181452f
C1560 P_1_0 net133 0.00860991f
C1561 P_1_0 net133_3 0.00810832f
C1562 P_1_0 net133_4 0.00816787f
C1563 P_1_0 net133_6 0.00326209f
C1564 P_1_0 net133_9 0.00504741f
C1565 P_1_0 net78 0.000289928f
C1566 P_1_0_1 VDD_1 0.00219176f
C1567 P_1_0_1 VSS_0 0.0103061f
C1568 P_1_0_1 VSS_2 0.00639586f
C1569 P_1_0_1 WL_1_17 0.00135798f
C1570 P_1_0_1 XB_1_0 0.00388699f
C1571 P_1_0_1 net133_2 0.00746962f
C1572 P_1_0_1 net78 0.000621071f
C1573 P_1_0_2 VDD_1 0.00398731f
C1574 P_1_0_2 VSS_0 0.0187491f
C1575 P_1_0_2 VSS_2 0.0116355f
C1576 P_1_0_2 WL_1_17 0.00247046f
C1577 P_1_0_2 XB_1_0 0.0070713f
C1578 P_1_0_2 net133_10 0.0078431f
C1579 P_1_0_2 net133_5 0.00326209f
C1580 P_1_0_2 net78 0.00112987f
C1581 P_1_0_3 VDD_1 0.00175449f
C1582 P_1_0_3 VSS_0 0.00872779f
C1583 P_1_0_3 VSS_2 0.00511083f
C1584 P_1_0_3 WL_1_17 0.00108514f
C1585 P_1_0_3 XB_1_0_3 0.00310604f
C1586 P_1_0_3 net133_8 0.00326209f
C1587 P_1_0_3 net78 0.000496288f
C1588 P_1_0_4 VDD_1 0.000442365f
C1589 P_1_0_4 VSS_0 0.00208009f
C1590 P_1_0_4 VSS_2 0.00129088f
C1591 P_1_0_4 WL_1_17 0.000274082f
C1592 P_1_0_4 XB_1_0 0.000784514f
C1593 P_1_0_4 net133_7 0.00163105f
C1594 P_1_0_4 net78 0.000125351f
C1595 P_1_0_5 VDD_1 0.000902426f
C1596 P_1_0_5 VSS_0 0.00489091f
C1597 P_1_0_5 VSS_2 0.00261628f
C1598 P_1_0_5 WL_1_17 0.000552514f
C1599 P_1_0_5 XB_1_0_2 0.00158148f
C1600 P_1_0_5 net78 0.000252692f
C1601 P_1_1 VDD_1 0.00102182f
C1602 P_1_1 VSS_0 0.00483284f
C1603 P_1_1 VSS_2 0.00297442f
C1604 P_1_1 WL_1_19 0.0006346f
C1605 P_1_1 XB_1_1 0.0018235f
C1606 P_1_1 net134 0.00864253f
C1607 P_1_1 net134_3 0.00813905f
C1608 P_1_1 net134_4 0.00819881f
C1609 P_1_1 net134_6 0.00327445f
C1610 P_1_1 net134_9 0.00506653f
C1611 P_1_1 net81 0.000286513f
C1612 P_1_1_1 VDD_1 0.00218889f
C1613 P_1_1_1 VSS_0 0.0103527f
C1614 P_1_1_1 VSS_2 0.00637168f
C1615 P_1_1_1 WL_1_19 0.00135941f
C1616 P_1_1_1 XB_1_1 0.00390623f
C1617 P_1_1_1 net134_2 0.00749792f
C1618 P_1_1_1 net81 0.000613757f
C1619 P_1_1_2 VDD_1 0.00398207f
C1620 P_1_1_2 VSS_0 0.0188339f
C1621 P_1_1_2 VSS_2 0.0115915f
C1622 P_1_1_2 WL_1_19 0.00247307f
C1623 P_1_1_2 XB_1_1 0.0071063f
C1624 P_1_1_2 net134_10 0.00787282f
C1625 P_1_1_2 net134_5 0.00327445f
C1626 P_1_1_2 net81 0.00111656f
C1627 P_1_1_3 VDD_1 0.00175888f
C1628 P_1_1_3 VSS_0 0.00870871f
C1629 P_1_1_3 VSS_2 0.00509151f
C1630 P_1_1_3 WL_1_19 0.00108629f
C1631 P_1_1_3 XB_1_1_3 0.00312141f
C1632 P_1_1_3 net134_8 0.00327445f
C1633 P_1_1_3 net81 0.000490444f
C1634 P_1_1_4 VDD_1 0.000441785f
C1635 P_1_1_4 VSS_0 0.00208949f
C1636 P_1_1_4 VSS_2 0.001286f
C1637 P_1_1_4 WL_1_19 0.000274371f
C1638 P_1_1_4 XB_1_1 0.000788397f
C1639 P_1_1_4 net134_7 0.00163723f
C1640 P_1_1_4 net81 0.000123875f
C1641 P_1_1_5 VDD_1 0.000901256f
C1642 P_1_1_5 VSS_0 0.00490986f
C1643 P_1_1_5 VSS_2 0.00260644f
C1644 P_1_1_5 WL_1_19 0.000553097f
C1645 P_1_1_5 XB_1_1_2 0.00158931f
C1646 P_1_1_5 net81 0.000249716f
C1647 P_1_2 VDD_1 0.00102182f
C1648 P_1_2 VSS_0 0.00483284f
C1649 P_1_2 VSS_2 0.00297442f
C1650 P_1_2 WL_1_21 0.0006346f
C1651 P_1_2 XB_1_2 0.0018235f
C1652 P_1_2 net136 0.00864253f
C1653 P_1_2 net136_3 0.00813905f
C1654 P_1_2 net136_4 0.00819881f
C1655 P_1_2 net136_6 0.00327445f
C1656 P_1_2 net136_9 0.00506653f
C1657 P_1_2 net84 0.000286513f
C1658 P_1_2_1 VDD_1 0.00218889f
C1659 P_1_2_1 VSS_0 0.0103527f
C1660 P_1_2_1 VSS_2 0.00637168f
C1661 P_1_2_1 WL_1_21 0.00135941f
C1662 P_1_2_1 XB_1_2 0.00390623f
C1663 P_1_2_1 net136_2 0.00749792f
C1664 P_1_2_1 net84 0.000613757f
C1665 P_1_2_2 VDD_1 0.00398207f
C1666 P_1_2_2 VSS_0 0.0188339f
C1667 P_1_2_2 VSS_2 0.0115915f
C1668 P_1_2_2 WL_1_21 0.00247307f
C1669 P_1_2_2 XB_1_2 0.0071063f
C1670 P_1_2_2 net136_10 0.00787282f
C1671 P_1_2_2 net136_5 0.00327445f
C1672 P_1_2_2 net84 0.00111656f
C1673 P_1_2_3 VDD_1 0.00175888f
C1674 P_1_2_3 VSS_0 0.00870871f
C1675 P_1_2_3 VSS_2 0.00509151f
C1676 P_1_2_3 WL_1_21 0.00108629f
C1677 P_1_2_3 XB_1_2_3 0.00312141f
C1678 P_1_2_3 net136_8 0.00327445f
C1679 P_1_2_3 net84 0.000490444f
C1680 P_1_2_4 VDD_1 0.000441785f
C1681 P_1_2_4 VSS_0 0.00208949f
C1682 P_1_2_4 VSS_2 0.001286f
C1683 P_1_2_4 WL_1_21 0.000274371f
C1684 P_1_2_4 XB_1_2 0.000788397f
C1685 P_1_2_4 net136_7 0.00163723f
C1686 P_1_2_4 net84 0.000123875f
C1687 P_1_2_5 VDD_1 0.000901256f
C1688 P_1_2_5 VSS_0 0.00490986f
C1689 P_1_2_5 VSS_2 0.00260644f
C1690 P_1_2_5 WL_1_21 0.000553097f
C1691 P_1_2_5 XB_1_2_2 0.00158931f
C1692 P_1_2_5 net84 0.000249716f
C1693 P_1_3 VDD_1 0.00102182f
C1694 P_1_3 VSS_0 0.00483284f
C1695 P_1_3 VSS_2 0.00297442f
C1696 P_1_3 WL_1_23 0.0006346f
C1697 P_1_3 XB_1_3 0.0018235f
C1698 P_1_3 net137 0.00864253f
C1699 P_1_3 net137_3 0.00813905f
C1700 P_1_3 net137_4 0.00819881f
C1701 P_1_3 net137_6 0.00327445f
C1702 P_1_3 net137_9 0.00506653f
C1703 P_1_3 net87 0.000286513f
C1704 P_1_3_1 VDD_1 0.00218889f
C1705 P_1_3_1 VSS_0 0.0103527f
C1706 P_1_3_1 VSS_2 0.00637168f
C1707 P_1_3_1 WL_1_23 0.00135941f
C1708 P_1_3_1 XB_1_3 0.00390623f
C1709 P_1_3_1 net137_2 0.00749792f
C1710 P_1_3_1 net87 0.000613757f
C1711 P_1_3_2 VDD_1 0.00398207f
C1712 P_1_3_2 VSS_0 0.0188339f
C1713 P_1_3_2 VSS_2 0.0115915f
C1714 P_1_3_2 WL_1_23 0.00247307f
C1715 P_1_3_2 XB_1_3 0.0071063f
C1716 P_1_3_2 net137_10 0.00787282f
C1717 P_1_3_2 net137_5 0.00327445f
C1718 P_1_3_2 net87 0.00111656f
C1719 P_1_3_3 VDD_1 0.00175888f
C1720 P_1_3_3 VSS_0 0.00870871f
C1721 P_1_3_3 VSS_2 0.00509151f
C1722 P_1_3_3 WL_1_23 0.00108629f
C1723 P_1_3_3 XB_1_3_3 0.00312141f
C1724 P_1_3_3 net137_8 0.00327445f
C1725 P_1_3_3 net87 0.000490444f
C1726 P_1_3_4 VDD_1 0.000441785f
C1727 P_1_3_4 VSS_0 0.00208949f
C1728 P_1_3_4 VSS_2 0.001286f
C1729 P_1_3_4 WL_1_23 0.000274371f
C1730 P_1_3_4 XB_1_3 0.000788397f
C1731 P_1_3_4 net137_7 0.00163723f
C1732 P_1_3_4 net87 0.000123875f
C1733 P_1_3_5 VDD_1 0.000901256f
C1734 P_1_3_5 VSS_0 0.00490986f
C1735 P_1_3_5 VSS_2 0.00260644f
C1736 P_1_3_5 WL_1_23 0.000553097f
C1737 P_1_3_5 XB_1_3_2 0.00158931f
C1738 P_1_3_5 net87 0.000249716f
C1739 P_1_4 VDD_1 0.00102182f
C1740 P_1_4 VSS_0 0.00483284f
C1741 P_1_4 VSS_2 0.00297442f
C1742 P_1_4 WL_1_25 0.0006346f
C1743 P_1_4 XB_1_4 0.0018235f
C1744 P_1_4 net139 0.00864253f
C1745 P_1_4 net139_3 0.00813905f
C1746 P_1_4 net139_4 0.00819881f
C1747 P_1_4 net139_6 0.00327445f
C1748 P_1_4 net139_9 0.00506653f
C1749 P_1_4 net90 0.000286513f
C1750 P_1_4_1 VDD_1 0.00218889f
C1751 P_1_4_1 VSS_0 0.0103527f
C1752 P_1_4_1 VSS_2 0.00637168f
C1753 P_1_4_1 WL_1_25 0.00135941f
C1754 P_1_4_1 XB_1_4 0.00390623f
C1755 P_1_4_1 net139_2 0.00749792f
C1756 P_1_4_1 net90 0.000613757f
C1757 P_1_4_2 VDD_1 0.00398207f
C1758 P_1_4_2 VSS_0 0.0188339f
C1759 P_1_4_2 VSS_2 0.0115915f
C1760 P_1_4_2 WL_1_25 0.00247307f
C1761 P_1_4_2 XB_1_4 0.0071063f
C1762 P_1_4_2 net139_10 0.00787282f
C1763 P_1_4_2 net139_5 0.00327445f
C1764 P_1_4_2 net90 0.00111656f
C1765 P_1_4_3 VDD_1 0.00175888f
C1766 P_1_4_3 VSS_0 0.00870871f
C1767 P_1_4_3 VSS_2 0.00509151f
C1768 P_1_4_3 WL_1_25 0.00108629f
C1769 P_1_4_3 XB_1_4_3 0.00312141f
C1770 P_1_4_3 net139_8 0.00327445f
C1771 P_1_4_3 net90 0.000490444f
C1772 P_1_4_4 VDD_1 0.000441785f
C1773 P_1_4_4 VSS_0 0.00208949f
C1774 P_1_4_4 VSS_2 0.001286f
C1775 P_1_4_4 WL_1_25 0.000274371f
C1776 P_1_4_4 XB_1_4 0.000788397f
C1777 P_1_4_4 net139_7 0.00163723f
C1778 P_1_4_4 net90 0.000123875f
C1779 P_1_4_5 VDD_1 0.000901256f
C1780 P_1_4_5 VSS_0 0.00490986f
C1781 P_1_4_5 VSS_2 0.00260644f
C1782 P_1_4_5 WL_1_25 0.000553097f
C1783 P_1_4_5 XB_1_4_2 0.00158931f
C1784 P_1_4_5 net90 0.000249716f
C1785 P_1_5 VDD_1 0.00102182f
C1786 P_1_5 VSS_0 0.00483284f
C1787 P_1_5 VSS_2 0.00297442f
C1788 P_1_5 WL_1_27 0.0006346f
C1789 P_1_5 XB_1_5 0.0018235f
C1790 P_1_5 net141 0.00864253f
C1791 P_1_5 net141_3 0.00813905f
C1792 P_1_5 net141_4 0.00819881f
C1793 P_1_5 net141_6 0.00327445f
C1794 P_1_5 net141_9 0.00506653f
C1795 P_1_5 net93 0.000286513f
C1796 P_1_5_1 VDD_1 0.00218889f
C1797 P_1_5_1 VSS_0 0.0103527f
C1798 P_1_5_1 VSS_2 0.00637168f
C1799 P_1_5_1 WL_1_27 0.00135941f
C1800 P_1_5_1 XB_1_5 0.00390623f
C1801 P_1_5_1 net141_2 0.00749792f
C1802 P_1_5_1 net93 0.000613757f
C1803 P_1_5_2 VDD_1 0.00398207f
C1804 P_1_5_2 VSS_0 0.0188339f
C1805 P_1_5_2 VSS_2 0.0115915f
C1806 P_1_5_2 WL_1_27 0.00247307f
C1807 P_1_5_2 XB_1_5 0.0071063f
C1808 P_1_5_2 net141_10 0.00787282f
C1809 P_1_5_2 net141_5 0.00327445f
C1810 P_1_5_2 net93 0.00111656f
C1811 P_1_5_3 VDD_1 0.00175888f
C1812 P_1_5_3 VSS_0 0.00870871f
C1813 P_1_5_3 VSS_2 0.00509151f
C1814 P_1_5_3 WL_1_27 0.00108629f
C1815 P_1_5_3 XB_1_5_3 0.00312141f
C1816 P_1_5_3 net141_8 0.00327445f
C1817 P_1_5_3 net93 0.000490444f
C1818 P_1_5_4 VDD_1 0.000441785f
C1819 P_1_5_4 VSS_0 0.00208949f
C1820 P_1_5_4 VSS_2 0.001286f
C1821 P_1_5_4 WL_1_27 0.000274371f
C1822 P_1_5_4 XB_1_5 0.000788397f
C1823 P_1_5_4 net141_7 0.00163723f
C1824 P_1_5_4 net93 0.000123875f
C1825 P_1_5_5 VDD_1 0.000901256f
C1826 P_1_5_5 VSS_0 0.00490986f
C1827 P_1_5_5 VSS_2 0.00260644f
C1828 P_1_5_5 WL_1_27 0.000553097f
C1829 P_1_5_5 XB_1_5_2 0.00158931f
C1830 P_1_5_5 net93 0.000249716f
C1831 P_1_6 VDD_1 0.00102182f
C1832 P_1_6 VSS_0 0.00483284f
C1833 P_1_6 VSS_2 0.00297442f
C1834 P_1_6 WL_1_29 0.0006346f
C1835 P_1_6 XB_1_6 0.0018235f
C1836 P_1_6 net142 0.00864253f
C1837 P_1_6 net142_3 0.00813905f
C1838 P_1_6 net142_4 0.00819881f
C1839 P_1_6 net142_6 0.00327445f
C1840 P_1_6 net142_9 0.00506653f
C1841 P_1_6 net96 0.000286513f
C1842 P_1_6_1 VDD_1 0.00218889f
C1843 P_1_6_1 VSS_0 0.0103527f
C1844 P_1_6_1 VSS_2 0.00637168f
C1845 P_1_6_1 WL_1_29 0.00135941f
C1846 P_1_6_1 XB_1_6 0.00390623f
C1847 P_1_6_1 net142_2 0.00749792f
C1848 P_1_6_1 net96 0.000613757f
C1849 P_1_6_2 VDD_1 0.00398207f
C1850 P_1_6_2 VSS_0 0.0188339f
C1851 P_1_6_2 VSS_2 0.0115915f
C1852 P_1_6_2 WL_1_29 0.00247307f
C1853 P_1_6_2 XB_1_6 0.0071063f
C1854 P_1_6_2 net142_10 0.00787282f
C1855 P_1_6_2 net142_5 0.00327445f
C1856 P_1_6_2 net96 0.00111656f
C1857 P_1_6_3 VDD_1 0.00175845f
C1858 P_1_6_3 VSS_0 0.00872558f
C1859 P_1_6_3 VSS_2 0.00509151f
C1860 P_1_6_3 WL_1_29 0.00108629f
C1861 P_1_6_3 XB_1_6_3 0.00312141f
C1862 P_1_6_3 net142_8 0.00327445f
C1863 P_1_6_3 net96 0.000490444f
C1864 P_1_6_4 VDD_1 0.000441785f
C1865 P_1_6_4 VSS_0 0.00208949f
C1866 P_1_6_4 VSS_2 0.001286f
C1867 P_1_6_4 WL_1_29 0.000274371f
C1868 P_1_6_4 XB_1_6 0.000788397f
C1869 P_1_6_4 net142_7 0.00163723f
C1870 P_1_6_4 net96 0.000123875f
C1871 P_1_6_5 VDD_1 0.000890582f
C1872 P_1_6_5 VSS_0 0.00493089f
C1873 P_1_6_5 VSS_2 0.00261578f
C1874 P_1_6_5 WL_1_29 0.000553097f
C1875 P_1_6_5 XB_1_6_2 0.00158931f
C1876 P_1_6_5 net96 0.000249716f
C1877 P_1_7 VDD_1 0.00102167f
C1878 P_1_7 VSS_0 0.00477338f
C1879 P_1_7 VSS_2 0.00295734f
C1880 P_1_7 WL_1_31 0.000630419f
C1881 P_1_7 XB_1_7 0.00186436f
C1882 P_1_7 net144 0.00866343f
C1883 P_1_7 net144_3 0.00815873f
C1884 P_1_7 net144_4 0.00821864f
C1885 P_1_7 net144_6 0.00328237f
C1886 P_1_7 net144_9 0.00507878f
C1887 P_1_7 net99 0.000289823f
C1888 P_1_7_1 VDD_1 0.00218858f
C1889 P_1_7_1 VSS_0 0.0102253f
C1890 P_1_7_1 VSS_2 0.00633509f
C1891 P_1_7_1 WL_1_31 0.00135046f
C1892 P_1_7_1 XB_1_7 0.00399376f
C1893 P_1_7_1 net144_2 0.00751605f
C1894 P_1_7_1 net99 0.000620847f
C1895 P_1_7_2 VDD_1 0.00398151f
C1896 P_1_7_2 VSS_0 0.0186021f
C1897 P_1_7_2 VSS_2 0.0115249f
C1898 P_1_7_2 WL_1_31 0.00245678f
C1899 P_1_7_2 XB_1_7 0.00726554f
C1900 P_1_7_2 net144_10 0.00789186f
C1901 P_1_7_2 net144_5 0.00328237f
C1902 P_1_7_2 net99 0.00112946f
C1903 P_1_7_3 VDD_1 0.00175753f
C1904 P_1_7_3 VSS_0 0.00854535f
C1905 P_1_7_3 VSS_2 0.00506228f
C1906 P_1_7_3 WL_1_31 0.00107913f
C1907 P_1_7_3 XB_1_7_3 0.00319135f
C1908 P_1_7_3 net144_8 0.00328237f
C1909 P_1_7_3 net99 0.000496109f
C1910 P_1_7_4 VDD_1 0.000441723f
C1911 P_1_7_4 VSS_0 0.00206379f
C1912 P_1_7_4 VSS_2 0.00127862f
C1913 P_1_7_4 WL_1_31 0.000272563f
C1914 P_1_7_4 XB_1_7 0.000806063f
C1915 P_1_7_4 net144_7 0.00164119f
C1916 P_1_7_4 net99 0.000125306f
C1917 P_1_7_5 VDD_1 0.000890457f
C1918 P_1_7_5 VSS_0 0.00416033f
C1919 P_1_7_5 VSS_2 0.00257753f
C1920 P_1_7_5 WL_1_31 0.000549453f
C1921 P_1_7_5 XB_1_7_2 0.00162492f
C1922 P_1_7_5 net99 0.000252601f
C1923 VDD_1 VSS_0 0.530361f
C1924 VDD_1 WL_0 0.000954577f
C1925 VDD_1 WL_0_1 0.00816551f
C1926 VDD_1 WL_0_10 0.00390071f
C1927 VDD_1 WL_0_11 0.00367864f
C1928 VDD_1 WL_0_12 0.00390071f
C1929 VDD_1 WL_0_13 0.00390071f
C1930 VDD_1 WL_0_14 0.00390071f
C1931 VDD_1 WL_0_15 0.00579597f
C1932 VDD_1 WL_0_16 0.00189942f
C1933 VDD_1 WL_0_17 0.00189942f
C1934 VDD_1 WL_0_18 0.0017933f
C1935 VDD_1 WL_0_19 0.0017933f
C1936 VDD_1 WL_0_2 0.00809674f
C1937 VDD_1 WL_0_20 0.00186033f
C1938 VDD_1 WL_0_21 0.00186033f
C1939 VDD_1 WL_0_22 0.0017933f
C1940 VDD_1 WL_0_23 0.0017933f
C1941 VDD_1 WL_0_24 0.0017933f
C1942 VDD_1 WL_0_25 0.0017933f
C1943 VDD_1 WL_0_26 0.0017933f
C1944 VDD_1 WL_0_27 0.0017933f
C1945 VDD_1 WL_0_28 0.00122128f
C1946 VDD_1 WL_0_29 0.00122128f
C1947 VDD_1 WL_0_3 0.00818477f
C1948 VDD_1 WL_0_30 0.00290509f
C1949 VDD_1 WL_0_31 0.00290509f
C1950 VDD_1 WL_0_4 0.00809674f
C1951 VDD_1 WL_0_5 0.00809674f
C1952 VDD_1 WL_0_6 0.00809674f
C1953 VDD_1 WL_0_7 0.00734553f
C1954 VDD_1 WL_0_8 0.00945568f
C1955 VDD_1 WL_0_9 0.00262916f
C1956 VDD_1 WL_1 0.00151697f
C1957 VDD_1 WL_1_1 0.00364085f
C1958 VDD_1 WL_1_10 0.00613683f
C1959 VDD_1 WL_1_11 0.00578746f
C1960 VDD_1 WL_1_12 0.00613683f
C1961 VDD_1 WL_1_13 0.00613683f
C1962 VDD_1 WL_1_14 0.00613683f
C1963 VDD_1 WL_1_15 0.00911856f
C1964 VDD_1 WL_1_16 0.00301846f
C1965 VDD_1 WL_1_17 0.00301846f
C1966 VDD_1 WL_1_18 0.00282133f
C1967 VDD_1 WL_1_19 0.00282133f
C1968 VDD_1 WL_1_2 0.00370517f
C1969 VDD_1 WL_1_20 0.00292677f
C1970 VDD_1 WL_1_21 0.00292677f
C1971 VDD_1 WL_1_22 0.00282133f
C1972 VDD_1 WL_1_23 0.00282133f
C1973 VDD_1 WL_1_24 0.00282133f
C1974 VDD_1 WL_1_25 0.00282133f
C1975 VDD_1 WL_1_26 0.00282133f
C1976 VDD_1 WL_1_27 0.00282133f
C1977 VDD_1 WL_1_28 0.00192139f
C1978 VDD_1 WL_1_29 0.00192139f
C1979 VDD_1 WL_1_3 0.00384366f
C1980 VDD_1 WL_1_30 0.00464187f
C1981 VDD_1 WL_1_31 0.00464187f
C1982 VDD_1 WL_1_4 0.00370517f
C1983 VDD_1 WL_1_5 0.00370517f
C1984 VDD_1 WL_1_6 0.00370517f
C1985 VDD_1 WL_1_7 0.00252332f
C1986 VDD_1 WL_1_8 0.00616862f
C1987 VDD_1 WL_1_9 0.00417813f
C1988 VDD_1 XB_0_0 0.0035184f
C1989 VDD_1 XB_0_0_1 0.0147317f
C1990 VDD_1 XB_0_0_2 0.00207885f
C1991 VDD_1 XB_0_0_3 0.00491767f
C1992 VDD_1 XB_0_1 0.00350022f
C1993 VDD_1 XB_0_1_1 0.0146557f
C1994 VDD_1 XB_0_1_2 0.0020681f
C1995 VDD_1 XB_0_1_3 0.00486801f
C1996 VDD_1 XB_0_2 0.00350022f
C1997 VDD_1 XB_0_2_1 0.0146557f
C1998 VDD_1 XB_0_2_2 0.0020681f
C1999 VDD_1 XB_0_2_3 0.00486801f
C2000 VDD_1 XB_0_3 0.00350022f
C2001 VDD_1 XB_0_3_1 0.0146557f
C2002 VDD_1 XB_0_3_2 0.0020681f
C2003 VDD_1 XB_0_3_3 0.00486801f
C2004 VDD_1 XB_0_4 0.00350022f
C2005 VDD_1 XB_0_4_1 0.0146557f
C2006 VDD_1 XB_0_4_2 0.0020681f
C2007 VDD_1 XB_0_4_3 0.00486801f
C2008 VDD_1 XB_0_5 0.00350022f
C2009 VDD_1 XB_0_5_1 0.0146557f
C2010 VDD_1 XB_0_5_2 0.0020681f
C2011 VDD_1 XB_0_5_3 0.00486801f
C2012 VDD_1 XB_0_6 0.00350022f
C2013 VDD_1 XB_0_6_1 0.0146501f
C2014 VDD_1 XB_0_6_2 0.0020681f
C2015 VDD_1 XB_0_6_3 0.00489803f
C2016 VDD_1 XB_0_7 0.0035359f
C2017 VDD_1 XB_0_7_1 0.0147814f
C2018 VDD_1 XB_0_7_2 0.00208919f
C2019 VDD_1 XB_0_7_3 0.00505101f
C2020 VDD_1 XB_1_0 0.00361007f
C2021 VDD_1 XB_1_0_1 0.0150915f
C2022 VDD_1 XB_1_0_2 0.00213301f
C2023 VDD_1 XB_1_0_3 0.00426602f
C2024 VDD_1 XB_1_1 0.00360243f
C2025 VDD_1 XB_1_1_1 0.0150596f
C2026 VDD_1 XB_1_1_2 0.0021285f
C2027 VDD_1 XB_1_1_3 0.00429563f
C2028 VDD_1 XB_1_2 0.00360243f
C2029 VDD_1 XB_1_2_1 0.0150596f
C2030 VDD_1 XB_1_2_2 0.0021285f
C2031 VDD_1 XB_1_2_3 0.00429563f
C2032 VDD_1 XB_1_3 0.00360243f
C2033 VDD_1 XB_1_3_1 0.0150596f
C2034 VDD_1 XB_1_3_2 0.0021285f
C2035 VDD_1 XB_1_3_3 0.00429563f
C2036 VDD_1 XB_1_4 0.00360243f
C2037 VDD_1 XB_1_4_1 0.0150596f
C2038 VDD_1 XB_1_4_2 0.0021285f
C2039 VDD_1 XB_1_4_3 0.00429563f
C2040 VDD_1 XB_1_5 0.00360243f
C2041 VDD_1 XB_1_5_1 0.0150596f
C2042 VDD_1 XB_1_5_2 0.0021285f
C2043 VDD_1 XB_1_5_3 0.00429563f
C2044 VDD_1 XB_1_6 0.00360243f
C2045 VDD_1 XB_1_6_1 0.0150837f
C2046 VDD_1 XB_1_6_2 0.0021285f
C2047 VDD_1 XB_1_6_3 0.00429563f
C2048 VDD_1 XB_1_7 0.00365462f
C2049 VDD_1 XB_1_7_1 0.0152777f
C2050 VDD_1 XB_1_7_2 0.00215933f
C2051 VDD_1 XB_1_7_3 0.00434291f
C2052 VDD_1 net10 0.0018757f
C2053 VDD_1 net10_2 0.00244327f
C2054 VDD_1 net10_3 0.00782837f
C2055 VDD_1 net10_4 0.00422254f
C2056 VDD_1 net10_6 0.00176961f
C2057 VDD_1 net10_7 0.00632439f
C2058 VDD_1 net11 0.00337444f
C2059 VDD_1 net11_11 0.00958281f
C2060 VDD_1 net11_2 0.00285547f
C2061 VDD_1 net11_3 0.00309964f
C2062 VDD_1 net11_4 0.0031224f
C2063 VDD_1 net11_5 0.00124703f
C2064 VDD_1 net11_6 0.0013125f
C2065 VDD_1 net11_7 0.000623514f
C2066 VDD_1 net11_8 0.00124703f
C2067 VDD_1 net11_9 0.00299825f
C2068 VDD_1 net13 0.0018757f
C2069 VDD_1 net133 0.00448933f
C2070 VDD_1 net133_10 0.0040895f
C2071 VDD_1 net133_2 0.00389477f
C2072 VDD_1 net133_3 0.0042278f
C2073 VDD_1 net133_4 0.00425884f
C2074 VDD_1 net133_5 0.0017009f
C2075 VDD_1 net133_6 0.0017009f
C2076 VDD_1 net133_7 0.000850451f
C2077 VDD_1 net133_8 0.0017009f
C2078 VDD_1 net133_9 0.00263179f
C2079 VDD_1 net134 0.00469787f
C2080 VDD_1 net134_10 0.00408779f
C2081 VDD_1 net134_2 0.00389314f
C2082 VDD_1 net134_3 0.00422603f
C2083 VDD_1 net134_4 0.00425706f
C2084 VDD_1 net134_5 0.00170019f
C2085 VDD_1 net134_6 0.00170019f
C2086 VDD_1 net134_7 0.000850096f
C2087 VDD_1 net134_8 0.00170019f
C2088 VDD_1 net134_9 0.00263069f
C2089 VDD_1 net136 0.00465738f
C2090 VDD_1 net136_10 0.00408779f
C2091 VDD_1 net136_2 0.00389314f
C2092 VDD_1 net136_3 0.00422603f
C2093 VDD_1 net136_4 0.00425706f
C2094 VDD_1 net136_5 0.00170019f
C2095 VDD_1 net136_6 0.00170019f
C2096 VDD_1 net136_7 0.000850096f
C2097 VDD_1 net136_8 0.00170019f
C2098 VDD_1 net136_9 0.00263069f
C2099 VDD_1 net137 0.00465738f
C2100 VDD_1 net137_10 0.00408779f
C2101 VDD_1 net137_2 0.00389314f
C2102 VDD_1 net137_3 0.00422603f
C2103 VDD_1 net137_4 0.00425706f
C2104 VDD_1 net137_5 0.00170019f
C2105 VDD_1 net137_6 0.00170019f
C2106 VDD_1 net137_7 0.000850096f
C2107 VDD_1 net137_8 0.00170019f
C2108 VDD_1 net137_9 0.00263069f
C2109 VDD_1 net139 0.00465738f
C2110 VDD_1 net139_10 0.00408779f
C2111 VDD_1 net139_2 0.00389314f
C2112 VDD_1 net139_3 0.00422603f
C2113 VDD_1 net139_4 0.00425706f
C2114 VDD_1 net139_5 0.00170019f
C2115 VDD_1 net139_6 0.00170019f
C2116 VDD_1 net139_7 0.000850096f
C2117 VDD_1 net139_8 0.00170019f
C2118 VDD_1 net139_9 0.00263069f
C2119 VDD_1 net13_2 0.00244327f
C2120 VDD_1 net13_3 0.00782837f
C2121 VDD_1 net13_4 0.00422254f
C2122 VDD_1 net13_6 0.00176961f
C2123 VDD_1 net13_7 0.00632439f
C2124 VDD_1 net14 0.00337444f
C2125 VDD_1 net141 0.00465738f
C2126 VDD_1 net141_10 0.00408779f
C2127 VDD_1 net141_2 0.00389314f
C2128 VDD_1 net141_3 0.00422603f
C2129 VDD_1 net141_4 0.00425706f
C2130 VDD_1 net141_5 0.00170019f
C2131 VDD_1 net141_6 0.00170019f
C2132 VDD_1 net141_7 0.000850096f
C2133 VDD_1 net141_8 0.00170019f
C2134 VDD_1 net141_9 0.00263069f
C2135 VDD_1 net142 0.00465738f
C2136 VDD_1 net142_10 0.00408779f
C2137 VDD_1 net142_2 0.00389314f
C2138 VDD_1 net142_3 0.00422603f
C2139 VDD_1 net142_4 0.00425706f
C2140 VDD_1 net142_5 0.00170019f
C2141 VDD_1 net142_6 0.00170019f
C2142 VDD_1 net142_7 0.000850096f
C2143 VDD_1 net142_8 0.00170019f
C2144 VDD_1 net142_9 0.00263069f
C2145 VDD_1 net144 0.00464802f
C2146 VDD_1 net144_10 0.00407926f
C2147 VDD_1 net144_2 0.00388501f
C2148 VDD_1 net144_3 0.00421721f
C2149 VDD_1 net144_4 0.00424817f
C2150 VDD_1 net144_5 0.00169664f
C2151 VDD_1 net144_6 0.00169664f
C2152 VDD_1 net144_7 0.000848321f
C2153 VDD_1 net144_8 0.00169664f
C2154 VDD_1 net144_9 0.0026252f
C2155 VDD_1 net14_11 0.00958281f
C2156 VDD_1 net14_2 0.00285547f
C2157 VDD_1 net14_3 0.00309964f
C2158 VDD_1 net14_4 0.0031224f
C2159 VDD_1 net14_5 0.00124703f
C2160 VDD_1 net14_6 0.0013125f
C2161 VDD_1 net14_7 0.000623514f
C2162 VDD_1 net14_8 0.00124703f
C2163 VDD_1 net14_9 0.00299825f
C2164 VDD_1 net16 0.0018757f
C2165 VDD_1 net16_2 0.00244327f
C2166 VDD_1 net16_3 0.00782837f
C2167 VDD_1 net16_4 0.00422254f
C2168 VDD_1 net16_6 0.00176961f
C2169 VDD_1 net16_7 0.00632439f
C2170 VDD_1 net17 0.00337444f
C2171 VDD_1 net17_11 0.00958281f
C2172 VDD_1 net17_2 0.00285547f
C2173 VDD_1 net17_3 0.00309964f
C2174 VDD_1 net17_4 0.0031224f
C2175 VDD_1 net17_5 0.00124703f
C2176 VDD_1 net17_6 0.0013125f
C2177 VDD_1 net17_7 0.000623514f
C2178 VDD_1 net17_8 0.00124703f
C2179 VDD_1 net17_9 0.00299825f
C2180 VDD_1 net20 0.0018757f
C2181 VDD_1 net20_2 0.00244327f
C2182 VDD_1 net20_3 0.00782837f
C2183 VDD_1 net20_4 0.00422254f
C2184 VDD_1 net20_6 0.00176961f
C2185 VDD_1 net20_7 0.00632439f
C2186 VDD_1 net21 0.00337444f
C2187 VDD_1 net21_11 0.00958281f
C2188 VDD_1 net21_2 0.00285547f
C2189 VDD_1 net21_3 0.00309964f
C2190 VDD_1 net21_4 0.0031224f
C2191 VDD_1 net21_5 0.00124703f
C2192 VDD_1 net21_6 0.0013125f
C2193 VDD_1 net21_7 0.000623514f
C2194 VDD_1 net21_8 0.00124703f
C2195 VDD_1 net21_9 0.00299825f
C2196 VDD_1 net23 0.0018757f
C2197 VDD_1 net23_2 0.00244327f
C2198 VDD_1 net23_3 0.00782837f
C2199 VDD_1 net23_4 0.00422254f
C2200 VDD_1 net23_6 0.00176961f
C2201 VDD_1 net23_7 0.00632439f
C2202 VDD_1 net24 0.00337444f
C2203 VDD_1 net24_11 0.00958281f
C2204 VDD_1 net24_2 0.00285547f
C2205 VDD_1 net24_3 0.00309964f
C2206 VDD_1 net24_4 0.0031224f
C2207 VDD_1 net24_5 0.00124703f
C2208 VDD_1 net24_6 0.0013125f
C2209 VDD_1 net24_7 0.000623514f
C2210 VDD_1 net24_8 0.00124703f
C2211 VDD_1 net24_9 0.00299825f
C2212 VDD_1 net27 0.00188895f
C2213 VDD_1 net27_2 0.00246054f
C2214 VDD_1 net27_3 0.00785204f
C2215 VDD_1 net27_4 0.00425194f
C2216 VDD_1 net27_6 0.00178212f
C2217 VDD_1 net27_7 0.00636909f
C2218 VDD_1 net28 0.00334999f
C2219 VDD_1 net28_11 0.00949348f
C2220 VDD_1 net28_2 0.00283426f
C2221 VDD_1 net28_3 0.00307661f
C2222 VDD_1 net28_4 0.0030992f
C2223 VDD_1 net28_5 0.00123776f
C2224 VDD_1 net28_6 0.00130323f
C2225 VDD_1 net28_7 0.000618881f
C2226 VDD_1 net28_8 0.00123776f
C2227 VDD_1 net28_9 0.00297597f
C2228 VDD_1 net3 0.00188755f
C2229 VDD_1 net3_2 0.00245871f
C2230 VDD_1 net3_3 0.00791036f
C2231 VDD_1 net3_4 0.00418579f
C2232 VDD_1 net3_6 0.0017808f
C2233 VDD_1 net3_7 0.00636435f
C2234 VDD_1 net4 0.00329112f
C2235 VDD_1 net4_11 0.00970111f
C2236 VDD_1 net4_2 0.00285525f
C2237 VDD_1 net4_3 0.00309939f
C2238 VDD_1 net4_4 0.00312215f
C2239 VDD_1 net4_5 0.00124693f
C2240 VDD_1 net4_6 0.00124693f
C2241 VDD_1 net4_7 0.000623465f
C2242 VDD_1 net4_8 0.00124693f
C2243 VDD_1 net4_9 0.00299801f
C2244 VDD_1 net6 0.0018757f
C2245 VDD_1 net67 0.00838487f
C2246 VDD_1 net68 0.00828958f
C2247 VDD_1 net69 0.00828958f
C2248 VDD_1 net6_2 0.00244327f
C2249 VDD_1 net6_3 0.00782837f
C2250 VDD_1 net6_4 0.00423368f
C2251 VDD_1 net6_6 0.00176961f
C2252 VDD_1 net6_7 0.00632439f
C2253 VDD_1 net7 0.00338761f
C2254 VDD_1 net70 0.00828958f
C2255 VDD_1 net71 0.00828958f
C2256 VDD_1 net72 0.00828958f
C2257 VDD_1 net73 0.00830184f
C2258 VDD_1 net74 0.00835579f
C2259 VDD_1 net76 0.00241377f
C2260 VDD_1 net76_2 0.00314416f
C2261 VDD_1 net76_3 0.00315566f
C2262 VDD_1 net76_4 0.00227725f
C2263 VDD_1 net76_5 0.00535272f
C2264 VDD_1 net76_7 0.00813864f
C2265 VDD_1 net78 0.00915203f
C2266 VDD_1 net79 0.00241735f
C2267 VDD_1 net79_2 0.00314882f
C2268 VDD_1 net79_3 0.00315951f
C2269 VDD_1 net79_4 0.00228063f
C2270 VDD_1 net79_5 0.00536066f
C2271 VDD_1 net79_7 0.00819906f
C2272 VDD_1 net7_11 0.00958281f
C2273 VDD_1 net7_2 0.00285547f
C2274 VDD_1 net7_3 0.00309964f
C2275 VDD_1 net7_4 0.0031224f
C2276 VDD_1 net7_5 0.00124703f
C2277 VDD_1 net7_6 0.00131292f
C2278 VDD_1 net7_7 0.000623514f
C2279 VDD_1 net7_8 0.00124703f
C2280 VDD_1 net7_9 0.00299825f
C2281 VDD_1 net81 0.00919509f
C2282 VDD_1 net82 0.00241735f
C2283 VDD_1 net82_2 0.00314882f
C2284 VDD_1 net82_3 0.00315951f
C2285 VDD_1 net82_4 0.00228063f
C2286 VDD_1 net82_5 0.00536066f
C2287 VDD_1 net82_7 0.00822706f
C2288 VDD_1 net84 0.00919509f
C2289 VDD_1 net85 0.00241735f
C2290 VDD_1 net85_2 0.00314882f
C2291 VDD_1 net85_3 0.00315951f
C2292 VDD_1 net85_4 0.00228063f
C2293 VDD_1 net85_5 0.00536066f
C2294 VDD_1 net85_7 0.00822706f
C2295 VDD_1 net87 0.00919509f
C2296 VDD_1 net88 0.00241735f
C2297 VDD_1 net88_2 0.00314882f
C2298 VDD_1 net88_3 0.00315951f
C2299 VDD_1 net88_4 0.00228063f
C2300 VDD_1 net88_5 0.00536066f
C2301 VDD_1 net88_7 0.00822706f
C2302 VDD_1 net90 0.00919509f
C2303 VDD_1 net91 0.00241735f
C2304 VDD_1 net91_2 0.00314882f
C2305 VDD_1 net91_3 0.00315951f
C2306 VDD_1 net91_4 0.00228063f
C2307 VDD_1 net91_5 0.00536066f
C2308 VDD_1 net91_7 0.00822706f
C2309 VDD_1 net93 0.00919509f
C2310 VDD_1 net94 0.00241735f
C2311 VDD_1 net94_2 0.00314882f
C2312 VDD_1 net94_3 0.00315951f
C2313 VDD_1 net94_4 0.00228063f
C2314 VDD_1 net94_5 0.00536066f
C2315 VDD_1 net94_7 0.00822706f
C2316 VDD_1 net96 0.00920687f
C2317 VDD_1 net97 0.00241805f
C2318 VDD_1 net97_2 0.00314974f
C2319 VDD_1 net97_3 0.00315299f
C2320 VDD_1 net97_4 0.0022813f
C2321 VDD_1 net97_5 0.00536223f
C2322 VDD_1 net97_7 0.00822943f
C2323 VDD_1 net99 0.0091564f
C2324 VSS_0 VSS_2 0.325183f
C2325 VSS_0 WL_0 0.00920446f
C2326 VSS_0 WL_0_1 0.023065f
C2327 VSS_0 WL_0_10 0.0363247f
C2328 VSS_0 WL_0_11 0.0342566f
C2329 VSS_0 WL_0_12 0.0363247f
C2330 VSS_0 WL_0_13 0.0363247f
C2331 VSS_0 WL_0_14 0.0363247f
C2332 VSS_0 WL_0_15 0.0539738f
C2333 VSS_0 WL_0_16 0.018315f
C2334 VSS_0 WL_0_17 0.018315f
C2335 VSS_0 WL_0_18 0.0166998f
C2336 VSS_0 WL_0_19 0.0166998f
C2337 VSS_0 WL_0_2 0.0228896f
C2338 VSS_0 WL_0_20 0.0173239f
C2339 VSS_0 WL_0_21 0.0173239f
C2340 VSS_0 WL_0_22 0.0166998f
C2341 VSS_0 WL_0_23 0.0166998f
C2342 VSS_0 WL_0_24 0.0166998f
C2343 VSS_0 WL_0_25 0.0166998f
C2344 VSS_0 WL_0_26 0.0166998f
C2345 VSS_0 WL_0_27 0.0166998f
C2346 VSS_0 WL_0_28 0.011373f
C2347 VSS_0 WL_0_29 0.011373f
C2348 VSS_0 WL_0_3 0.0237093f
C2349 VSS_0 WL_0_30 0.0279229f
C2350 VSS_0 WL_0_31 0.0279229f
C2351 VSS_0 WL_0_4 0.0228896f
C2352 VSS_0 WL_0_5 0.0228896f
C2353 VSS_0 WL_0_6 0.0228896f
C2354 VSS_0 WL_0_7 0.015894f
C2355 VSS_0 WL_0_8 0.0377219f
C2356 VSS_0 WL_0_9 0.0253515f
C2357 VSS_0 WL_1 0.00890559f
C2358 VSS_0 WL_1_1 0.0224195f
C2359 VSS_0 WL_1_10 0.0351766f
C2360 VSS_0 WL_1_11 0.0331656f
C2361 VSS_0 WL_1_12 0.0351678f
C2362 VSS_0 WL_1_13 0.0351678f
C2363 VSS_0 WL_1_14 0.0351678f
C2364 VSS_0 WL_1_15 0.0522393f
C2365 VSS_0 WL_1_16 0.0177203f
C2366 VSS_0 WL_1_17 0.0177203f
C2367 VSS_0 WL_1_18 0.016172f
C2368 VSS_0 WL_1_19 0.016172f
C2369 VSS_0 WL_1_2 0.0222145f
C2370 VSS_0 WL_1_20 0.0167722f
C2371 VSS_0 WL_1_21 0.0167722f
C2372 VSS_0 WL_1_22 0.0161679f
C2373 VSS_0 WL_1_23 0.0161679f
C2374 VSS_0 WL_1_24 0.0161679f
C2375 VSS_0 WL_1_25 0.0161679f
C2376 VSS_0 WL_1_26 0.0161679f
C2377 VSS_0 WL_1_27 0.0161679f
C2378 VSS_0 WL_1_28 0.0110075f
C2379 VSS_0 WL_1_29 0.0110075f
C2380 VSS_0 WL_1_3 0.0230027f
C2381 VSS_0 WL_1_30 0.0269548f
C2382 VSS_0 WL_1_31 0.0269548f
C2383 VSS_0 WL_1_4 0.0222092f
C2384 VSS_0 WL_1_5 0.0222092f
C2385 VSS_0 WL_1_6 0.0222092f
C2386 VSS_0 WL_1_7 0.0154321f
C2387 VSS_0 WL_1_8 0.0364526f
C2388 VSS_0 WL_1_9 0.0245284f
C2389 VSS_0 XB_0_0 0.00893683f
C2390 VSS_0 XB_0_0_1 0.0382367f
C2391 VSS_0 XB_0_0_2 0.00528032f
C2392 VSS_0 XB_0_0_3 0.0114904f
C2393 VSS_0 XB_0_1 0.00898042f
C2394 VSS_0 XB_0_1_1 0.038419f
C2395 VSS_0 XB_0_1_2 0.00530608f
C2396 VSS_0 XB_0_1_3 0.0115361f
C2397 VSS_0 XB_0_2 0.00898042f
C2398 VSS_0 XB_0_2_1 0.038419f
C2399 VSS_0 XB_0_2_2 0.00530608f
C2400 VSS_0 XB_0_2_3 0.0115361f
C2401 VSS_0 XB_0_3 0.00898042f
C2402 VSS_0 XB_0_3_1 0.038419f
C2403 VSS_0 XB_0_3_2 0.00530608f
C2404 VSS_0 XB_0_3_3 0.0115361f
C2405 VSS_0 XB_0_4 0.00898042f
C2406 VSS_0 XB_0_4_1 0.038419f
C2407 VSS_0 XB_0_4_2 0.00530608f
C2408 VSS_0 XB_0_4_3 0.0115361f
C2409 VSS_0 XB_0_5 0.00898042f
C2410 VSS_0 XB_0_5_1 0.038419f
C2411 VSS_0 XB_0_5_2 0.00530608f
C2412 VSS_0 XB_0_5_3 0.0115361f
C2413 VSS_0 XB_0_6 0.00897993f
C2414 VSS_0 XB_0_6_1 0.0383655f
C2415 VSS_0 XB_0_6_2 0.00530579f
C2416 VSS_0 XB_0_6_3 0.0115687f
C2417 VSS_0 XB_0_7 0.00956293f
C2418 VSS_0 XB_0_7_1 0.0399768f
C2419 VSS_0 XB_0_7_2 0.00565025f
C2420 VSS_0 XB_0_7_3 0.0121841f
C2421 VSS_0 XB_1_0 0.00678096f
C2422 VSS_0 XB_1_0_1 0.029035f
C2423 VSS_0 XB_1_0_2 0.00400653f
C2424 VSS_0 XB_1_0_3 0.00882428f
C2425 VSS_0 XB_1_1 0.00678509f
C2426 VSS_0 XB_1_1_1 0.0290522f
C2427 VSS_0 XB_1_1_2 0.00400897f
C2428 VSS_0 XB_1_1_3 0.00882799f
C2429 VSS_0 XB_1_2 0.00678509f
C2430 VSS_0 XB_1_2_1 0.0290522f
C2431 VSS_0 XB_1_2_2 0.00400897f
C2432 VSS_0 XB_1_2_3 0.00882799f
C2433 VSS_0 XB_1_3 0.00678509f
C2434 VSS_0 XB_1_3_1 0.0290522f
C2435 VSS_0 XB_1_3_2 0.00400897f
C2436 VSS_0 XB_1_3_3 0.00882799f
C2437 VSS_0 XB_1_4 0.00678509f
C2438 VSS_0 XB_1_4_1 0.0290522f
C2439 VSS_0 XB_1_4_2 0.00400897f
C2440 VSS_0 XB_1_4_3 0.00882799f
C2441 VSS_0 XB_1_5 0.00678509f
C2442 VSS_0 XB_1_5_1 0.0290522f
C2443 VSS_0 XB_1_5_2 0.00400897f
C2444 VSS_0 XB_1_5_3 0.00882799f
C2445 VSS_0 XB_1_6 0.00678545f
C2446 VSS_0 XB_1_6_1 0.0290332f
C2447 VSS_0 XB_1_6_2 0.00400918f
C2448 VSS_0 XB_1_6_3 0.00882802f
C2449 VSS_0 XB_1_7 0.00720093f
C2450 VSS_0 XB_1_7_1 0.0301027f
C2451 VSS_0 XB_1_7_2 0.00425466f
C2452 VSS_0 XB_1_7_3 0.00935362f
C2453 VSS_0 net10 0.00638212f
C2454 VSS_0 net10_2 0.0083133f
C2455 VSS_0 net10_3 0.00910812f
C2456 VSS_0 net10_4 0.0143891f
C2457 VSS_0 net10_6 0.00616555f
C2458 VSS_0 net10_7 0.0215189f
C2459 VSS_0 net11 0.0207457f
C2460 VSS_0 net11_11 0.0128669f
C2461 VSS_0 net11_2 0.0172293f
C2462 VSS_0 net11_3 0.01847f
C2463 VSS_0 net11_4 0.0186057f
C2464 VSS_0 net11_5 0.00743076f
C2465 VSS_0 net11_6 0.00768464f
C2466 VSS_0 net11_7 0.00371538f
C2467 VSS_0 net11_8 0.00755521f
C2468 VSS_0 net11_9 0.0178659f
C2469 VSS_0 net13 0.00638212f
C2470 VSS_0 net133 0.0121481f
C2471 VSS_0 net133_10 0.0110662f
C2472 VSS_0 net133_2 0.0107262f
C2473 VSS_0 net133_3 0.0114404f
C2474 VSS_0 net133_4 0.0115244f
C2475 VSS_0 net133_5 0.00460264f
C2476 VSS_0 net133_6 0.00460264f
C2477 VSS_0 net133_7 0.00230132f
C2478 VSS_0 net133_8 0.00469729f
C2479 VSS_0 net133_9 0.00863459f
C2480 VSS_0 net134 0.0129847f
C2481 VSS_0 net134_10 0.0107396f
C2482 VSS_0 net134_2 0.0104152f
C2483 VSS_0 net134_3 0.0111028f
C2484 VSS_0 net134_4 0.0111844f
C2485 VSS_0 net134_5 0.00446682f
C2486 VSS_0 net134_6 0.00477744f
C2487 VSS_0 net134_7 0.00223341f
C2488 VSS_0 net134_8 0.00456148f
C2489 VSS_0 net134_9 0.00842237f
C2490 VSS_0 net136 0.0128916f
C2491 VSS_0 net136_10 0.010761f
C2492 VSS_0 net136_2 0.0104355f
C2493 VSS_0 net136_3 0.0111249f
C2494 VSS_0 net136_4 0.0112066f
C2495 VSS_0 net136_5 0.00447571f
C2496 VSS_0 net136_6 0.00475498f
C2497 VSS_0 net136_7 0.00223785f
C2498 VSS_0 net136_8 0.00457036f
C2499 VSS_0 net136_9 0.00843611f
C2500 VSS_0 net137 0.0128916f
C2501 VSS_0 net137_10 0.010761f
C2502 VSS_0 net137_2 0.0104355f
C2503 VSS_0 net137_3 0.0111249f
C2504 VSS_0 net137_4 0.0112066f
C2505 VSS_0 net137_5 0.00447571f
C2506 VSS_0 net137_6 0.00475498f
C2507 VSS_0 net137_7 0.00223785f
C2508 VSS_0 net137_8 0.00457036f
C2509 VSS_0 net137_9 0.00843611f
C2510 VSS_0 net139 0.0128916f
C2511 VSS_0 net139_10 0.010761f
C2512 VSS_0 net139_2 0.0104355f
C2513 VSS_0 net139_3 0.0111249f
C2514 VSS_0 net139_4 0.0112066f
C2515 VSS_0 net139_5 0.00447571f
C2516 VSS_0 net139_6 0.00475498f
C2517 VSS_0 net139_7 0.00223785f
C2518 VSS_0 net139_8 0.00457036f
C2519 VSS_0 net139_9 0.00843611f
C2520 VSS_0 net13_2 0.0083133f
C2521 VSS_0 net13_3 0.00910812f
C2522 VSS_0 net13_4 0.0143891f
C2523 VSS_0 net13_6 0.00616555f
C2524 VSS_0 net13_7 0.0215189f
C2525 VSS_0 net14 0.0207457f
C2526 VSS_0 net141 0.0128916f
C2527 VSS_0 net141_10 0.010761f
C2528 VSS_0 net141_2 0.0104355f
C2529 VSS_0 net141_3 0.0111249f
C2530 VSS_0 net141_4 0.0112066f
C2531 VSS_0 net141_5 0.00447571f
C2532 VSS_0 net141_6 0.00475498f
C2533 VSS_0 net141_7 0.00223785f
C2534 VSS_0 net141_8 0.00457036f
C2535 VSS_0 net141_9 0.00843611f
C2536 VSS_0 net142 0.0128802f
C2537 VSS_0 net142_10 0.0107506f
C2538 VSS_0 net142_2 0.0104348f
C2539 VSS_0 net142_3 0.0111142f
C2540 VSS_0 net142_4 0.0111958f
C2541 VSS_0 net142_5 0.00447139f
C2542 VSS_0 net142_6 0.00475066f
C2543 VSS_0 net142_7 0.00223569f
C2544 VSS_0 net142_8 0.00456619f
C2545 VSS_0 net142_9 0.00842943f
C2546 VSS_0 net144 0.012837f
C2547 VSS_0 net144_10 0.0107113f
C2548 VSS_0 net144_2 0.0102013f
C2549 VSS_0 net144_3 0.0110735f
C2550 VSS_0 net144_4 0.0111549f
C2551 VSS_0 net144_5 0.00445504f
C2552 VSS_0 net144_6 0.00473432f
C2553 VSS_0 net144_7 0.00222752f
C2554 VSS_0 net144_8 0.00445504f
C2555 VSS_0 net144_9 0.00846827f
C2556 VSS_0 net14_11 0.0128669f
C2557 VSS_0 net14_2 0.0172293f
C2558 VSS_0 net14_3 0.01847f
C2559 VSS_0 net14_4 0.0186057f
C2560 VSS_0 net14_5 0.00743076f
C2561 VSS_0 net14_6 0.00768464f
C2562 VSS_0 net14_7 0.00371538f
C2563 VSS_0 net14_8 0.00755521f
C2564 VSS_0 net14_9 0.0178659f
C2565 VSS_0 net16 0.00638212f
C2566 VSS_0 net16_2 0.0083133f
C2567 VSS_0 net16_3 0.00910812f
C2568 VSS_0 net16_4 0.0143891f
C2569 VSS_0 net16_6 0.00616555f
C2570 VSS_0 net16_7 0.0215189f
C2571 VSS_0 net17 0.0207457f
C2572 VSS_0 net17_11 0.0128669f
C2573 VSS_0 net17_2 0.0172293f
C2574 VSS_0 net17_3 0.01847f
C2575 VSS_0 net17_4 0.0186057f
C2576 VSS_0 net17_5 0.00743076f
C2577 VSS_0 net17_6 0.00768464f
C2578 VSS_0 net17_7 0.00371538f
C2579 VSS_0 net17_8 0.00755521f
C2580 VSS_0 net17_9 0.0178659f
C2581 VSS_0 net20 0.00638212f
C2582 VSS_0 net20_2 0.0083133f
C2583 VSS_0 net20_3 0.00910812f
C2584 VSS_0 net20_4 0.0143891f
C2585 VSS_0 net20_6 0.00616555f
C2586 VSS_0 net20_7 0.0215189f
C2587 VSS_0 net21 0.0207457f
C2588 VSS_0 net21_11 0.0128669f
C2589 VSS_0 net21_2 0.0172293f
C2590 VSS_0 net21_3 0.01847f
C2591 VSS_0 net21_4 0.0186057f
C2592 VSS_0 net21_5 0.00743076f
C2593 VSS_0 net21_6 0.00768464f
C2594 VSS_0 net21_7 0.00371538f
C2595 VSS_0 net21_8 0.00755521f
C2596 VSS_0 net21_9 0.0178659f
C2597 VSS_0 net23 0.00638212f
C2598 VSS_0 net23_2 0.0083133f
C2599 VSS_0 net23_3 0.00910812f
C2600 VSS_0 net23_4 0.0143891f
C2601 VSS_0 net23_6 0.00616555f
C2602 VSS_0 net23_7 0.0215189f
C2603 VSS_0 net24 0.0207366f
C2604 VSS_0 net24_11 0.0128418f
C2605 VSS_0 net24_2 0.0171843f
C2606 VSS_0 net24_3 0.0184614f
C2607 VSS_0 net24_4 0.018597f
C2608 VSS_0 net24_5 0.0074273f
C2609 VSS_0 net24_6 0.00767276f
C2610 VSS_0 net24_7 0.00371365f
C2611 VSS_0 net24_8 0.00757594f
C2612 VSS_0 net24_9 0.0178576f
C2613 VSS_0 net27 0.00640241f
C2614 VSS_0 net27_2 0.00833974f
C2615 VSS_0 net27_3 0.00906677f
C2616 VSS_0 net27_4 0.0144341f
C2617 VSS_0 net27_6 0.00618469f
C2618 VSS_0 net27_7 0.0215874f
C2619 VSS_0 net28 0.0208388f
C2620 VSS_0 net28_11 0.0130138f
C2621 VSS_0 net28_2 0.0170959f
C2622 VSS_0 net28_3 0.0185578f
C2623 VSS_0 net28_4 0.018694f
C2624 VSS_0 net28_5 0.00746605f
C2625 VSS_0 net28_6 0.00771993f
C2626 VSS_0 net28_7 0.00373303f
C2627 VSS_0 net28_8 0.00746605f
C2628 VSS_0 net28_9 0.0179507f
C2629 VSS_0 net3 0.00634266f
C2630 VSS_0 net3_2 0.00826191f
C2631 VSS_0 net3_3 0.0091349f
C2632 VSS_0 net3_4 0.0140653f
C2633 VSS_0 net3_6 0.00598394f
C2634 VSS_0 net3_7 0.0213859f
C2635 VSS_0 net4 0.0201051f
C2636 VSS_0 net4_11 0.0131875f
C2637 VSS_0 net4_2 0.0176566f
C2638 VSS_0 net4_3 0.0189339f
C2639 VSS_0 net4_4 0.0190729f
C2640 VSS_0 net4_5 0.00761736f
C2641 VSS_0 net4_6 0.00761736f
C2642 VSS_0 net4_7 0.00380868f
C2643 VSS_0 net4_8 0.00774181f
C2644 VSS_0 net4_9 0.0183145f
C2645 VSS_0 net6 0.00638425f
C2646 VSS_0 net67 0.000701459f
C2647 VSS_0 net68 0.000837172f
C2648 VSS_0 net69 0.000837172f
C2649 VSS_0 net6_2 0.00831608f
C2650 VSS_0 net6_3 0.0091109f
C2651 VSS_0 net6_4 0.0143625f
C2652 VSS_0 net6_6 0.00617937f
C2653 VSS_0 net6_7 0.0215261f
C2654 VSS_0 net7 0.0208473f
C2655 VSS_0 net70 0.000837172f
C2656 VSS_0 net71 0.000837172f
C2657 VSS_0 net72 0.000837172f
C2658 VSS_0 net73 0.000828748f
C2659 VSS_0 net74 0.000534323f
C2660 VSS_0 net76 0.00289089f
C2661 VSS_0 net76_2 0.00376566f
C2662 VSS_0 net76_3 0.00453523f
C2663 VSS_0 net76_4 0.0027274f
C2664 VSS_0 net76_5 0.00641079f
C2665 VSS_0 net76_7 0.00974739f
C2666 VSS_0 net78 0.000762927f
C2667 VSS_0 net79 0.00296291f
C2668 VSS_0 net79_2 0.00385947f
C2669 VSS_0 net79_3 0.00454663f
C2670 VSS_0 net79_4 0.00295312f
C2671 VSS_0 net79_5 0.00657048f
C2672 VSS_0 net79_7 0.0102124f
C2673 VSS_0 net7_11 0.0128627f
C2674 VSS_0 net7_2 0.0172232f
C2675 VSS_0 net7_3 0.0184634f
C2676 VSS_0 net7_4 0.0185989f
C2677 VSS_0 net7_5 0.00742807f
C2678 VSS_0 net7_6 0.00770998f
C2679 VSS_0 net7_7 0.00371404f
C2680 VSS_0 net7_8 0.00755252f
C2681 VSS_0 net7_9 0.0178594f
C2682 VSS_0 net81 0.000688431f
C2683 VSS_0 net82 0.00295853f
C2684 VSS_0 net82_2 0.00385376f
C2685 VSS_0 net82_3 0.00454092f
C2686 VSS_0 net82_4 0.00296187f
C2687 VSS_0 net82_5 0.00656077f
C2688 VSS_0 net82_7 0.0101388f
C2689 VSS_0 net84 0.000688431f
C2690 VSS_0 net85 0.00295853f
C2691 VSS_0 net85_2 0.00385376f
C2692 VSS_0 net85_3 0.00454092f
C2693 VSS_0 net85_4 0.00296187f
C2694 VSS_0 net85_5 0.00656077f
C2695 VSS_0 net85_7 0.0101388f
C2696 VSS_0 net87 0.000688431f
C2697 VSS_0 net88 0.00295853f
C2698 VSS_0 net88_2 0.00385376f
C2699 VSS_0 net88_3 0.00454092f
C2700 VSS_0 net88_4 0.00296187f
C2701 VSS_0 net88_5 0.00656077f
C2702 VSS_0 net88_7 0.0101388f
C2703 VSS_0 net90 0.000688431f
C2704 VSS_0 net91 0.00295853f
C2705 VSS_0 net91_2 0.00385376f
C2706 VSS_0 net91_3 0.00454092f
C2707 VSS_0 net91_4 0.00296187f
C2708 VSS_0 net91_5 0.00656077f
C2709 VSS_0 net91_7 0.0101388f
C2710 VSS_0 net93 0.000688431f
C2711 VSS_0 net94 0.00295853f
C2712 VSS_0 net94_2 0.00385376f
C2713 VSS_0 net94_3 0.00454092f
C2714 VSS_0 net94_4 0.00296187f
C2715 VSS_0 net94_5 0.00656077f
C2716 VSS_0 net94_7 0.0101388f
C2717 VSS_0 net96 0.000735313f
C2718 VSS_0 net97 0.00296513f
C2719 VSS_0 net97_2 0.00386236f
C2720 VSS_0 net97_3 0.00457513f
C2721 VSS_0 net97_4 0.00294041f
C2722 VSS_0 net97_5 0.00657541f
C2723 VSS_0 net97_7 0.010161f
C2724 VSS_0 net99 0.000555598f
C2725 VSS_2 WL_1 0.00030957f
C2726 VSS_2 WL_1_1 0.000742993f
C2727 VSS_2 WL_1_10 0.00119194f
C2728 VSS_2 WL_1_11 0.00112408f
C2729 VSS_2 WL_1_12 0.00119194f
C2730 VSS_2 WL_1_13 0.00119194f
C2731 VSS_2 WL_1_14 0.00119194f
C2732 VSS_2 WL_1_15 0.00177108f
C2733 VSS_2 WL_1_16 0.000615981f
C2734 VSS_2 WL_1_17 0.000615981f
C2735 VSS_2 WL_1_18 0.000547979f
C2736 VSS_2 WL_1_19 0.000547979f
C2737 VSS_2 WL_1_2 0.000719647f
C2738 VSS_2 WL_1_20 0.00056846f
C2739 VSS_2 WL_1_21 0.00056846f
C2740 VSS_2 WL_1_22 0.000547979f
C2741 VSS_2 WL_1_23 0.000547979f
C2742 VSS_2 WL_1_24 0.000547979f
C2743 VSS_2 WL_1_25 0.000547979f
C2744 VSS_2 WL_1_26 0.000547979f
C2745 VSS_2 WL_1_27 0.000547979f
C2746 VSS_2 WL_1_28 0.000373188f
C2747 VSS_2 WL_1_29 0.000373188f
C2748 VSS_2 WL_1_3 0.000746544f
C2749 VSS_2 WL_1_30 0.000962807f
C2750 VSS_2 WL_1_31 0.000962807f
C2751 VSS_2 WL_1_4 0.000719647f
C2752 VSS_2 WL_1_5 0.000719647f
C2753 VSS_2 WL_1_6 0.000719647f
C2754 VSS_2 WL_1_7 0.000490098f
C2755 VSS_2 WL_1_8 0.00126443f
C2756 VSS_2 WL_1_9 0.000852637f
C2757 VSS_2 XB_1_0 0.00215435f
C2758 VSS_2 XB_1_0_1 0.00907592f
C2759 VSS_2 XB_1_0_2 0.0012729f
C2760 VSS_2 XB_1_0_3 0.00254579f
C2761 VSS_2 XB_1_1 0.00218609f
C2762 VSS_2 XB_1_1_1 0.00920862f
C2763 VSS_2 XB_1_1_2 0.00129165f
C2764 VSS_2 XB_1_1_3 0.0025833f
C2765 VSS_2 XB_1_2 0.00218609f
C2766 VSS_2 XB_1_2_1 0.00920862f
C2767 VSS_2 XB_1_2_2 0.00129165f
C2768 VSS_2 XB_1_2_3 0.0025833f
C2769 VSS_2 XB_1_3 0.00218609f
C2770 VSS_2 XB_1_3_1 0.00920862f
C2771 VSS_2 XB_1_3_2 0.00129165f
C2772 VSS_2 XB_1_3_3 0.0025833f
C2773 VSS_2 XB_1_4 0.00218609f
C2774 VSS_2 XB_1_4_1 0.00920862f
C2775 VSS_2 XB_1_4_2 0.00129165f
C2776 VSS_2 XB_1_4_3 0.0025833f
C2777 VSS_2 XB_1_5 0.00218609f
C2778 VSS_2 XB_1_5_1 0.00920862f
C2779 VSS_2 XB_1_5_2 0.00129165f
C2780 VSS_2 XB_1_5_3 0.0025833f
C2781 VSS_2 XB_1_6 0.00218609f
C2782 VSS_2 XB_1_6_1 0.00916211f
C2783 VSS_2 XB_1_6_2 0.00129165f
C2784 VSS_2 XB_1_6_3 0.0025833f
C2785 VSS_2 XB_1_7 0.00233138f
C2786 VSS_2 XB_1_7_1 0.0097461f
C2787 VSS_2 XB_1_7_2 0.0013775f
C2788 VSS_2 XB_1_7_3 0.00275499f
C2789 VSS_2 net133 0.00775636f
C2790 VSS_2 net133_10 0.00706557f
C2791 VSS_2 net133_2 0.00674819f
C2792 VSS_2 net133_3 0.0073045f
C2793 VSS_2 net133_4 0.00735814f
C2794 VSS_2 net133_5 0.00293871f
C2795 VSS_2 net133_6 0.00293871f
C2796 VSS_2 net133_7 0.00146935f
C2797 VSS_2 net133_8 0.00293871f
C2798 VSS_2 net133_9 0.00454703f
C2799 VSS_2 net134 0.00782362f
C2800 VSS_2 net134_10 0.00707569f
C2801 VSS_2 net134_2 0.00675783f
C2802 VSS_2 net134_3 0.00731497f
C2803 VSS_2 net134_4 0.00736868f
C2804 VSS_2 net134_5 0.00294291f
C2805 VSS_2 net134_6 0.00294291f
C2806 VSS_2 net134_7 0.00147146f
C2807 VSS_2 net134_8 0.00294291f
C2808 VSS_2 net134_9 0.00455354f
C2809 VSS_2 net136 0.00778206f
C2810 VSS_2 net136_10 0.00707569f
C2811 VSS_2 net136_2 0.00675783f
C2812 VSS_2 net136_3 0.00731497f
C2813 VSS_2 net136_4 0.00736868f
C2814 VSS_2 net136_5 0.00294291f
C2815 VSS_2 net136_6 0.00294291f
C2816 VSS_2 net136_7 0.00147146f
C2817 VSS_2 net136_8 0.00294291f
C2818 VSS_2 net136_9 0.00455354f
C2819 VSS_2 net137 0.00778206f
C2820 VSS_2 net137_10 0.00707569f
C2821 VSS_2 net137_2 0.00675783f
C2822 VSS_2 net137_3 0.00731497f
C2823 VSS_2 net137_4 0.00736868f
C2824 VSS_2 net137_5 0.00294291f
C2825 VSS_2 net137_6 0.00294291f
C2826 VSS_2 net137_7 0.00147146f
C2827 VSS_2 net137_8 0.00294291f
C2828 VSS_2 net137_9 0.00455354f
C2829 VSS_2 net139 0.00778206f
C2830 VSS_2 net139_10 0.00707569f
C2831 VSS_2 net139_2 0.00675783f
C2832 VSS_2 net139_3 0.00731497f
C2833 VSS_2 net139_4 0.00736868f
C2834 VSS_2 net139_5 0.00294291f
C2835 VSS_2 net139_6 0.00294291f
C2836 VSS_2 net139_7 0.00147146f
C2837 VSS_2 net139_8 0.00294291f
C2838 VSS_2 net139_9 0.00455354f
C2839 VSS_2 net141 0.00778206f
C2840 VSS_2 net141_10 0.00707569f
C2841 VSS_2 net141_2 0.00675783f
C2842 VSS_2 net141_3 0.00731497f
C2843 VSS_2 net141_4 0.00736868f
C2844 VSS_2 net141_5 0.00294291f
C2845 VSS_2 net141_6 0.00294291f
C2846 VSS_2 net141_7 0.00147146f
C2847 VSS_2 net141_8 0.00294291f
C2848 VSS_2 net141_9 0.00455354f
C2849 VSS_2 net142 0.00778206f
C2850 VSS_2 net142_10 0.00707569f
C2851 VSS_2 net142_2 0.00677745f
C2852 VSS_2 net142_3 0.00731497f
C2853 VSS_2 net142_4 0.00736868f
C2854 VSS_2 net142_5 0.00294291f
C2855 VSS_2 net142_6 0.00294291f
C2856 VSS_2 net142_7 0.00147146f
C2857 VSS_2 net142_8 0.00294291f
C2858 VSS_2 net142_9 0.00455354f
C2859 VSS_2 net144 0.00781371f
C2860 VSS_2 net144_10 0.00710453f
C2861 VSS_2 net144_2 0.00676622f
C2862 VSS_2 net144_3 0.00734478f
C2863 VSS_2 net144_4 0.00739871f
C2864 VSS_2 net144_5 0.00295491f
C2865 VSS_2 net144_6 0.00295491f
C2866 VSS_2 net144_7 0.00147745f
C2867 VSS_2 net144_8 0.00295491f
C2868 VSS_2 net144_9 0.0045721f
C2869 VSS_2 net76 0.00348193f
C2870 VSS_2 net76_2 0.00453554f
C2871 VSS_2 net76_3 0.00453554f
C2872 VSS_2 net76_4 0.00328501f
C2873 VSS_2 net76_5 0.00772146f
C2874 VSS_2 net76_7 0.0117402f
C2875 VSS_2 net79 0.00348028f
C2876 VSS_2 net79_2 0.00453339f
C2877 VSS_2 net79_3 0.00453339f
C2878 VSS_2 net79_4 0.00328345f
C2879 VSS_2 net79_5 0.00771779f
C2880 VSS_2 net79_7 0.0117347f
C2881 VSS_2 net82 0.00348028f
C2882 VSS_2 net82_2 0.00453339f
C2883 VSS_2 net82_3 0.00453339f
C2884 VSS_2 net82_4 0.00328345f
C2885 VSS_2 net82_5 0.00771779f
C2886 VSS_2 net82_7 0.0117347f
C2887 VSS_2 net85 0.00348028f
C2888 VSS_2 net85_2 0.00453339f
C2889 VSS_2 net85_3 0.00453339f
C2890 VSS_2 net85_4 0.00328345f
C2891 VSS_2 net85_5 0.00771779f
C2892 VSS_2 net85_7 0.0117347f
C2893 VSS_2 net88 0.00348028f
C2894 VSS_2 net88_2 0.00453339f
C2895 VSS_2 net88_3 0.00453339f
C2896 VSS_2 net88_4 0.00328345f
C2897 VSS_2 net88_5 0.00771779f
C2898 VSS_2 net88_7 0.0117347f
C2899 VSS_2 net91 0.00348028f
C2900 VSS_2 net91_2 0.00453339f
C2901 VSS_2 net91_3 0.00453339f
C2902 VSS_2 net91_4 0.00328345f
C2903 VSS_2 net91_5 0.00771779f
C2904 VSS_2 net91_7 0.0117347f
C2905 VSS_2 net94 0.00348028f
C2906 VSS_2 net94_2 0.00453339f
C2907 VSS_2 net94_3 0.00453339f
C2908 VSS_2 net94_4 0.00328345f
C2909 VSS_2 net94_5 0.00771779f
C2910 VSS_2 net94_7 0.0117347f
C2911 VSS_2 net97 0.00348349f
C2912 VSS_2 net97_2 0.00453757f
C2913 VSS_2 net97_3 0.00453757f
C2914 VSS_2 net97_4 0.00328647f
C2915 VSS_2 net97_5 0.00772491f
C2916 VSS_2 net97_7 0.0117455f
C2917 WL_0 WL_1_1 0.000159115f
C2918 WL_0 XB_0_0 0.000519998f
C2919 WL_0 net67 5.54738e-05f
C2920 WL_0 net7 4.16758e-05f
C2921 WL_0_1 WL_1 0.00014796f
C2922 WL_0_1 WL_1_1 0.000737006f
C2923 WL_0_1 WL_1_16 0.000294411f
C2924 WL_0_1 WL_1_17 0.000294411f
C2925 WL_0_1 WL_1_9 0.000407521f
C2926 WL_0_1 XB_0_0 0.00124804f
C2927 WL_0_1 net3 0.0065055f
C2928 WL_0_1 net3_3 0.00847402f
C2929 WL_0_1 net3_6 0.00613757f
C2930 WL_0_1 net3_7 0.021935f
C2931 WL_0_1 net4 0.0142794f
C2932 WL_0_1 net4_11 0.00837103f
C2933 WL_0_1 net4_4 0.0135463f
C2934 WL_0_1 net4_6 0.00541013f
C2935 WL_0_1 net67 0.000133142f
C2936 WL_0_1 net7 0.000100025f
C2937 WL_0_10 WL_1_2 0.00060524f
C2938 WL_0_10 XB_0_0_1 2.77016e-05f
C2939 WL_0_10 XB_0_1 0.0009696f
C2940 WL_0_10 net11 0.000167756f
C2941 WL_0_10 net4_2 2.64225e-05f
C2942 WL_0_10 net67 2.33175e-05f
C2943 WL_0_10 net68 0.00022207f
C2944 WL_0_11 WL_1_3 0.000570782f
C2945 WL_0_11 XB_0_1_1 2.61245e-05f
C2946 WL_0_11 XB_0_2 0.000914399f
C2947 WL_0_11 net14 0.000158205f
C2948 WL_0_11 net68 2.199e-05f
C2949 WL_0_11 net69 0.000209427f
C2950 WL_0_11 net7_2 2.49182e-05f
C2951 WL_0_12 WL_1_4 0.00060524f
C2952 WL_0_12 XB_0_2_1 2.77016e-05f
C2953 WL_0_12 XB_0_3 0.0009696f
C2954 WL_0_12 net11_2 2.64225e-05f
C2955 WL_0_12 net17 0.000167756f
C2956 WL_0_12 net69 2.33175e-05f
C2957 WL_0_12 net70 0.00022207f
C2958 WL_0_13 WL_1_5 0.00060524f
C2959 WL_0_13 XB_0_3_1 2.77016e-05f
C2960 WL_0_13 XB_0_4 0.0009696f
C2961 WL_0_13 net14_2 2.64225e-05f
C2962 WL_0_13 net21 0.000167756f
C2963 WL_0_13 net70 2.33175e-05f
C2964 WL_0_13 net71 0.00022207f
C2965 WL_0_14 WL_1_6 0.00060524f
C2966 WL_0_14 XB_0_4_1 2.77016e-05f
C2967 WL_0_14 XB_0_5 0.0009696f
C2968 WL_0_14 net17_2 2.64225e-05f
C2969 WL_0_14 net24 0.000167756f
C2970 WL_0_14 net71 2.33175e-05f
C2971 WL_0_14 net72 0.00022207f
C2972 WL_0_15 WL_1_7 0.000899309f
C2973 WL_0_15 XB_0_5_1 4.1161e-05f
C2974 WL_0_15 XB_0_6 0.0014407f
C2975 WL_0_15 net21_2 3.92604e-05f
C2976 WL_0_15 net28 0.000249264f
C2977 WL_0_15 net72 3.46469e-05f
C2978 WL_0_15 net73 0.000329967f
C2979 WL_0_16 WL_1_1 0.000316606f
C2980 WL_0_16 XB_0_0 0.00103469f
C2981 WL_0_16 net3_4 0.0144265f
C2982 WL_0_16 net4_5 0.00541013f
C2983 WL_0_16 net67 0.000110382f
C2984 WL_0_16 net7 8.29264e-05f
C2985 WL_0_17 WL_1_1 0.000316606f
C2986 WL_0_17 XB_0_0 0.00103469f
C2987 WL_0_17 net3_2 0.00847402f
C2988 WL_0_17 net4_2 0.0123882f
C2989 WL_0_17 net4_3 0.0134475f
C2990 WL_0_17 net4_7 0.00270506f
C2991 WL_0_17 net4_8 0.00541013f
C2992 WL_0_17 net4_9 0.0130076f
C2993 WL_0_17 net67 0.000110382f
C2994 WL_0_17 net7 8.29264e-05f
C2995 WL_0_18 WL_1_2 0.000278251f
C2996 WL_0_18 XB_0_0_1 1.27354e-05f
C2997 WL_0_18 XB_0_1 0.00044576f
C2998 WL_0_18 net11 7.71235e-05f
C2999 WL_0_18 net4_2 1.21474e-05f
C3000 WL_0_18 net67 1.07199e-05f
C3001 WL_0_18 net68 0.000102093f
C3002 WL_0_18 net6_4 0.0144467f
C3003 WL_0_18 net7_5 0.00541856f
C3004 WL_0_19 WL_1_2 0.000278251f
C3005 WL_0_19 XB_0_0_1 1.27354e-05f
C3006 WL_0_19 XB_0_1 0.0008162f
C3007 WL_0_19 XB_0_1_1 0.00154859f
C3008 WL_0_19 XB_0_1_2 0.000218875f
C3009 WL_0_19 XB_0_1_3 0.000437749f
C3010 WL_0_19 net11 7.71235e-05f
C3011 WL_0_19 net4_2 1.21474e-05f
C3012 WL_0_19 net67 1.07199e-05f
C3013 WL_0_19 net68 0.000102093f
C3014 WL_0_19 net6_2 0.00848593f
C3015 WL_0_19 net7_2 0.0124076f
C3016 WL_0_19 net7_3 0.0134685f
C3017 WL_0_19 net7_7 0.00270928f
C3018 WL_0_19 net7_8 0.00541856f
C3019 WL_0_19 net7_9 0.0130279f
C3020 WL_0_2 WL_1_10 0.000571283f
C3021 WL_0_2 WL_1_18 0.00026264f
C3022 WL_0_2 WL_1_19 0.00026264f
C3023 WL_0_2 WL_1_2 0.000710337f
C3024 WL_0_2 XB_0_0_1 1.67251e-05f
C3025 WL_0_2 XB_0_1 0.000585405f
C3026 WL_0_2 net11 0.000101284f
C3027 WL_0_2 net4_2 1.59528e-05f
C3028 WL_0_2 net6 0.00651464f
C3029 WL_0_2 net67 1.40782e-05f
C3030 WL_0_2 net68 0.000134077f
C3031 WL_0_2 net6_3 0.00848593f
C3032 WL_0_2 net6_6 0.0061462f
C3033 WL_0_2 net6_7 0.0219658f
C3034 WL_0_2 net7 0.0143017f
C3035 WL_0_2 net7_11 0.00838409f
C3036 WL_0_2 net7_4 0.0135674f
C3037 WL_0_2 net7_6 0.00541856f
C3038 WL_0_20 WL_1_3 0.00028865f
C3039 WL_0_20 XB_0_1_1 1.32114e-05f
C3040 WL_0_20 XB_0_2 0.000462421f
C3041 WL_0_20 net10_4 0.0144467f
C3042 WL_0_20 net11_5 0.00541856f
C3043 WL_0_20 net14 8.00061e-05f
C3044 WL_0_20 net68 1.11206e-05f
C3045 WL_0_20 net69 0.000105909f
C3046 WL_0_20 net7_2 1.26014e-05f
C3047 WL_0_21 WL_1_3 0.00028865f
C3048 WL_0_21 XB_0_1_1 1.32114e-05f
C3049 WL_0_21 XB_0_2 0.000832861f
C3050 WL_0_21 XB_0_2_1 0.00154859f
C3051 WL_0_21 XB_0_2_2 0.000218875f
C3052 WL_0_21 XB_0_2_3 0.000437749f
C3053 WL_0_21 net10_2 0.00848593f
C3054 WL_0_21 net11_2 0.0124076f
C3055 WL_0_21 net11_3 0.0134685f
C3056 WL_0_21 net11_7 0.00270928f
C3057 WL_0_21 net11_8 0.00541856f
C3058 WL_0_21 net11_9 0.0130279f
C3059 WL_0_21 net14 8.00061e-05f
C3060 WL_0_21 net68 1.11206e-05f
C3061 WL_0_21 net69 0.000105909f
C3062 WL_0_21 net7_2 1.26014e-05f
C3063 WL_0_22 WL_1_4 0.000278251f
C3064 WL_0_22 XB_0_2_1 1.27354e-05f
C3065 WL_0_22 XB_0_3 0.00044576f
C3066 WL_0_22 net11_2 1.21474e-05f
C3067 WL_0_22 net13_4 0.0144467f
C3068 WL_0_22 net14_5 0.00541856f
C3069 WL_0_22 net17 7.71235e-05f
C3070 WL_0_22 net69 1.07199e-05f
C3071 WL_0_22 net70 0.000102093f
C3072 WL_0_23 WL_1_4 0.000278251f
C3073 WL_0_23 XB_0_2_1 1.27354e-05f
C3074 WL_0_23 XB_0_3 0.0008162f
C3075 WL_0_23 XB_0_3_1 0.00154859f
C3076 WL_0_23 XB_0_3_2 0.000218875f
C3077 WL_0_23 XB_0_3_3 0.000437749f
C3078 WL_0_23 net11_2 1.21474e-05f
C3079 WL_0_23 net13_2 0.00848593f
C3080 WL_0_23 net14_2 0.0124076f
C3081 WL_0_23 net14_3 0.0134685f
C3082 WL_0_23 net14_7 0.00270928f
C3083 WL_0_23 net14_8 0.00541856f
C3084 WL_0_23 net14_9 0.0130279f
C3085 WL_0_23 net17 7.71235e-05f
C3086 WL_0_23 net69 1.07199e-05f
C3087 WL_0_23 net70 0.000102093f
C3088 WL_0_24 WL_1_5 0.000278251f
C3089 WL_0_24 XB_0_3_1 1.27354e-05f
C3090 WL_0_24 XB_0_4 0.00044576f
C3091 WL_0_24 net14_2 1.21474e-05f
C3092 WL_0_24 net16_4 0.0144467f
C3093 WL_0_24 net17_5 0.00541856f
C3094 WL_0_24 net21 7.71235e-05f
C3095 WL_0_24 net70 1.07199e-05f
C3096 WL_0_24 net71 0.000102093f
C3097 WL_0_25 WL_1_5 0.000278251f
C3098 WL_0_25 XB_0_3_1 1.27354e-05f
C3099 WL_0_25 XB_0_4 0.0008162f
C3100 WL_0_25 XB_0_4_1 0.00154859f
C3101 WL_0_25 XB_0_4_2 0.000218875f
C3102 WL_0_25 XB_0_4_3 0.000437749f
C3103 WL_0_25 net14_2 1.21474e-05f
C3104 WL_0_25 net16_2 0.00848593f
C3105 WL_0_25 net17_2 0.0124076f
C3106 WL_0_25 net17_3 0.0134685f
C3107 WL_0_25 net17_7 0.00270928f
C3108 WL_0_25 net17_8 0.00541856f
C3109 WL_0_25 net17_9 0.0130279f
C3110 WL_0_25 net21 7.71235e-05f
C3111 WL_0_25 net70 1.07199e-05f
C3112 WL_0_25 net71 0.000102093f
C3113 WL_0_26 WL_1_6 0.000278251f
C3114 WL_0_26 XB_0_4_1 1.27354e-05f
C3115 WL_0_26 XB_0_5 0.00044576f
C3116 WL_0_26 net17_2 1.21474e-05f
C3117 WL_0_26 net20_4 0.0144467f
C3118 WL_0_26 net21_5 0.00541856f
C3119 WL_0_26 net24 7.71235e-05f
C3120 WL_0_26 net71 1.07199e-05f
C3121 WL_0_26 net72 0.000102093f
C3122 WL_0_27 WL_1_6 0.000278251f
C3123 WL_0_27 XB_0_4_1 1.27354e-05f
C3124 WL_0_27 XB_0_5 0.0008162f
C3125 WL_0_27 XB_0_5_1 0.00154859f
C3126 WL_0_27 XB_0_5_2 0.000218875f
C3127 WL_0_27 XB_0_5_3 0.000437749f
C3128 WL_0_27 net17_2 1.21474e-05f
C3129 WL_0_27 net20_2 0.00848593f
C3130 WL_0_27 net21_2 0.0124076f
C3131 WL_0_27 net21_3 0.0134685f
C3132 WL_0_27 net21_7 0.00270928f
C3133 WL_0_27 net21_8 0.00541856f
C3134 WL_0_27 net21_9 0.0130279f
C3135 WL_0_27 net24 7.71235e-05f
C3136 WL_0_27 net71 1.07199e-05f
C3137 WL_0_27 net72 0.000102093f
C3138 WL_0_28 WL_1_7 0.000189496f
C3139 WL_0_28 XB_0_6 0.000303574f
C3140 WL_0_28 net23_4 0.0144467f
C3141 WL_0_28 net24_5 0.00541856f
C3142 WL_0_28 net28 5.25231e-05f
C3143 WL_0_28 net73 6.95282e-05f
C3144 WL_0_29 WL_1_7 0.000189496f
C3145 WL_0_29 XB_0_6 0.000674014f
C3146 WL_0_29 XB_0_6_1 0.00154859f
C3147 WL_0_29 XB_0_6_2 0.000218875f
C3148 WL_0_29 XB_0_6_3 0.000437749f
C3149 WL_0_29 net23_2 0.00848593f
C3150 WL_0_29 net24_2 0.0124076f
C3151 WL_0_29 net24_3 0.0134685f
C3152 WL_0_29 net24_7 0.00270928f
C3153 WL_0_29 net24_8 0.00541856f
C3154 WL_0_29 net24_9 0.0130279f
C3155 WL_0_29 net28 5.25231e-05f
C3156 WL_0_29 net73 6.95282e-05f
C3157 WL_0_3 WL_1_11 0.000538759f
C3158 WL_0_3 WL_1_20 0.000272456f
C3159 WL_0_3 WL_1_21 0.000272456f
C3160 WL_0_3 WL_1_3 0.000736886f
C3161 WL_0_3 XB_0_1_1 1.73502e-05f
C3162 WL_0_3 XB_0_2 0.000607285f
C3163 WL_0_3 net10 0.00651464f
C3164 WL_0_3 net10_3 0.00848593f
C3165 WL_0_3 net10_6 0.0061462f
C3166 WL_0_3 net10_7 0.0219658f
C3167 WL_0_3 net11 0.0143017f
C3168 WL_0_3 net11_11 0.00838409f
C3169 WL_0_3 net11_4 0.0135674f
C3170 WL_0_3 net11_6 0.00541856f
C3171 WL_0_3 net14 0.00010507f
C3172 WL_0_3 net68 1.46044e-05f
C3173 WL_0_3 net69 0.000139088f
C3174 WL_0_3 net7_2 1.65491e-05f
C3175 WL_0_30 WL_1_8 0.000468369f
C3176 WL_0_30 XB_0_6_1 2.21586e-05f
C3177 WL_0_30 net24_2 4.61314e-05f
C3178 WL_0_30 net27_4 0.0144388f
C3179 WL_0_30 net28_5 0.00539417f
C3180 WL_0_30 net73 1.59849e-05f
C3181 WL_0_30 net74 0.000160591f
C3182 WL_0_31 WL_1_8 0.000468369f
C3183 WL_0_31 XB_0_6_1 2.21586e-05f
C3184 WL_0_31 XB_0_7 0.000767988f
C3185 WL_0_31 XB_0_7_1 0.00321049f
C3186 WL_0_31 XB_0_7_2 0.000453766f
C3187 WL_0_31 XB_0_7_3 0.000907531f
C3188 WL_0_31 net24_2 4.61314e-05f
C3189 WL_0_31 net27_2 0.0084813f
C3190 WL_0_31 net28_2 0.0123517f
C3191 WL_0_31 net28_3 0.0134078f
C3192 WL_0_31 net28_7 0.00269708f
C3193 WL_0_31 net28_8 0.00539417f
C3194 WL_0_31 net28_9 0.0129693f
C3195 WL_0_31 net73 1.59849e-05f
C3196 WL_0_31 net74 0.000160591f
C3197 WL_0_4 WL_1_12 0.000571283f
C3198 WL_0_4 WL_1_22 0.00026264f
C3199 WL_0_4 WL_1_23 0.00026264f
C3200 WL_0_4 WL_1_4 0.000710337f
C3201 WL_0_4 XB_0_2_1 1.67251e-05f
C3202 WL_0_4 XB_0_3 0.000585405f
C3203 WL_0_4 net11_2 1.59528e-05f
C3204 WL_0_4 net13 0.00651464f
C3205 WL_0_4 net13_3 0.00848593f
C3206 WL_0_4 net13_6 0.0061462f
C3207 WL_0_4 net13_7 0.0219658f
C3208 WL_0_4 net14 0.0143017f
C3209 WL_0_4 net14_11 0.00838409f
C3210 WL_0_4 net14_4 0.0135674f
C3211 WL_0_4 net14_6 0.00541856f
C3212 WL_0_4 net17 0.000101284f
C3213 WL_0_4 net69 1.40782e-05f
C3214 WL_0_4 net70 0.000134077f
C3215 WL_0_5 WL_1_13 0.000571283f
C3216 WL_0_5 WL_1_24 0.00026264f
C3217 WL_0_5 WL_1_25 0.00026264f
C3218 WL_0_5 WL_1_5 0.000710337f
C3219 WL_0_5 XB_0_3_1 1.67251e-05f
C3220 WL_0_5 XB_0_4 0.000585405f
C3221 WL_0_5 net14_2 1.59528e-05f
C3222 WL_0_5 net16 0.00651464f
C3223 WL_0_5 net16_3 0.00848593f
C3224 WL_0_5 net16_6 0.0061462f
C3225 WL_0_5 net16_7 0.0219658f
C3226 WL_0_5 net17 0.0143017f
C3227 WL_0_5 net17_11 0.00838409f
C3228 WL_0_5 net17_4 0.0135674f
C3229 WL_0_5 net17_6 0.00541856f
C3230 WL_0_5 net21 0.000101284f
C3231 WL_0_5 net70 1.40782e-05f
C3232 WL_0_5 net71 0.000134077f
C3233 WL_0_6 WL_1_14 0.000571283f
C3234 WL_0_6 WL_1_26 0.00026264f
C3235 WL_0_6 WL_1_27 0.00026264f
C3236 WL_0_6 WL_1_6 0.000710337f
C3237 WL_0_6 XB_0_4_1 1.67251e-05f
C3238 WL_0_6 XB_0_5 0.000585405f
C3239 WL_0_6 net17_2 1.59528e-05f
C3240 WL_0_6 net20 0.00651464f
C3241 WL_0_6 net20_3 0.00848593f
C3242 WL_0_6 net20_6 0.0061462f
C3243 WL_0_6 net20_7 0.0219658f
C3244 WL_0_6 net21 0.0143017f
C3245 WL_0_6 net21_11 0.00838409f
C3246 WL_0_6 net21_4 0.0135674f
C3247 WL_0_6 net21_6 0.00541856f
C3248 WL_0_6 net24 0.000101284f
C3249 WL_0_6 net71 1.40782e-05f
C3250 WL_0_6 net72 0.000134077f
C3251 WL_0_7 WL_1_15 0.000848854f
C3252 WL_0_7 WL_1_28 0.000178864f
C3253 WL_0_7 WL_1_29 0.000178864f
C3254 WL_0_7 WL_1_7 0.000483757f
C3255 WL_0_7 XB_0_5_1 1.13902e-05f
C3256 WL_0_7 XB_0_6 0.000398676f
C3257 WL_0_7 net21_2 1.08643e-05f
C3258 WL_0_7 net23 0.00651464f
C3259 WL_0_7 net23_3 0.00848593f
C3260 WL_0_7 net23_6 0.0061462f
C3261 WL_0_7 net23_7 0.0219658f
C3262 WL_0_7 net24 0.0143017f
C3263 WL_0_7 net24_11 0.00838409f
C3264 WL_0_7 net24_4 0.0135674f
C3265 WL_0_7 net24_6 0.00541856f
C3266 WL_0_7 net28 6.89772e-05f
C3267 WL_0_7 net73 9.13096e-05f
C3268 WL_0_8 WL_1_30 0.000449243f
C3269 WL_0_8 WL_1_31 0.000449243f
C3270 WL_0_8 WL_1_8 0.00120508f
C3271 WL_0_8 XB_0_6_1 2.91003e-05f
C3272 WL_0_8 net24_2 6.05832e-05f
C3273 WL_0_8 net27 0.00651109f
C3274 WL_0_8 net27_3 0.0084813f
C3275 WL_0_8 net27_6 0.00614284f
C3276 WL_0_8 net27_7 0.0219538f
C3277 WL_0_8 net28 0.0142373f
C3278 WL_0_8 net28_11 0.00834634f
C3279 WL_0_8 net28_4 0.0135063f
C3280 WL_0_8 net28_6 0.00539417f
C3281 WL_0_8 net73 2.09926e-05f
C3282 WL_0_8 net74 0.0002109f
C3283 WL_0_9 WL_1_1 0.000438244f
C3284 WL_0_9 XB_0_0 0.00143221f
C3285 WL_0_9 net67 0.00015279f
C3286 WL_0_9 net7 0.000114786f
C3287 WL_1 XB_1_0 0.000498661f
C3288 WL_1 net134 3.58389e-05f
C3289 WL_1 net78 6.2207e-05f
C3290 WL_1_1 XB_1_0 0.00119683f
C3291 WL_1_1 net133 0.0142915f
C3292 WL_1_1 net133_4 0.0135577f
C3293 WL_1_1 net133_6 0.00541471f
C3294 WL_1_1 net133_9 0.00837812f
C3295 WL_1_1 net134 8.60164e-05f
C3296 WL_1_1 net76 0.00648671f
C3297 WL_1_1 net76_3 0.00844955f
C3298 WL_1_1 net76_4 0.00611985f
C3299 WL_1_1 net76_7 0.0218716f
C3300 WL_1_1 net78 0.000149302f
C3301 WL_1_10 XB_1_0_1 8.07078e-05f
C3302 WL_1_10 XB_1_1 0.000968581f
C3303 WL_1_10 net133_2 2.24714e-05f
C3304 WL_1_10 net136 0.000141555f
C3305 WL_1_10 net78 1.97375e-05f
C3306 WL_1_10 net81 0.000235412f
C3307 WL_1_11 XB_1_1_1 7.6113e-05f
C3308 WL_1_11 XB_1_2 0.000913438f
C3309 WL_1_11 net134_2 2.1192e-05f
C3310 WL_1_11 net137 0.000133496f
C3311 WL_1_11 net81 1.86138e-05f
C3312 WL_1_11 net84 0.000222009f
C3313 WL_1_12 XB_1_2_1 8.07078e-05f
C3314 WL_1_12 XB_1_3 0.000968581f
C3315 WL_1_12 net136_2 2.24714e-05f
C3316 WL_1_12 net139 0.000141555f
C3317 WL_1_12 net84 1.97375e-05f
C3318 WL_1_12 net87 0.000235412f
C3319 WL_1_13 XB_1_3_1 8.07078e-05f
C3320 WL_1_13 XB_1_4 0.000968581f
C3321 WL_1_13 net137_2 2.24714e-05f
C3322 WL_1_13 net141 0.000141555f
C3323 WL_1_13 net87 1.97375e-05f
C3324 WL_1_13 net90 0.000235412f
C3325 WL_1_14 XB_1_4_1 8.07078e-05f
C3326 WL_1_14 XB_1_5 0.000968581f
C3327 WL_1_14 net139_2 2.24714e-05f
C3328 WL_1_14 net142 0.000141555f
C3329 WL_1_14 net90 1.97375e-05f
C3330 WL_1_14 net93 0.000235412f
C3331 WL_1_15 XB_1_5_1 0.000119922f
C3332 WL_1_15 XB_1_6 0.00143919f
C3333 WL_1_15 net141_2 3.33896e-05f
C3334 WL_1_15 net144 0.000210332f
C3335 WL_1_15 net93 2.93274e-05f
C3336 WL_1_15 net96 0.000349792f
C3337 WL_1_16 XB_1_0 0.000992235f
C3338 WL_1_16 net133_5 0.00541471f
C3339 WL_1_16 net134 7.13122e-05f
C3340 WL_1_16 net76_5 0.0143848f
C3341 WL_1_16 net78 0.000123779f
C3342 WL_1_17 XB_1_0 0.000992235f
C3343 WL_1_17 net133_10 0.0130187f
C3344 WL_1_17 net133_2 0.0123987f
C3345 WL_1_17 net133_3 0.0134589f
C3346 WL_1_17 net133_7 0.00270735f
C3347 WL_1_17 net133_8 0.00541471f
C3348 WL_1_17 net134 7.13122e-05f
C3349 WL_1_17 net76_2 0.00844955f
C3350 WL_1_17 net78 0.000123779f
C3351 WL_1_18 XB_1_0_1 3.71043e-05f
C3352 WL_1_18 XB_1_1 0.000445292f
C3353 WL_1_18 net133_2 1.03309e-05f
C3354 WL_1_18 net134_5 0.00543183f
C3355 WL_1_18 net136 6.50778e-05f
C3356 WL_1_18 net79_5 0.0143941f
C3357 WL_1_18 net81 0.000108227f
C3358 WL_1_19 XB_1_0_1 3.71043e-05f
C3359 WL_1_19 XB_1_1 0.000826096f
C3360 WL_1_19 XB_1_1_1 0.00159191f
C3361 WL_1_19 XB_1_1_2 0.000224998f
C3362 WL_1_19 XB_1_1_3 0.000449996f
C3363 WL_1_19 net133_2 1.03309e-05f
C3364 WL_1_19 net134_10 0.0130598f
C3365 WL_1_19 net134_2 0.0124379f
C3366 WL_1_19 net134_3 0.0135015f
C3367 WL_1_19 net134_7 0.00271591f
C3368 WL_1_19 net134_8 0.00543183f
C3369 WL_1_19 net136 6.50778e-05f
C3370 WL_1_19 net79_2 0.00845502f
C3371 WL_1_19 net81 0.000108227f
C3372 WL_1_2 XB_1_0_1 4.87281e-05f
C3373 WL_1_2 XB_1_1 0.00058479f
C3374 WL_1_2 net133_2 1.35673e-05f
C3375 WL_1_2 net134 0.0143367f
C3376 WL_1_2 net134_4 0.0136006f
C3377 WL_1_2 net134_6 0.00543183f
C3378 WL_1_2 net134_9 0.00840461f
C3379 WL_1_2 net136 8.54649e-05f
C3380 WL_1_2 net78 1.19167e-05f
C3381 WL_1_2 net79 0.00649091f
C3382 WL_1_2 net79_3 0.00845502f
C3383 WL_1_2 net79_4 0.00612381f
C3384 WL_1_2 net79_7 0.0218858f
C3385 WL_1_2 net81 0.000142132f
C3386 WL_1_20 XB_1_1_1 3.84911e-05f
C3387 WL_1_20 XB_1_2 0.000461935f
C3388 WL_1_20 net134_2 1.0717e-05f
C3389 WL_1_20 net136_5 0.00543183f
C3390 WL_1_20 net137 6.75101e-05f
C3391 WL_1_20 net82_5 0.0143941f
C3392 WL_1_20 net84 0.000112272f
C3393 WL_1_21 XB_1_1_1 3.84911e-05f
C3394 WL_1_21 XB_1_2 0.000842739f
C3395 WL_1_21 XB_1_2_1 0.00159191f
C3396 WL_1_21 XB_1_2_2 0.000224998f
C3397 WL_1_21 XB_1_2_3 0.000449996f
C3398 WL_1_21 net134_2 1.0717e-05f
C3399 WL_1_21 net136_10 0.0130598f
C3400 WL_1_21 net136_2 0.0124379f
C3401 WL_1_21 net136_3 0.0135015f
C3402 WL_1_21 net136_7 0.00271591f
C3403 WL_1_21 net136_8 0.00543183f
C3404 WL_1_21 net137 6.75101e-05f
C3405 WL_1_21 net82_2 0.00845502f
C3406 WL_1_21 net84 0.000112272f
C3407 WL_1_22 XB_1_2_1 3.71043e-05f
C3408 WL_1_22 XB_1_3 0.000445292f
C3409 WL_1_22 net136_2 1.03309e-05f
C3410 WL_1_22 net137_5 0.00543183f
C3411 WL_1_22 net139 6.50778e-05f
C3412 WL_1_22 net85_5 0.0143941f
C3413 WL_1_22 net87 0.000108227f
C3414 WL_1_23 XB_1_2_1 3.71043e-05f
C3415 WL_1_23 XB_1_3 0.000826096f
C3416 WL_1_23 XB_1_3_1 0.00159191f
C3417 WL_1_23 XB_1_3_2 0.000224998f
C3418 WL_1_23 XB_1_3_3 0.000449996f
C3419 WL_1_23 net136_2 1.03309e-05f
C3420 WL_1_23 net137_10 0.0130598f
C3421 WL_1_23 net137_2 0.0124379f
C3422 WL_1_23 net137_3 0.0135015f
C3423 WL_1_23 net137_7 0.00271591f
C3424 WL_1_23 net137_8 0.00543183f
C3425 WL_1_23 net139 6.50778e-05f
C3426 WL_1_23 net85_2 0.00845502f
C3427 WL_1_23 net87 0.000108227f
C3428 WL_1_24 XB_1_3_1 3.71043e-05f
C3429 WL_1_24 XB_1_4 0.000445292f
C3430 WL_1_24 net137_2 1.03309e-05f
C3431 WL_1_24 net139_5 0.00543183f
C3432 WL_1_24 net141 6.50778e-05f
C3433 WL_1_24 net88_5 0.0143941f
C3434 WL_1_24 net90 0.000108227f
C3435 WL_1_25 XB_1_3_1 3.71043e-05f
C3436 WL_1_25 XB_1_4 0.000826096f
C3437 WL_1_25 XB_1_4_1 0.00159191f
C3438 WL_1_25 XB_1_4_2 0.000224998f
C3439 WL_1_25 XB_1_4_3 0.000449996f
C3440 WL_1_25 net137_2 1.03309e-05f
C3441 WL_1_25 net139_10 0.0130598f
C3442 WL_1_25 net139_2 0.0124379f
C3443 WL_1_25 net139_3 0.0135015f
C3444 WL_1_25 net139_7 0.00271591f
C3445 WL_1_25 net139_8 0.00543183f
C3446 WL_1_25 net141 6.50778e-05f
C3447 WL_1_25 net88_2 0.00845502f
C3448 WL_1_25 net90 0.000108227f
C3449 WL_1_26 XB_1_4_1 3.71043e-05f
C3450 WL_1_26 XB_1_5 0.000445292f
C3451 WL_1_26 net139_2 1.03309e-05f
C3452 WL_1_26 net141_5 0.00543183f
C3453 WL_1_26 net142 6.50778e-05f
C3454 WL_1_26 net91_5 0.0143941f
C3455 WL_1_26 net93 0.000108227f
C3456 WL_1_27 XB_1_4_1 3.71043e-05f
C3457 WL_1_27 XB_1_5 0.000826096f
C3458 WL_1_27 XB_1_5_1 0.00159191f
C3459 WL_1_27 XB_1_5_2 0.000224998f
C3460 WL_1_27 XB_1_5_3 0.000449996f
C3461 WL_1_27 net139_2 1.03309e-05f
C3462 WL_1_27 net141_10 0.0130598f
C3463 WL_1_27 net141_2 0.0124379f
C3464 WL_1_27 net141_3 0.0135015f
C3465 WL_1_27 net141_7 0.00271591f
C3466 WL_1_27 net141_8 0.00543183f
C3467 WL_1_27 net142 6.50778e-05f
C3468 WL_1_27 net91_2 0.00845502f
C3469 WL_1_27 net93 0.000108227f
C3470 WL_1_28 XB_1_5_1 2.5269e-05f
C3471 WL_1_28 XB_1_6 0.000303255f
C3472 WL_1_28 net142_5 0.00543183f
C3473 WL_1_28 net144 4.43196e-05f
C3474 WL_1_28 net94_5 0.0143941f
C3475 WL_1_28 net96 7.37055e-05f
C3476 WL_1_29 XB_1_5_1 2.5269e-05f
C3477 WL_1_29 XB_1_6 0.000684059f
C3478 WL_1_29 XB_1_6_1 0.00159191f
C3479 WL_1_29 XB_1_6_2 0.000224998f
C3480 WL_1_29 XB_1_6_3 0.000449996f
C3481 WL_1_29 net142_10 0.0130598f
C3482 WL_1_29 net142_2 0.0124379f
C3483 WL_1_29 net142_3 0.0135015f
C3484 WL_1_29 net142_7 0.00271591f
C3485 WL_1_29 net142_8 0.00543183f
C3486 WL_1_29 net144 4.43196e-05f
C3487 WL_1_29 net94_2 0.00845502f
C3488 WL_1_29 net96 7.37055e-05f
C3489 WL_1_3 XB_1_1_1 5.05494e-05f
C3490 WL_1_3 XB_1_2 0.000606647f
C3491 WL_1_3 net134_2 1.40744e-05f
C3492 WL_1_3 net136 0.0143367f
C3493 WL_1_3 net136_4 0.0136006f
C3494 WL_1_3 net136_6 0.00543183f
C3495 WL_1_3 net136_9 0.00840461f
C3496 WL_1_3 net137 8.86592e-05f
C3497 WL_1_3 net81 1.23621e-05f
C3498 WL_1_3 net82 0.00649091f
C3499 WL_1_3 net82_3 0.00845502f
C3500 WL_1_3 net82_4 0.00612381f
C3501 WL_1_3 net82_7 0.0218858f
C3502 WL_1_3 net84 0.000147444f
C3503 WL_1_30 XB_1_6_1 5.31246e-05f
C3504 WL_1_30 net142_2 2.88835e-05f
C3505 WL_1_30 net144_5 0.00541912f
C3506 WL_1_30 net96 1.04154e-05f
C3507 WL_1_30 net97_5 0.0144132f
C3508 WL_1_30 net99 0.000174104f
C3509 WL_1_31 XB_1_6_1 5.31246e-05f
C3510 WL_1_31 XB_1_7 0.000763169f
C3511 WL_1_31 XB_1_7_1 0.00319034f
C3512 WL_1_31 XB_1_7_2 0.000450918f
C3513 WL_1_31 XB_1_7_3 0.000901836f
C3514 WL_1_31 net142_2 2.88835e-05f
C3515 WL_1_31 net144_10 0.0130293f
C3516 WL_1_31 net144_2 0.0124088f
C3517 WL_1_31 net144_3 0.0134699f
C3518 WL_1_31 net144_7 0.00270956f
C3519 WL_1_31 net144_8 0.00541912f
C3520 WL_1_31 net96 1.04154e-05f
C3521 WL_1_31 net97_2 0.00846624f
C3522 WL_1_31 net99 0.000174104f
C3523 WL_1_4 XB_1_2_1 4.87281e-05f
C3524 WL_1_4 XB_1_3 0.00058479f
C3525 WL_1_4 net136_2 1.35673e-05f
C3526 WL_1_4 net137 0.0143367f
C3527 WL_1_4 net137_4 0.0136006f
C3528 WL_1_4 net137_6 0.00543183f
C3529 WL_1_4 net137_9 0.00840461f
C3530 WL_1_4 net139 8.54649e-05f
C3531 WL_1_4 net84 1.19167e-05f
C3532 WL_1_4 net85 0.00649091f
C3533 WL_1_4 net85_3 0.00845502f
C3534 WL_1_4 net85_4 0.00612381f
C3535 WL_1_4 net85_7 0.0218858f
C3536 WL_1_4 net87 0.000142132f
C3537 WL_1_5 XB_1_3_1 4.87281e-05f
C3538 WL_1_5 XB_1_4 0.00058479f
C3539 WL_1_5 net137_2 1.35673e-05f
C3540 WL_1_5 net139 0.0143367f
C3541 WL_1_5 net139_4 0.0136006f
C3542 WL_1_5 net139_6 0.00543183f
C3543 WL_1_5 net139_9 0.00840461f
C3544 WL_1_5 net141 8.54649e-05f
C3545 WL_1_5 net87 1.19167e-05f
C3546 WL_1_5 net88 0.00649091f
C3547 WL_1_5 net88_3 0.00845502f
C3548 WL_1_5 net88_4 0.00612381f
C3549 WL_1_5 net88_7 0.0218858f
C3550 WL_1_5 net90 0.000142132f
C3551 WL_1_6 XB_1_4_1 4.87281e-05f
C3552 WL_1_6 XB_1_5 0.00058479f
C3553 WL_1_6 net139_2 1.35673e-05f
C3554 WL_1_6 net141 0.0143367f
C3555 WL_1_6 net141_4 0.0136006f
C3556 WL_1_6 net141_6 0.00543183f
C3557 WL_1_6 net141_9 0.00840461f
C3558 WL_1_6 net142 8.54649e-05f
C3559 WL_1_6 net90 1.19167e-05f
C3560 WL_1_6 net91 0.00649091f
C3561 WL_1_6 net91_3 0.00845502f
C3562 WL_1_6 net91_4 0.00612381f
C3563 WL_1_6 net91_7 0.0218858f
C3564 WL_1_6 net93 0.000142132f
C3565 WL_1_7 XB_1_5_1 3.31851e-05f
C3566 WL_1_7 XB_1_6 0.000398257f
C3567 WL_1_7 net142 0.0143367f
C3568 WL_1_7 net142_4 0.0136006f
C3569 WL_1_7 net142_6 0.00543183f
C3570 WL_1_7 net142_9 0.00840461f
C3571 WL_1_7 net144 5.82038e-05f
C3572 WL_1_7 net94 0.00649091f
C3573 WL_1_7 net94_3 0.00845502f
C3574 WL_1_7 net94_4 0.00612381f
C3575 WL_1_7 net94_7 0.0218858f
C3576 WL_1_7 net96 9.67955e-05f
C3577 WL_1_8 XB_1_6_1 6.97672e-05f
C3578 WL_1_8 net142_2 3.7932e-05f
C3579 WL_1_8 net144 0.0143031f
C3580 WL_1_8 net144_4 0.0135688f
C3581 WL_1_8 net144_6 0.00541912f
C3582 WL_1_8 net144_9 0.00838495f
C3583 WL_1_8 net96 1.36782e-05f
C3584 WL_1_8 net97 0.00649952f
C3585 WL_1_8 net97_3 0.00846624f
C3586 WL_1_8 net97_4 0.00613193f
C3587 WL_1_8 net97_7 0.0219148f
C3588 WL_1_8 net99 0.000228646f
C3589 WL_1_9 XB_1_0 0.00137344f
C3590 WL_1_9 net134 9.87098e-05f
C3591 WL_1_9 net78 0.000171335f
C3592 XB_0_0 net4 0.00221466f
C3593 XB_0_0 net4_2 0.00192136f
C3594 XB_0_0 net4_3 0.00208565f
C3595 XB_0_0 net4_4 0.00210096f
C3596 XB_0_0 net4_5 0.000839085f
C3597 XB_0_0 net4_9 0.00201742f
C3598 XB_0_0 net67 0.00334204f
C3599 XB_0_0 net7 0.00023966f
C3600 XB_0_0_1 net67 0.013971f
C3601 XB_0_0_1 net7 0.00127102f
C3602 XB_0_0_1 net7_11 0.000157784f
C3603 XB_0_0_1 net7_2 0.000233504f
C3604 XB_0_0_1 net7_3 0.00025347f
C3605 XB_0_0_1 net7_4 0.000255331f
C3606 XB_0_0_1 net7_5 0.000101975f
C3607 XB_0_0_1 net7_6 0.000101975f
C3608 XB_0_0_1 net7_7 5.09873e-05f
C3609 XB_0_0_1 net7_8 0.000101975f
C3610 XB_0_0_1 net7_9 0.000245179f
C3611 XB_0_0_2 net4_7 0.000419542f
C3612 XB_0_0_2 net67 0.00197464f
C3613 XB_0_0_2 net7 0.000141603f
C3614 XB_0_0_3 net4_11 0.00129831f
C3615 XB_0_0_3 net4_6 0.000839085f
C3616 XB_0_0_3 net4_8 0.000839085f
C3617 XB_0_0_3 net67 0.00394929f
C3618 XB_0_0_3 net7 0.000283207f
C3619 XB_0_1 net11 0.000255344f
C3620 XB_0_1 net68 0.00333429f
C3621 XB_0_1 net7 0.00220147f
C3622 XB_0_1 net7_2 0.00190991f
C3623 XB_0_1 net7_3 0.00207322f
C3624 XB_0_1 net7_4 0.00208845f
C3625 XB_0_1 net7_5 0.000834088f
C3626 XB_0_1 net7_9 0.00200541f
C3627 XB_0_1_1 net11 0.00133659f
C3628 XB_0_1_1 net11_11 0.000157784f
C3629 XB_0_1_1 net11_2 0.000233504f
C3630 XB_0_1_1 net11_3 0.00025347f
C3631 XB_0_1_1 net11_4 0.000255331f
C3632 XB_0_1_1 net11_5 0.000101975f
C3633 XB_0_1_1 net11_6 0.000101975f
C3634 XB_0_1_1 net11_7 5.09873e-05f
C3635 XB_0_1_1 net11_8 0.000101975f
C3636 XB_0_1_1 net11_9 0.000245179f
C3637 XB_0_1_1 net68 0.0139386f
C3638 XB_0_1_2 net11 0.00015087f
C3639 XB_0_1_2 net68 0.00197006f
C3640 XB_0_1_2 net7_7 0.000417044f
C3641 XB_0_1_3 net11 0.00030174f
C3642 XB_0_1_3 net68 0.00394012f
C3643 XB_0_1_3 net7_11 0.00129058f
C3644 XB_0_1_3 net7_6 0.000834088f
C3645 XB_0_1_3 net7_8 0.000834088f
C3646 XB_0_2 net11 0.00220147f
C3647 XB_0_2 net11_2 0.00190991f
C3648 XB_0_2 net11_3 0.00207322f
C3649 XB_0_2 net11_4 0.00208845f
C3650 XB_0_2 net11_5 0.000834088f
C3651 XB_0_2 net11_9 0.00200541f
C3652 XB_0_2 net14 0.000255344f
C3653 XB_0_2 net69 0.00333429f
C3654 XB_0_2_1 net14 0.00133659f
C3655 XB_0_2_1 net14_11 0.000157784f
C3656 XB_0_2_1 net14_2 0.000233504f
C3657 XB_0_2_1 net14_3 0.00025347f
C3658 XB_0_2_1 net14_4 0.000255331f
C3659 XB_0_2_1 net14_5 0.000101975f
C3660 XB_0_2_1 net14_6 0.000101975f
C3661 XB_0_2_1 net14_7 5.09873e-05f
C3662 XB_0_2_1 net14_8 0.000101975f
C3663 XB_0_2_1 net14_9 0.000245179f
C3664 XB_0_2_1 net69 0.0139386f
C3665 XB_0_2_2 net11_7 0.000417044f
C3666 XB_0_2_2 net14 0.00015087f
C3667 XB_0_2_2 net69 0.00197006f
C3668 XB_0_2_3 net11_11 0.00129058f
C3669 XB_0_2_3 net11_6 0.000834088f
C3670 XB_0_2_3 net11_8 0.000834088f
C3671 XB_0_2_3 net14 0.00030174f
C3672 XB_0_2_3 net69 0.00394012f
C3673 XB_0_3 net14 0.00220147f
C3674 XB_0_3 net14_2 0.00190991f
C3675 XB_0_3 net14_3 0.00207322f
C3676 XB_0_3 net14_4 0.00208845f
C3677 XB_0_3 net14_5 0.000834088f
C3678 XB_0_3 net14_9 0.00200541f
C3679 XB_0_3 net17 0.000255344f
C3680 XB_0_3 net70 0.00333429f
C3681 XB_0_3_1 net17 0.00133659f
C3682 XB_0_3_1 net17_11 0.000157784f
C3683 XB_0_3_1 net17_2 0.000233504f
C3684 XB_0_3_1 net17_3 0.00025347f
C3685 XB_0_3_1 net17_4 0.000255331f
C3686 XB_0_3_1 net17_5 0.000101975f
C3687 XB_0_3_1 net17_6 0.000101975f
C3688 XB_0_3_1 net17_7 5.09873e-05f
C3689 XB_0_3_1 net17_8 0.000101975f
C3690 XB_0_3_1 net17_9 0.000245179f
C3691 XB_0_3_1 net70 0.0139386f
C3692 XB_0_3_2 net14_7 0.000417044f
C3693 XB_0_3_2 net17 0.00015087f
C3694 XB_0_3_2 net70 0.00197006f
C3695 XB_0_3_3 net14_11 0.00129058f
C3696 XB_0_3_3 net14_6 0.000834088f
C3697 XB_0_3_3 net14_8 0.000834088f
C3698 XB_0_3_3 net17 0.00030174f
C3699 XB_0_3_3 net70 0.00394012f
C3700 XB_0_4 net17 0.00220147f
C3701 XB_0_4 net17_2 0.00190991f
C3702 XB_0_4 net17_3 0.00207322f
C3703 XB_0_4 net17_4 0.00208845f
C3704 XB_0_4 net17_5 0.000834088f
C3705 XB_0_4 net17_9 0.00200541f
C3706 XB_0_4 net21 0.000255344f
C3707 XB_0_4 net71 0.00333429f
C3708 XB_0_4_1 net21 0.00133659f
C3709 XB_0_4_1 net21_11 0.000157784f
C3710 XB_0_4_1 net21_2 0.000233504f
C3711 XB_0_4_1 net21_3 0.00025347f
C3712 XB_0_4_1 net21_4 0.000255331f
C3713 XB_0_4_1 net21_5 0.000101975f
C3714 XB_0_4_1 net21_6 0.000101975f
C3715 XB_0_4_1 net21_7 5.09873e-05f
C3716 XB_0_4_1 net21_8 0.000101975f
C3717 XB_0_4_1 net21_9 0.000245179f
C3718 XB_0_4_1 net71 0.0139386f
C3719 XB_0_4_2 net17_7 0.000417044f
C3720 XB_0_4_2 net21 0.00015087f
C3721 XB_0_4_2 net71 0.00197006f
C3722 XB_0_4_3 net17_11 0.00129058f
C3723 XB_0_4_3 net17_6 0.000834088f
C3724 XB_0_4_3 net17_8 0.000834088f
C3725 XB_0_4_3 net21 0.00030174f
C3726 XB_0_4_3 net71 0.00394012f
C3727 XB_0_5 net21 0.00220147f
C3728 XB_0_5 net21_2 0.00190991f
C3729 XB_0_5 net21_3 0.00207322f
C3730 XB_0_5 net21_4 0.00208845f
C3731 XB_0_5 net21_5 0.000834088f
C3732 XB_0_5 net21_9 0.00200541f
C3733 XB_0_5 net24 0.000255344f
C3734 XB_0_5 net72 0.00333429f
C3735 XB_0_5_1 net24 0.00133659f
C3736 XB_0_5_1 net24_11 0.000157784f
C3737 XB_0_5_1 net24_2 0.000233504f
C3738 XB_0_5_1 net24_3 0.00025347f
C3739 XB_0_5_1 net24_4 0.000255331f
C3740 XB_0_5_1 net24_5 0.000101975f
C3741 XB_0_5_1 net24_6 0.000101975f
C3742 XB_0_5_1 net24_7 5.09873e-05f
C3743 XB_0_5_1 net24_8 0.000101975f
C3744 XB_0_5_1 net24_9 0.000245179f
C3745 XB_0_5_1 net72 0.0139386f
C3746 XB_0_5_2 net21_7 0.000417044f
C3747 XB_0_5_2 net24 0.00015087f
C3748 XB_0_5_2 net72 0.00197006f
C3749 XB_0_5_3 net21_11 0.00129058f
C3750 XB_0_5_3 net21_6 0.000834088f
C3751 XB_0_5_3 net21_8 0.000834088f
C3752 XB_0_5_3 net24 0.00030174f
C3753 XB_0_5_3 net72 0.00394012f
C3754 XB_0_6 net24 0.00220147f
C3755 XB_0_6 net24_2 0.00190991f
C3756 XB_0_6 net24_3 0.00207322f
C3757 XB_0_6 net24_4 0.00208845f
C3758 XB_0_6 net24_5 0.000834088f
C3759 XB_0_6 net24_9 0.00200541f
C3760 XB_0_6 net28 0.000255344f
C3761 XB_0_6 net73 0.00333429f
C3762 XB_0_6_1 net28 0.00133348f
C3763 XB_0_6_1 net28_11 0.00015596f
C3764 XB_0_6_1 net28_2 0.000230805f
C3765 XB_0_6_1 net28_3 0.00025054f
C3766 XB_0_6_1 net28_4 0.00025238f
C3767 XB_0_6_1 net28_5 0.000100796f
C3768 XB_0_6_1 net28_6 0.000100796f
C3769 XB_0_6_1 net28_7 5.0398e-05f
C3770 XB_0_6_1 net28_8 0.000100796f
C3771 XB_0_6_1 net28_9 0.000242345f
C3772 XB_0_6_1 net73 0.0139386f
C3773 XB_0_6_2 net24_7 0.000417044f
C3774 XB_0_6_2 net28 0.00015087f
C3775 XB_0_6_2 net73 0.00197006f
C3776 XB_0_6_3 net24_11 0.00129058f
C3777 XB_0_6_3 net24_6 0.000834088f
C3778 XB_0_6_3 net24_8 0.000834088f
C3779 XB_0_6_3 net28 0.00030174f
C3780 XB_0_6_3 net73 0.00394012f
C3781 XB_0_7 net28 0.00214256f
C3782 XB_0_7 net28_2 0.0018588f
C3783 XB_0_7 net28_3 0.00201775f
C3784 XB_0_7 net28_4 0.00203256f
C3785 XB_0_7 net28_5 0.000811768f
C3786 XB_0_7 net28_9 0.00195174f
C3787 XB_0_7 net74 0.00333726f
C3788 XB_0_7_1 net74 0.0139511f
C3789 XB_0_7_2 net28_7 0.000405884f
C3790 XB_0_7_2 net74 0.00197182f
C3791 XB_0_7_3 net28_11 0.00125604f
C3792 XB_0_7_3 net28_6 0.000811768f
C3793 XB_0_7_3 net28_8 0.000811768f
C3794 XB_0_7_3 net74 0.00394364f
C3795 XB_1_0 net133 0.00221706f
C3796 XB_1_0 net133_10 0.0020196f
C3797 XB_1_0 net133_2 0.00192343f
C3798 XB_1_0 net133_3 0.0020879f
C3799 XB_1_0 net133_4 0.00210323f
C3800 XB_1_0 net133_5 0.000839991f
C3801 XB_1_0 net134 0.000232869f
C3802 XB_1_0 net78 0.00321393f
C3803 XB_1_0_1 net134 0.00122994f
C3804 XB_1_0_1 net134_10 0.000233613f
C3805 XB_1_0_1 net134_2 0.000222489f
C3806 XB_1_0_1 net134_3 0.000241513f
C3807 XB_1_0_1 net134_4 0.000243287f
C3808 XB_1_0_1 net134_5 9.71641e-05f
C3809 XB_1_0_1 net134_6 9.71641e-05f
C3810 XB_1_0_1 net134_7 4.85821e-05f
C3811 XB_1_0_1 net134_8 9.71641e-05f
C3812 XB_1_0_1 net134_9 0.000150341f
C3813 XB_1_0_1 net78 0.0134355f
C3814 XB_1_0_2 net133_7 0.000419996f
C3815 XB_1_0_2 net134 0.000137591f
C3816 XB_1_0_2 net78 0.00189895f
C3817 XB_1_0_3 net133_6 0.000839991f
C3818 XB_1_0_3 net133_8 0.000839991f
C3819 XB_1_0_3 net133_9 0.00129971f
C3820 XB_1_0_3 net134 0.000275181f
C3821 XB_1_0_3 net78 0.0037979f
C3822 XB_1_1 net134 0.00219594f
C3823 XB_1_1 net134_10 0.00200037f
C3824 XB_1_1 net134_2 0.00190511f
C3825 XB_1_1 net134_3 0.00206802f
C3826 XB_1_1 net134_4 0.0020832f
C3827 XB_1_1 net134_5 0.000831992f
C3828 XB_1_1 net136 0.000239246f
C3829 XB_1_1 net81 0.00321604f
C3830 XB_1_1_1 net136 0.00125659f
C3831 XB_1_1_1 net136_10 0.000233613f
C3832 XB_1_1_1 net136_2 0.000222489f
C3833 XB_1_1_1 net136_3 0.000241513f
C3834 XB_1_1_1 net136_4 0.000243287f
C3835 XB_1_1_1 net136_5 9.71641e-05f
C3836 XB_1_1_1 net136_6 9.71641e-05f
C3837 XB_1_1_1 net136_7 4.85821e-05f
C3838 XB_1_1_1 net136_8 9.71641e-05f
C3839 XB_1_1_1 net136_9 0.000150341f
C3840 XB_1_1_1 net81 0.0134443f
C3841 XB_1_1_2 net134_7 0.000415996f
C3842 XB_1_1_2 net136 0.000141358f
C3843 XB_1_1_2 net81 0.0019002f
C3844 XB_1_1_3 net134_6 0.000831992f
C3845 XB_1_1_3 net134_8 0.000831992f
C3846 XB_1_1_3 net134_9 0.00128733f
C3847 XB_1_1_3 net136 0.000282716f
C3848 XB_1_1_3 net81 0.00380039f
C3849 XB_1_2 net136 0.00219594f
C3850 XB_1_2 net136_10 0.00200037f
C3851 XB_1_2 net136_2 0.00190511f
C3852 XB_1_2 net136_3 0.00206802f
C3853 XB_1_2 net136_4 0.0020832f
C3854 XB_1_2 net136_5 0.000831992f
C3855 XB_1_2 net137 0.000239246f
C3856 XB_1_2 net84 0.00321604f
C3857 XB_1_2_1 net137 0.00125659f
C3858 XB_1_2_1 net137_10 0.000233613f
C3859 XB_1_2_1 net137_2 0.000222489f
C3860 XB_1_2_1 net137_3 0.000241513f
C3861 XB_1_2_1 net137_4 0.000243287f
C3862 XB_1_2_1 net137_5 9.71641e-05f
C3863 XB_1_2_1 net137_6 9.71641e-05f
C3864 XB_1_2_1 net137_7 4.85821e-05f
C3865 XB_1_2_1 net137_8 9.71641e-05f
C3866 XB_1_2_1 net137_9 0.000150341f
C3867 XB_1_2_1 net84 0.0134443f
C3868 XB_1_2_2 net136_7 0.000415996f
C3869 XB_1_2_2 net137 0.000141358f
C3870 XB_1_2_2 net84 0.0019002f
C3871 XB_1_2_3 net136_6 0.000831992f
C3872 XB_1_2_3 net136_8 0.000831992f
C3873 XB_1_2_3 net136_9 0.00128733f
C3874 XB_1_2_3 net137 0.000282716f
C3875 XB_1_2_3 net84 0.00380039f
C3876 XB_1_3 net137 0.00219594f
C3877 XB_1_3 net137_10 0.00200037f
C3878 XB_1_3 net137_2 0.00190511f
C3879 XB_1_3 net137_3 0.00206802f
C3880 XB_1_3 net137_4 0.0020832f
C3881 XB_1_3 net137_5 0.000831992f
C3882 XB_1_3 net139 0.000239246f
C3883 XB_1_3 net87 0.00321604f
C3884 XB_1_3_1 net139 0.00125659f
C3885 XB_1_3_1 net139_10 0.000233613f
C3886 XB_1_3_1 net139_2 0.000222489f
C3887 XB_1_3_1 net139_3 0.000241513f
C3888 XB_1_3_1 net139_4 0.000243287f
C3889 XB_1_3_1 net139_5 9.71641e-05f
C3890 XB_1_3_1 net139_6 9.71641e-05f
C3891 XB_1_3_1 net139_7 4.85821e-05f
C3892 XB_1_3_1 net139_8 9.71641e-05f
C3893 XB_1_3_1 net139_9 0.000150341f
C3894 XB_1_3_1 net87 0.0134443f
C3895 XB_1_3_2 net137_7 0.000415996f
C3896 XB_1_3_2 net139 0.000141358f
C3897 XB_1_3_2 net87 0.0019002f
C3898 XB_1_3_3 net137_6 0.000831992f
C3899 XB_1_3_3 net137_8 0.000831992f
C3900 XB_1_3_3 net137_9 0.00128733f
C3901 XB_1_3_3 net139 0.000282716f
C3902 XB_1_3_3 net87 0.00380039f
C3903 XB_1_4 net139 0.00219594f
C3904 XB_1_4 net139_10 0.00200037f
C3905 XB_1_4 net139_2 0.00190511f
C3906 XB_1_4 net139_3 0.00206802f
C3907 XB_1_4 net139_4 0.0020832f
C3908 XB_1_4 net139_5 0.000831992f
C3909 XB_1_4 net141 0.000239246f
C3910 XB_1_4 net90 0.00321604f
C3911 XB_1_4_1 net141 0.00125659f
C3912 XB_1_4_1 net141_10 0.000233613f
C3913 XB_1_4_1 net141_2 0.000222489f
C3914 XB_1_4_1 net141_3 0.000241513f
C3915 XB_1_4_1 net141_4 0.000243287f
C3916 XB_1_4_1 net141_5 9.71641e-05f
C3917 XB_1_4_1 net141_6 9.71641e-05f
C3918 XB_1_4_1 net141_7 4.85821e-05f
C3919 XB_1_4_1 net141_8 9.71641e-05f
C3920 XB_1_4_1 net141_9 0.000150341f
C3921 XB_1_4_1 net90 0.0134443f
C3922 XB_1_4_2 net139_7 0.000415996f
C3923 XB_1_4_2 net141 0.000141358f
C3924 XB_1_4_2 net90 0.0019002f
C3925 XB_1_4_3 net139_6 0.000831992f
C3926 XB_1_4_3 net139_8 0.000831992f
C3927 XB_1_4_3 net139_9 0.00128733f
C3928 XB_1_4_3 net141 0.000282716f
C3929 XB_1_4_3 net90 0.00380039f
C3930 XB_1_5 net141 0.00219594f
C3931 XB_1_5 net141_10 0.00200037f
C3932 XB_1_5 net141_2 0.00190511f
C3933 XB_1_5 net141_3 0.00206802f
C3934 XB_1_5 net141_4 0.0020832f
C3935 XB_1_5 net141_5 0.000831992f
C3936 XB_1_5 net142 0.000239246f
C3937 XB_1_5 net93 0.00321604f
C3938 XB_1_5_1 net142 0.00125659f
C3939 XB_1_5_1 net142_10 0.000233613f
C3940 XB_1_5_1 net142_2 0.000222489f
C3941 XB_1_5_1 net142_3 0.000241513f
C3942 XB_1_5_1 net142_4 0.000243287f
C3943 XB_1_5_1 net142_5 9.71641e-05f
C3944 XB_1_5_1 net142_6 9.71641e-05f
C3945 XB_1_5_1 net142_7 4.85821e-05f
C3946 XB_1_5_1 net142_8 9.71641e-05f
C3947 XB_1_5_1 net142_9 0.000150341f
C3948 XB_1_5_1 net93 0.0134443f
C3949 XB_1_5_2 net141_7 0.000415996f
C3950 XB_1_5_2 net142 0.000141358f
C3951 XB_1_5_2 net93 0.0019002f
C3952 XB_1_5_3 net141_6 0.000831992f
C3953 XB_1_5_3 net141_8 0.000831992f
C3954 XB_1_5_3 net141_9 0.00128733f
C3955 XB_1_5_3 net142 0.000282716f
C3956 XB_1_5_3 net93 0.00380039f
C3957 XB_1_6 net142 0.00219594f
C3958 XB_1_6 net142_10 0.00200037f
C3959 XB_1_6 net142_2 0.00190511f
C3960 XB_1_6 net142_3 0.00206802f
C3961 XB_1_6 net142_4 0.0020832f
C3962 XB_1_6 net142_5 0.000831992f
C3963 XB_1_6 net144 0.000239246f
C3964 XB_1_6 net96 0.00321604f
C3965 XB_1_6_1 net144 0.00125269f
C3966 XB_1_6_1 net144_10 0.000230062f
C3967 XB_1_6_1 net144_2 0.000219107f
C3968 XB_1_6_1 net144_3 0.000237842f
C3969 XB_1_6_1 net144_4 0.000239588f
C3970 XB_1_6_1 net144_5 9.56872e-05f
C3971 XB_1_6_1 net144_6 9.56872e-05f
C3972 XB_1_6_1 net144_7 4.78436e-05f
C3973 XB_1_6_1 net144_8 9.56872e-05f
C3974 XB_1_6_1 net144_9 0.000148056f
C3975 XB_1_6_1 net96 0.0134443f
C3976 XB_1_6_2 net142_7 0.000415996f
C3977 XB_1_6_2 net144 0.000141358f
C3978 XB_1_6_2 net96 0.0019002f
C3979 XB_1_6_3 net142_6 0.000831992f
C3980 XB_1_6_3 net142_8 0.000831992f
C3981 XB_1_6_3 net142_9 0.00128733f
C3982 XB_1_6_3 net144 0.000282716f
C3983 XB_1_6_3 net96 0.00380039f
C3984 XB_1_7 net144 0.0021388f
C3985 XB_1_7 net144_10 0.00194832f
C3986 XB_1_7 net144_2 0.00185554f
C3987 XB_1_7 net144_3 0.0020142f
C3988 XB_1_7 net144_4 0.00202899f
C3989 XB_1_7 net144_5 0.000810343f
C3990 XB_1_7 net99 0.00322111f
C3991 XB_1_7_1 net99 0.0134655f
C3992 XB_1_7_2 net144_7 0.000405172f
C3993 XB_1_7_2 net99 0.00190319f
C3994 XB_1_7_3 net144_6 0.000810343f
C3995 XB_1_7_3 net144_8 0.000810343f
C3996 XB_1_7_3 net144_9 0.00125384f
C3997 XB_1_7_3 net99 0.00380639f
C3998 net10 net11_2 0.0126928f
C3999 net10 net11_3 0.0137781f
C4000 net10 net11_4 0.0138793f
C4001 net10_2 net11_7 0.00277156f
C4002 net10_2 net11_9 0.0133274f
C4003 net10_3 net11_11 0.00857682f
C4004 net10_3 net11_8 0.00554313f
C4005 net10_4 net11_5 0.00554313f
C4006 net10_6 net11_6 0.00554313f
C4007 net10_7 net11 0.0146304f
C4008 net11 net69 0.0034428f
C4009 net11_11 net69 0.00201828f
C4010 net11_2 net69 0.00298684f
C4011 net11_3 net69 0.00324223f
C4012 net11_4 net69 0.00326604f
C4013 net11_5 net69 0.0013044f
C4014 net11_6 net69 0.0013044f
C4015 net11_7 net69 0.000652198f
C4016 net11_8 net69 0.0013044f
C4017 net11_9 net69 0.00313618f
C4018 net13 net14_2 0.0126928f
C4019 net13 net14_3 0.0137781f
C4020 net13 net14_4 0.0138793f
C4021 net133 net76_7 0.0145736f
C4022 net133 net78 0.00337832f
C4023 net133_10 net76_2 0.0132756f
C4024 net133_10 net78 0.00307744f
C4025 net133_2 net76 0.0126434f
C4026 net133_2 net78 0.0029309f
C4027 net133_3 net76 0.0137245f
C4028 net133_3 net78 0.00318151f
C4029 net133_4 net76 0.0138253f
C4030 net133_4 net78 0.00320487f
C4031 net133_5 net76_5 0.00552158f
C4032 net133_5 net78 0.00127997f
C4033 net133_6 net76_4 0.00552158f
C4034 net133_6 net78 0.00127997f
C4035 net133_7 net76_2 0.00276079f
C4036 net133_7 net78 0.000639983f
C4037 net133_8 net76_3 0.00552158f
C4038 net133_8 net78 0.00127997f
C4039 net133_9 net76_3 0.00854349f
C4040 net133_9 net78 0.00198048f
C4041 net134 net79_7 0.014433f
C4042 net134 net81 0.00338159f
C4043 net134_10 net79_2 0.0131476f
C4044 net134_10 net81 0.00308042f
C4045 net134_2 net79 0.0125215f
C4046 net134_2 net81 0.00293374f
C4047 net134_3 net79 0.0135922f
C4048 net134_3 net81 0.00318459f
C4049 net134_4 net79 0.013692f
C4050 net134_4 net81 0.00320798f
C4051 net134_5 net79_5 0.00546832f
C4052 net134_5 net81 0.00128121f
C4053 net134_6 net79_4 0.00546832f
C4054 net134_6 net81 0.00128121f
C4055 net134_7 net79_2 0.00273416f
C4056 net134_7 net81 0.000640604f
C4057 net134_8 net79_3 0.00546832f
C4058 net134_8 net81 0.00128121f
C4059 net134_9 net79_3 0.00846108f
C4060 net134_9 net81 0.0019824f
C4061 net136 net82_7 0.014433f
C4062 net136 net84 0.00338159f
C4063 net136_10 net82_2 0.0131476f
C4064 net136_10 net84 0.00308042f
C4065 net136_2 net82 0.0125215f
C4066 net136_2 net84 0.00293374f
C4067 net136_3 net82 0.0135922f
C4068 net136_3 net84 0.00318459f
C4069 net136_4 net82 0.013692f
C4070 net136_4 net84 0.00320798f
C4071 net136_5 net82_5 0.00546832f
C4072 net136_5 net84 0.00128121f
C4073 net136_6 net82_4 0.00546832f
C4074 net136_6 net84 0.00128121f
C4075 net136_7 net82_2 0.00273416f
C4076 net136_7 net84 0.000640604f
C4077 net136_8 net82_3 0.00546832f
C4078 net136_8 net84 0.00128121f
C4079 net136_9 net82_3 0.00846108f
C4080 net136_9 net84 0.0019824f
C4081 net137 net85_7 0.014433f
C4082 net137 net87 0.00338159f
C4083 net137_10 net85_2 0.0131476f
C4084 net137_10 net87 0.00308042f
C4085 net137_2 net85 0.0125215f
C4086 net137_2 net87 0.00293374f
C4087 net137_3 net85 0.0135922f
C4088 net137_3 net87 0.00318459f
C4089 net137_4 net85 0.013692f
C4090 net137_4 net87 0.00320798f
C4091 net137_5 net85_5 0.00546832f
C4092 net137_5 net87 0.00128121f
C4093 net137_6 net85_4 0.00546832f
C4094 net137_6 net87 0.00128121f
C4095 net137_7 net85_2 0.00273416f
C4096 net137_7 net87 0.000640604f
C4097 net137_8 net85_3 0.00546832f
C4098 net137_8 net87 0.00128121f
C4099 net137_9 net85_3 0.00846108f
C4100 net137_9 net87 0.0019824f
C4101 net139 net88_7 0.014433f
C4102 net139 net90 0.00338159f
C4103 net139_10 net88_2 0.0131476f
C4104 net139_10 net90 0.00308042f
C4105 net139_2 net88 0.0125215f
C4106 net139_2 net90 0.00293374f
C4107 net139_3 net88 0.0135922f
C4108 net139_3 net90 0.00318459f
C4109 net139_4 net88 0.013692f
C4110 net139_4 net90 0.00320798f
C4111 net139_5 net88_5 0.00546832f
C4112 net139_5 net90 0.00128121f
C4113 net139_6 net88_4 0.00546832f
C4114 net139_6 net90 0.00128121f
C4115 net139_7 net88_2 0.00273416f
C4116 net139_7 net90 0.000640604f
C4117 net139_8 net88_3 0.00546832f
C4118 net139_8 net90 0.00128121f
C4119 net139_9 net88_3 0.00846108f
C4120 net139_9 net90 0.0019824f
C4121 net13_2 net14_7 0.00277156f
C4122 net13_2 net14_9 0.0133274f
C4123 net13_3 net14_11 0.00857682f
C4124 net13_3 net14_8 0.00554313f
C4125 net13_4 net14_5 0.00554313f
C4126 net13_6 net14_6 0.00554313f
C4127 net13_7 net14 0.0146304f
C4128 net14 net70 0.0034428f
C4129 net141 net91_7 0.014433f
C4130 net141 net93 0.00338159f
C4131 net141_10 net91_2 0.0131476f
C4132 net141_10 net93 0.00308042f
C4133 net141_2 net91 0.0125215f
C4134 net141_2 net93 0.00293374f
C4135 net141_3 net91 0.0135922f
C4136 net141_3 net93 0.00318459f
C4137 net141_4 net91 0.013692f
C4138 net141_4 net93 0.00320798f
C4139 net141_5 net91_5 0.00546832f
C4140 net141_5 net93 0.00128121f
C4141 net141_6 net91_4 0.00546832f
C4142 net141_6 net93 0.00128121f
C4143 net141_7 net91_2 0.00273416f
C4144 net141_7 net93 0.000640604f
C4145 net141_8 net91_3 0.00546832f
C4146 net141_8 net93 0.00128121f
C4147 net141_9 net91_3 0.00846108f
C4148 net141_9 net93 0.0019824f
C4149 net142 net94_7 0.014433f
C4150 net142 net96 0.00338159f
C4151 net142_10 net94_2 0.0131476f
C4152 net142_10 net96 0.00308042f
C4153 net142_2 net94 0.0125215f
C4154 net142_2 net96 0.00293374f
C4155 net142_3 net94 0.0135922f
C4156 net142_3 net96 0.00318459f
C4157 net142_4 net94 0.013692f
C4158 net142_4 net96 0.00320798f
C4159 net142_5 net94_5 0.00546832f
C4160 net142_5 net96 0.00128121f
C4161 net142_6 net94_4 0.00546832f
C4162 net142_6 net96 0.00128121f
C4163 net142_7 net94_2 0.00273416f
C4164 net142_7 net96 0.000640604f
C4165 net142_8 net94_3 0.00546832f
C4166 net142_8 net96 0.00128121f
C4167 net142_9 net94_3 0.00846108f
C4168 net142_9 net96 0.0019824f
C4169 net144 net97_7 0.0144115f
C4170 net144 net99 0.00337985f
C4171 net144_10 net97_2 0.013128f
C4172 net144_10 net99 0.00307883f
C4173 net144_2 net97 0.0125028f
C4174 net144_2 net99 0.00293222f
C4175 net144_3 net97 0.0135719f
C4176 net144_3 net99 0.00318295f
C4177 net144_4 net97 0.0136716f
C4178 net144_4 net99 0.00320632f
C4179 net144_5 net97_5 0.00546018f
C4180 net144_5 net99 0.00128055f
C4181 net144_6 net97_4 0.00546018f
C4182 net144_6 net99 0.00128055f
C4183 net144_7 net97_2 0.00273009f
C4184 net144_7 net99 0.000640273f
C4185 net144_8 net97_3 0.00546018f
C4186 net144_8 net99 0.00128055f
C4187 net144_9 net97_3 0.00844848f
C4188 net144_9 net99 0.00198137f
C4189 net14_11 net70 0.00201828f
C4190 net14_2 net70 0.00298684f
C4191 net14_3 net70 0.00324223f
C4192 net14_4 net70 0.00326604f
C4193 net14_5 net70 0.0013044f
C4194 net14_6 net70 0.0013044f
C4195 net14_7 net70 0.000652198f
C4196 net14_8 net70 0.0013044f
C4197 net14_9 net70 0.00313618f
C4198 net16 net17_2 0.0126928f
C4199 net16 net17_3 0.0137781f
C4200 net16 net17_4 0.0138793f
C4201 net16_2 net17_7 0.00277156f
C4202 net16_2 net17_9 0.0133274f
C4203 net16_3 net17_11 0.00857682f
C4204 net16_3 net17_8 0.00554313f
C4205 net16_4 net17_5 0.00554313f
C4206 net16_6 net17_6 0.00554313f
C4207 net16_7 net17 0.0146304f
C4208 net17 net71 0.0034428f
C4209 net17_11 net71 0.00201828f
C4210 net17_2 net71 0.00298684f
C4211 net17_3 net71 0.00324223f
C4212 net17_4 net71 0.00326604f
C4213 net17_5 net71 0.0013044f
C4214 net17_6 net71 0.0013044f
C4215 net17_7 net71 0.000652198f
C4216 net17_8 net71 0.0013044f
C4217 net17_9 net71 0.00313618f
C4218 net20 net21_2 0.0126928f
C4219 net20 net21_3 0.0137781f
C4220 net20 net21_4 0.0138793f
C4221 net20_2 net21_7 0.00277156f
C4222 net20_2 net21_9 0.0133274f
C4223 net20_3 net21_11 0.00857682f
C4224 net20_3 net21_8 0.00554313f
C4225 net20_4 net21_5 0.00554313f
C4226 net20_6 net21_6 0.00554313f
C4227 net20_7 net21 0.0146304f
C4228 net21 net72 0.0034428f
C4229 net21_11 net72 0.00201828f
C4230 net21_2 net72 0.00298684f
C4231 net21_3 net72 0.00324223f
C4232 net21_4 net72 0.00326604f
C4233 net21_5 net72 0.0013044f
C4234 net21_6 net72 0.0013044f
C4235 net21_7 net72 0.000652198f
C4236 net21_8 net72 0.0013044f
C4237 net21_9 net72 0.00313618f
C4238 net23 net24_2 0.0126928f
C4239 net23 net24_3 0.0137781f
C4240 net23 net24_4 0.0138793f
C4241 net23_2 net24_7 0.00277156f
C4242 net23_2 net24_9 0.0133274f
C4243 net23_3 net24_11 0.00857682f
C4244 net23_3 net24_8 0.00554313f
C4245 net23_4 net24_5 0.00554313f
C4246 net23_6 net24_6 0.00554313f
C4247 net23_7 net24 0.0146304f
C4248 net24 net73 0.0034428f
C4249 net24_11 net73 0.00201828f
C4250 net24_2 net73 0.00298684f
C4251 net24_3 net73 0.00324223f
C4252 net24_4 net73 0.00326604f
C4253 net24_5 net73 0.0013044f
C4254 net24_6 net73 0.0013044f
C4255 net24_7 net73 0.000652198f
C4256 net24_8 net73 0.0013044f
C4257 net24_9 net73 0.00313618f
C4258 net27 net28_2 0.0126656f
C4259 net27 net28_3 0.0137486f
C4260 net27 net28_4 0.0138495f
C4261 net27_2 net28_7 0.00276563f
C4262 net27_2 net28_9 0.0132989f
C4263 net27_3 net28_11 0.00855845f
C4264 net27_3 net28_8 0.00553125f
C4265 net27_4 net28_5 0.00553125f
C4266 net27_6 net28_6 0.00553125f
C4267 net27_7 net28 0.0145991f
C4268 net28 net74 0.00344217f
C4269 net28_11 net74 0.00201791f
C4270 net28_2 net74 0.00298629f
C4271 net28_3 net74 0.00324164f
C4272 net28_4 net74 0.00326544f
C4273 net28_5 net74 0.00130416f
C4274 net28_6 net74 0.00130416f
C4275 net28_7 net74 0.000652079f
C4276 net28_8 net74 0.00130416f
C4277 net28_9 net74 0.0031356f
C4278 net3 net4_2 0.0126918f
C4279 net3 net4_3 0.013777f
C4280 net3 net4_4 0.0138782f
C4281 net3_2 net4_7 0.00277135f
C4282 net3_2 net4_9 0.0133264f
C4283 net3_3 net4_11 0.00857616f
C4284 net3_3 net4_8 0.0055427f
C4285 net3_4 net4_5 0.0055427f
C4286 net3_6 net4_6 0.0055427f
C4287 net3_7 net4 0.0146293f
C4288 net4 net67 0.00345085f
C4289 net4_11 net67 0.002023f
C4290 net4_2 net67 0.00299382f
C4291 net4_3 net67 0.00324982f
C4292 net4_4 net67 0.00327368f
C4293 net4_5 net67 0.00130745f
C4294 net4_6 net67 0.00130745f
C4295 net4_7 net67 0.000653724f
C4296 net4_8 net67 0.00130745f
C4297 net4_9 net67 0.00314351f
C4298 net6 net7_2 0.0126928f
C4299 net6 net7_3 0.0137781f
C4300 net6 net7_4 0.0138793f
C4301 net68 net7 0.0034428f
C4302 net68 net7_11 0.00201828f
C4303 net68 net7_2 0.00298684f
C4304 net68 net7_3 0.00324223f
C4305 net68 net7_4 0.00326604f
C4306 net68 net7_5 0.0013044f
C4307 net68 net7_6 0.0013044f
C4308 net68 net7_7 0.000652198f
C4309 net68 net7_8 0.0013044f
C4310 net68 net7_9 0.00313618f
C4311 net6_2 net7_7 0.00277156f
C4312 net6_2 net7_9 0.0133274f
C4313 net6_3 net7_11 0.00857682f
C4314 net6_3 net7_8 0.00554313f
C4315 net6_4 net7_5 0.00554313f
C4316 net6_6 net7_6 0.00554313f
C4317 net6_7 net7 0.0146304f
.ends
