* A1x8 - parasitic extraction by OpenLayout (openlayout pex, mode rc)
* layout: /tmp/xs/a1x8.gds
* C: FasterCap 3D field solver (k = 4.6 front end, 3.23 above z = 0.074 um); R: KLayout RNetExtractor, reference sheet / via resistances
* 80 transistors, 223 resistors, 2078 capacitors
* total capacitance per net (fF): BLB_0 0.1204, BLB_1 0.1205, BLB_2 0.1205, BLB_3 0.1205, BLB_4 0.1205, BLB_5 0.1205, BLB_6 0.1205, BLB_7 0.1187, BL_0 0.0874, BL_1 0.0902, BL_2 0.0902, BL_3 0.0902, BL_4 0.0902, BL_5 0.0902, BL_6 0.0902, BL_7 0.0900, P_0_0 0.1915, P_0_1 0.1915, P_0_2 0.1915, P_0_3 0.1915, P_0_4 0.1915, P_0_5 0.1915, P_0_6 0.1915, P_0_7 0.1914, VDD_1 1.4653, VSS_0 3.9850, WL_0 2.6896, XB_0_0 0.1699, XB_0_1 0.1703, XB_0_2 0.1703, XB_0_3 0.1703, XB_0_4 0.1703, XB_0_5 0.1703, XB_0_6 0.1703, XB_0_7 0.1691, net12 0.2578, net13 0.4698, net16 0.2578, net17 0.4698, net19 0.2578, net20 0.4698, net23 0.2578, net24 0.4698, net26 0.2578, net27 0.4698, net30 0.2578, net31 0.4687, net4 0.2570, net5 0.4681, net68 0.0582, net69 0.0582, net70 0.0582, net71 0.0582, net72 0.0582, net73 0.0582, net74 0.0582, net75 0.0580, net8 0.2578, net9 0.4698

.subckt A1x8 BLB_0 BLB_1 BLB_2 BLB_3 BLB_4 BLB_5 BLB_6 BLB_7 BL_0 BL_1 BL_2 BL_3 BL_4 BL_5 BL_6 BL_7 P_0_0 P_0_1 P_0_2 P_0_3 P_0_4 P_0_5 P_0_6 P_0_7 VDD_1 VSS_0 WL_0 XB_0_0 XB_0_1 XB_0_2 XB_0_3 XB_0_4 XB_0_5 XB_0_6 XB_0_7
N1 net4_4 WL_0_16 BL_0_1 VSS_0 nmos_sram l=20n nfin=2
N2 VSS_0 net5_5 net4_4 VSS_0 nmos_sram l=20n nfin=2
N3 net5_9 net4_2 VSS_0 VSS_0 nmos_sram l=20n nfin=2
N4 BLB_0_1 WL_0_17 net5_9 VSS_0 nmos_sram l=20n nfin=2
N5 VSS_0 net5_7 P_0_0_3 VSS_0 nmos_sram l=20n nfin=1
N6 P_0_0_4 XB_0_0_2 VSS_0 VSS_0 nmos_sram l=20n nfin=1
N7 net8_4 WL_0_18 BL_1_1 VSS_0 nmos_sram l=20n nfin=2
N8 VSS_0 net9_5 net8_4 VSS_0 nmos_sram l=20n nfin=2
N9 net9_9 net8_2 VSS_0 VSS_0 nmos_sram l=20n nfin=2
N10 BLB_1_1 WL_0_19 net9_9 VSS_0 nmos_sram l=20n nfin=2
N11 VSS_0 net9_7 P_0_1_3 VSS_0 nmos_sram l=20n nfin=1
N12 P_0_1_4 XB_0_1_2 VSS_0 VSS_0 nmos_sram l=20n nfin=1
N13 net12_4 WL_0_20 BL_2_1 VSS_0 nmos_sram l=20n nfin=2
N14 VSS_0 net13_5 net12_4 VSS_0 nmos_sram l=20n nfin=2
N15 net13_9 net12_2 VSS_0 VSS_0 nmos_sram l=20n nfin=2
N16 BLB_2_1 WL_0_21 net13_9 VSS_0 nmos_sram l=20n nfin=2
N17 VSS_0 net13_7 P_0_2_3 VSS_0 nmos_sram l=20n nfin=1
N18 P_0_2_4 XB_0_2_2 VSS_0 VSS_0 nmos_sram l=20n nfin=1
N19 net16_4 WL_0_22 BL_3_1 VSS_0 nmos_sram l=20n nfin=2
N20 VSS_0 net17_5 net16_4 VSS_0 nmos_sram l=20n nfin=2
N21 net17_9 net16_2 VSS_0 VSS_0 nmos_sram l=20n nfin=2
N22 BLB_3_1 WL_0_23 net17_9 VSS_0 nmos_sram l=20n nfin=2
N23 VSS_0 net17_7 P_0_3_3 VSS_0 nmos_sram l=20n nfin=1
N24 P_0_3_4 XB_0_3_2 VSS_0 VSS_0 nmos_sram l=20n nfin=1
N25 net19_4 WL_0_24 BL_4_1 VSS_0 nmos_sram l=20n nfin=2
N26 VSS_0 net20_5 net19_4 VSS_0 nmos_sram l=20n nfin=2
N27 net20_9 net19_2 VSS_0 VSS_0 nmos_sram l=20n nfin=2
N28 BLB_4_1 WL_0_25 net20_9 VSS_0 nmos_sram l=20n nfin=2
N29 VSS_0 net20_7 P_0_4_3 VSS_0 nmos_sram l=20n nfin=1
N30 P_0_4_4 XB_0_4_2 VSS_0 VSS_0 nmos_sram l=20n nfin=1
N31 net23_4 WL_0_26 BL_5_1 VSS_0 nmos_sram l=20n nfin=2
N32 VSS_0 net24_5 net23_4 VSS_0 nmos_sram l=20n nfin=2
N33 net24_9 net23_2 VSS_0 VSS_0 nmos_sram l=20n nfin=2
N34 BLB_5_1 WL_0_27 net24_9 VSS_0 nmos_sram l=20n nfin=2
N35 VSS_0 net24_7 P_0_5_3 VSS_0 nmos_sram l=20n nfin=1
N36 P_0_5_4 XB_0_5_2 VSS_0 VSS_0 nmos_sram l=20n nfin=1
N37 net26_4 WL_0_28 BL_6_1 VSS_0 nmos_sram l=20n nfin=2
N38 VSS_0 net27_5 net26_4 VSS_0 nmos_sram l=20n nfin=2
N39 net27_9 net26_2 VSS_0 VSS_0 nmos_sram l=20n nfin=2
N40 BLB_6_1 WL_0_29 net27_9 VSS_0 nmos_sram l=20n nfin=2
N41 VSS_0 net27_7 P_0_6_3 VSS_0 nmos_sram l=20n nfin=1
N42 P_0_6_4 XB_0_6_2 VSS_0 VSS_0 nmos_sram l=20n nfin=1
N43 net30_4 WL_0_30 BL_7_1 VSS_0 nmos_sram l=20n nfin=2
N44 VSS_0 net31_5 net30_4 VSS_0 nmos_sram l=20n nfin=2
N45 net31_9 net30_2 VSS_0 VSS_0 nmos_sram l=20n nfin=2
N46 BLB_7_1 WL_0_31 net31_9 VSS_0 nmos_sram l=20n nfin=2
N47 VSS_0 net31_7 P_0_7_3 VSS_0 nmos_sram l=20n nfin=1
N48 P_0_7_4 XB_0_7_2 VSS_0 VSS_0 nmos_sram l=20n nfin=1
N49 VDD_1 net5_6 net4_6 VDD_1 pmos_sram l=20n nfin=1
N50 net5_11 net4_3 VDD_1 VDD_1 pmos_sram l=20n nfin=1
N51 net68 net5_8 P_0_0_5 VDD_1 pmos_sram l=20n nfin=2
N52 VDD_1 XB_0_0_3 net68 VDD_1 pmos_sram l=20n nfin=2
N53 VDD_1 net9_6 net8_6 VDD_1 pmos_sram l=20n nfin=1
N54 net9_11 net8_3 VDD_1 VDD_1 pmos_sram l=20n nfin=1
N55 net69 net9_8 P_0_1_5 VDD_1 pmos_sram l=20n nfin=2
N56 VDD_1 XB_0_1_3 net69 VDD_1 pmos_sram l=20n nfin=2
N57 VDD_1 net13_6 net12_6 VDD_1 pmos_sram l=20n nfin=1
N58 net13_11 net12_3 VDD_1 VDD_1 pmos_sram l=20n nfin=1
N59 net70 net13_8 P_0_2_5 VDD_1 pmos_sram l=20n nfin=2
N60 VDD_1 XB_0_2_3 net70 VDD_1 pmos_sram l=20n nfin=2
N61 VDD_1 net17_6 net16_6 VDD_1 pmos_sram l=20n nfin=1
N62 net17_11 net16_3 VDD_1 VDD_1 pmos_sram l=20n nfin=1
N63 net71 net17_8 P_0_3_5 VDD_1 pmos_sram l=20n nfin=2
N64 VDD_1 XB_0_3_3 net71 VDD_1 pmos_sram l=20n nfin=2
N65 VDD_1 net20_6 net19_6 VDD_1 pmos_sram l=20n nfin=1
N66 net20_11 net19_3 VDD_1 VDD_1 pmos_sram l=20n nfin=1
N67 net72 net20_8 P_0_4_5 VDD_1 pmos_sram l=20n nfin=2
N68 VDD_1 XB_0_4_3 net72 VDD_1 pmos_sram l=20n nfin=2
N69 VDD_1 net24_6 net23_6 VDD_1 pmos_sram l=20n nfin=1
N70 net24_11 net23_3 VDD_1 VDD_1 pmos_sram l=20n nfin=1
N71 net73 net24_8 P_0_5_5 VDD_1 pmos_sram l=20n nfin=2
N72 VDD_1 XB_0_5_3 net73 VDD_1 pmos_sram l=20n nfin=2
N73 VDD_1 net27_6 net26_6 VDD_1 pmos_sram l=20n nfin=1
N74 net27_11 net26_3 VDD_1 VDD_1 pmos_sram l=20n nfin=1
N75 net74 net27_8 P_0_6_5 VDD_1 pmos_sram l=20n nfin=2
N76 VDD_1 XB_0_6_3 net74 VDD_1 pmos_sram l=20n nfin=2
N77 VDD_1 net31_6 net30_6 VDD_1 pmos_sram l=20n nfin=1
N78 net31_11 net30_3 VDD_1 VDD_1 pmos_sram l=20n nfin=1
N79 net75 net31_8 P_0_7_5 VDD_1 pmos_sram l=20n nfin=2
N80 VDD_1 XB_0_7_3 net75 VDD_1 pmos_sram l=20n nfin=2
R1 BL_6 BL_6_1 68.2426
R2 BL_0 BL_0_1 68.2426
R3 net4_3 net4 34.1846
R4 net4 net4_2 25.5109
R5 net4_4 net4_7 39.8169
R6 net4_6 net4_7 43.642
R7 net4_7 net4 44.6984
R8 net5_6 net5 34.1846
R9 net5 net5_5 25.5109
R10 net5_8 net5_2 29.5926
R11 net5_2 net5_7 30.1028
R12 net5_4 net5_3 6.2952
R13 net5 net5_4 127.497
R14 net5_2 net5_3 90.749
R15 net5_9 net5_4 98.7906
R16 net5_3 net5_11 70.7246
R17 BLB_0_1 BLB_0 151.187
R18 BL_1 BL_1_1 68.2426
R19 net8_3 net8 34.1846
R20 net8 net8_2 25.5109
R21 net8_4 net8_7 39.8169
R22 net8_6 net8_7 43.642
R23 net8_7 net8 44.6984
R24 net9_6 net9 34.1846
R25 net9 net9_5 25.5109
R26 net9_8 net9_2 29.5926
R27 net9_2 net9_7 30.1028
R28 net9_4 net9_3 6.2952
R29 net9 net9_4 127.497
R30 net9_2 net9_3 90.749
R31 net9_9 net9_4 98.7906
R32 net9_3 net9_11 70.7246
R33 BLB_1_1 BLB_1 151.187
R34 BL_2 BL_2_1 68.2426
R35 net12_3 net12 34.1846
R36 net12 net12_2 25.5109
R37 net12_4 net12_7 39.8169
R38 net12_6 net12_7 43.642
R39 net12_7 net12 44.6984
R40 net13_6 net13 34.1846
R41 net13 net13_5 25.5109
R42 net13_8 net13_2 29.5926
R43 net13_2 net13_7 30.1028
R44 net13_4 net13_3 6.2952
R45 net13 net13_4 127.497
R46 net13_2 net13_3 90.749
R47 net13_9 net13_4 98.7906
R48 net13_3 net13_11 70.7246
R49 BLB_2_1 BLB_2 151.187
R50 BL_3 BL_3_1 68.2426
R51 net16_3 net16 34.1846
R52 net16 net16_2 25.5109
R53 net16_4 net16_7 39.8169
R54 net16_6 net16_7 43.642
R55 net16_7 net16 44.6984
R56 net17_6 net17 34.1846
R57 net17 net17_5 25.5109
R58 net17_8 net17_2 29.5926
R59 net17_2 net17_7 30.1028
R60 net17_4 net17_3 6.2952
R61 net17 net17_4 127.497
R62 net17_2 net17_3 90.749
R63 net17_9 net17_4 98.7906
R64 net17_3 net17_11 70.7246
R65 BLB_3_1 BLB_3 151.187
R66 net19_3 net19 34.1846
R67 net19 net19_2 25.5109
R68 net19_4 net19_7 39.8169
R69 net19_6 net19_7 43.642
R70 net19_7 net19 44.6984
R71 net20_6 net20 34.1846
R72 net20 net20_5 25.5109
R73 net20_8 net20_2 29.5926
R74 net20_2 net20_7 30.1028
R75 net20_4 net20_3 6.2952
R76 net20 net20_4 127.497
R77 net20_2 net20_3 90.749
R78 net20_9 net20_4 98.7906
R79 net20_3 net20_11 70.7246
R80 BLB_4_1 BLB_4 151.187
R81 BL_5 BL_5_1 68.2426
R82 net23_3 net23 34.1846
R83 net23 net23_2 25.5109
R84 net23_4 net23_7 39.8169
R85 net23_6 net23_7 43.642
R86 net23_7 net23 44.6984
R87 net24_6 net24 34.1846
R88 net24 net24_5 25.5109
R89 net24_8 net24_2 29.5926
R90 net24_2 net24_7 30.1028
R91 net24_4 net24_3 6.2952
R92 net24 net24_4 127.497
R93 net24_2 net24_3 90.749
R94 net24_9 net24_4 98.7906
R95 net24_3 net24_11 70.7246
R96 BLB_5_1 BLB_5 151.187
R97 net26_3 net26 34.1846
R98 net26 net26_2 25.5109
R99 net26_4 net26_7 39.8169
R100 net26_6 net26_7 43.642
R101 net26_7 net26 44.6984
R102 net27_6 net27 34.1846
R103 net27 net27_5 25.5109
R104 net27_8 net27_2 29.5926
R105 net27_2 net27_7 30.1028
R106 net27_4 net27_3 6.2952
R107 net27 net27_4 127.497
R108 net27_2 net27_3 90.749
R109 net27_9 net27_4 98.7906
R110 net27_3 net27_11 70.7246
R111 BLB_6_1 BLB_6 151.187
R112 BL_7 BL_7_1 68.2426
R113 net30_3 net30 34.1846
R114 net30 net30_2 25.5109
R115 net30_4 net30_7 39.8169
R116 net30_6 net30_7 43.642
R117 net30_7 net30 44.6984
R118 net31_6 net31 34.1846
R119 net31 net31_5 25.5109
R120 net31_8 net31_2 29.5926
R121 net31_2 net31_7 30.1028
R122 net31_4 net31_3 6.2952
R123 net31 net31_4 127.497
R124 net31_2 net31_3 90.749
R125 net31_9 net31_4 98.7906
R126 net31_3 net31_11 70.7246
R127 BLB_7_1 BLB_7 151.187
R128 P_0_0_1 P_0_0_2 27.5015
R129 P_0_0_1 P_0_0_3 20.424
R130 P_0_0_4 P_0_0_1 45.6048
R131 P_0_0_5 P_0_0_2 68.5329
R132 P_0_0 P_0_0_2 43.5
R133 XB_0_0_3 XB_0_0_1 36.7357
R134 XB_0_0_1 XB_0_0_2 22.9598
R135 XB_0_0 XB_0_0_1 109.677
R136 P_0_1_2 P_0_1_1 27.5015
R137 P_0_1_1 P_0_1_3 20.424
R138 P_0_1_4 P_0_1_1 45.6048
R139 P_0_1_5 P_0_1_2 68.5329
R140 P_0_1 P_0_1_2 43.5
R141 XB_0_1_3 XB_0_1_1 36.7357
R142 XB_0_1_1 XB_0_1_2 22.9598
R143 XB_0_1 XB_0_1_1 109.677
R144 P_0_2_1 P_0_2_2 27.5015
R145 P_0_2_1 P_0_2_3 20.424
R146 P_0_2_4 P_0_2_1 45.6048
R147 P_0_2_5 P_0_2_2 68.5329
R148 P_0_2 P_0_2_2 43.5
R149 XB_0_2_3 XB_0_2_1 36.7357
R150 XB_0_2_1 XB_0_2_2 22.9598
R151 XB_0_2 XB_0_2_1 109.677
R152 P_0_3_1 P_0_3_2 27.5015
R153 P_0_3_1 P_0_3_3 20.424
R154 P_0_3_4 P_0_3_1 45.6048
R155 P_0_3_5 P_0_3_2 68.5329
R156 P_0_3 P_0_3_2 43.5
R157 XB_0_3_3 XB_0_3_1 36.7357
R158 XB_0_3_1 XB_0_3_2 22.9598
R159 XB_0_3 XB_0_3_1 109.677
R160 BL_4 BL_4_1 68.2426
R161 P_0_4_1 P_0_4_2 27.5015
R162 P_0_4_1 P_0_4_3 20.424
R163 P_0_4_4 P_0_4_1 45.6048
R164 P_0_4_5 P_0_4_2 68.5329
R165 P_0_4 P_0_4_2 43.5
R166 XB_0_4_3 XB_0_4_1 36.7357
R167 XB_0_4_1 XB_0_4_2 22.9598
R168 XB_0_4 XB_0_4_1 109.677
R169 P_0_5_1 P_0_5_2 27.5015
R170 P_0_5_1 P_0_5_3 20.424
R171 P_0_5_4 P_0_5_1 45.6048
R172 P_0_5_5 P_0_5_2 68.5329
R173 P_0_5 P_0_5_2 43.5
R174 XB_0_5_3 XB_0_5_1 36.7357
R175 XB_0_5_1 XB_0_5_2 22.9598
R176 XB_0_5 XB_0_5_1 109.677
R177 P_0_6_1 P_0_6_2 27.5015
R178 P_0_6_1 P_0_6_3 20.424
R179 P_0_6_4 P_0_6_1 45.6048
R180 P_0_6_5 P_0_6_2 68.5329
R181 P_0_6 P_0_6_2 43.5
R182 XB_0_6_3 XB_0_6_1 36.7357
R183 XB_0_6_1 XB_0_6_2 22.9598
R184 XB_0_6 XB_0_6_1 109.677
R185 P_0_7_1 P_0_7_2 27.5015
R186 P_0_7_1 P_0_7_3 20.424
R187 P_0_7_4 P_0_7_1 45.6048
R188 P_0_7_5 P_0_7_2 68.5329
R189 P_0_7 P_0_7_2 43.5
R190 XB_0_7_3 XB_0_7_1 36.7357
R191 XB_0_7_1 XB_0_7_2 22.9598
R192 XB_0_7 XB_0_7_1 109.677
R193 WL_0 WL_0_9 35.4396
R194 WL_0_9 WL_0_10 125.904
R195 WL_0_10 WL_0_11 125.904
R196 WL_0_11 WL_0_12 125.904
R197 WL_0_12 WL_0_13 125.904
R198 WL_0_13 WL_0_14 125.904
R199 WL_0_14 WL_0_15 125.904
R200 WL_0_1 WL_0_9 38.915
R201 WL_0_2 WL_0_10 38.915
R202 WL_0_3 WL_0_11 38.915
R203 WL_0_4 WL_0_12 38.915
R204 WL_0_5 WL_0_13 38.915
R205 WL_0_6 WL_0_14 38.915
R206 WL_0_7 WL_0_15 38.915
R207 WL_0_16 WL_0_1 83.7722
R208 WL_0_17 WL_0_1 84.6073
R209 WL_0_18 WL_0_2 83.7722
R210 WL_0_19 WL_0_2 84.6073
R211 WL_0_20 WL_0_3 83.7722
R212 WL_0_21 WL_0_3 84.6073
R213 WL_0_22 WL_0_4 83.7722
R214 WL_0_23 WL_0_4 84.6073
R215 WL_0_24 WL_0_5 83.7722
R216 WL_0_25 WL_0_5 84.6073
R217 WL_0_26 WL_0_6 83.7722
R218 WL_0_27 WL_0_6 84.6073
R219 WL_0_28 WL_0_7 83.7722
R220 WL_0_29 WL_0_7 84.6073
R221 WL_0_30 WL_0_8 83.7722
R222 WL_0_31 WL_0_8 84.6073
R223 WL_0_15 WL_0_8 164.819
C1 BLB_0 BL_0 0.000168461f
C2 BLB_0 BL_1 0.00320678f
C3 BLB_0 BL_1_1 0.00131137f
C4 BLB_0 P_0_0_4 0.00157189f
C5 BLB_0 P_0_0_5 0.00308721f
C6 BLB_0 VDD_1 0.00109027f
C7 BLB_0 VSS_0 0.0192101f
C8 BLB_0 WL_0_10 0.000135318f
C9 BLB_0 WL_0_18 6.22106e-05f
C10 BLB_0 WL_0_19 6.22106e-05f
C11 BLB_0 WL_0_2 8.16996e-05f
C12 BLB_0 XB_0_0 0.00218067f
C13 BLB_0 XB_0_0_1 0.00911604f
C14 BLB_0 XB_0_0_2 0.00128845f
C15 BLB_0 XB_0_0_3 0.00257689f
C16 BLB_0 net5_2 0.00137356f
C17 BLB_0 net5_8 0.000599854f
C18 BLB_0 net9 0.00018079f
C19 BLB_0 net9_11 3.94704e-05f
C20 BLB_0 net9_2 5.8412e-05f
C21 BLB_0 net9_3 6.34067e-05f
C22 BLB_0 net9_4 6.38723e-05f
C23 BLB_0 net9_5 2.55094e-05f
C24 BLB_0 net9_6 2.55094e-05f
C25 BLB_0 net9_7 1.27547e-05f
C26 BLB_0 net9_8 2.55094e-05f
C27 BLB_0 net9_9 6.13326e-05f
C28 BLB_0_1 BL_0 0.000206038f
C29 BLB_0_1 BL_0_1 0.000348594f
C30 BLB_0_1 BL_1 0.00167652f
C31 BLB_0_1 P_0_0 0.00180352f
C32 BLB_0_1 P_0_0_1 0.00386343f
C33 BLB_0_1 P_0_0_2 0.00702844f
C34 BLB_0_1 P_0_0_3 0.000779759f
C35 BLB_0_1 VDD_1 0.000924124f
C36 BLB_0_1 VSS_0 0.0212387f
C37 BLB_0_1 WL_0 0.0025972f
C38 BLB_0_1 WL_0_1 0.0062335f
C39 BLB_0_1 WL_0_16 0.0051679f
C40 BLB_0_1 WL_0_17 0.0051679f
C41 BLB_0_1 WL_0_9 0.00715337f
C42 BLB_0_1 net5 0.00158324f
C43 BLB_0_1 net5_11 0.000928149f
C44 BLB_0_1 net5_3 0.00149101f
C45 BLB_0_1 net5_4 0.00150196f
C46 BLB_0_1 net5_5 0.000599854f
C47 BLB_0_1 net5_6 0.000599854f
C48 BLB_0_1 net5_7 0.000299927f
C49 BLB_0_1 net5_9 0.00144224f
C50 BLB_0_1 net9 0.00013122f
C51 BLB_1 BL_1 0.000150446f
C52 BLB_1 BL_2 0.00320788f
C53 BLB_1 BL_2_1 0.00131137f
C54 BLB_1 P_0_1_4 0.00157215f
C55 BLB_1 P_0_1_5 0.00308771f
C56 BLB_1 VDD_1 0.00109339f
C57 BLB_1 VSS_0 0.019244f
C58 BLB_1 WL_0_11 0.000127614f
C59 BLB_1 WL_0_20 6.45358e-05f
C60 BLB_1 WL_0_21 6.45358e-05f
C61 BLB_1 WL_0_3 8.47532e-05f
C62 BLB_1 XB_0_1 0.00219358f
C63 BLB_1 XB_0_1_1 0.00917f
C64 BLB_1 XB_0_1_2 0.00129607f
C65 BLB_1 XB_0_1_3 0.00259215f
C66 BLB_1 net13 0.0001779f
C67 BLB_1 net13_11 3.94704e-05f
C68 BLB_1 net13_2 5.8412e-05f
C69 BLB_1 net13_3 6.34067e-05f
C70 BLB_1 net13_4 6.38723e-05f
C71 BLB_1 net13_5 2.55094e-05f
C72 BLB_1 net13_6 2.55094e-05f
C73 BLB_1 net13_7 1.27547e-05f
C74 BLB_1 net13_8 2.55094e-05f
C75 BLB_1 net13_9 6.13326e-05f
C76 BLB_1 net9_2 0.00134391f
C77 BLB_1 net9_8 0.000586904f
C78 BLB_1_1 BL_1 0.000187899f
C79 BLB_1_1 BL_1_1 0.000314222f
C80 BLB_1_1 BL_2 0.00167778f
C81 BLB_1_1 P_0_1 0.00180382f
C82 BLB_1_1 P_0_1_1 0.00386406f
C83 BLB_1_1 P_0_1_2 0.00702958f
C84 BLB_1_1 P_0_1_3 0.000779885f
C85 BLB_1_1 VDD_1 0.000927735f
C86 BLB_1_1 VSS_0 0.0212779f
C87 BLB_1_1 WL_0_10 0.0105007f
C88 BLB_1_1 WL_0_18 0.00482755f
C89 BLB_1_1 WL_0_19 0.00482755f
C90 BLB_1_1 WL_0_2 0.0063399f
C91 BLB_1_1 net13 0.000127879f
C92 BLB_1_1 net9 0.00154906f
C93 BLB_1_1 net9_11 0.000908111f
C94 BLB_1_1 net9_3 0.00145882f
C95 BLB_1_1 net9_4 0.00146953f
C96 BLB_1_1 net9_5 0.000586904f
C97 BLB_1_1 net9_6 0.000586904f
C98 BLB_1_1 net9_7 0.000293452f
C99 BLB_1_1 net9_9 0.0014111f
C100 BLB_2 BL_2 0.000150446f
C101 BLB_2 BL_3 0.00320788f
C102 BLB_2 BL_3_1 0.00131137f
C103 BLB_2 P_0_2_4 0.00157215f
C104 BLB_2 P_0_2_5 0.00308771f
C105 BLB_2 VDD_1 0.00109339f
C106 BLB_2 VSS_0 0.019244f
C107 BLB_2 WL_0_12 0.000135318f
C108 BLB_2 WL_0_22 6.22106e-05f
C109 BLB_2 WL_0_23 6.22106e-05f
C110 BLB_2 WL_0_4 8.16996e-05f
C111 BLB_2 XB_0_2 0.00219358f
C112 BLB_2 XB_0_2_1 0.00917f
C113 BLB_2 XB_0_2_2 0.00129607f
C114 BLB_2 XB_0_2_3 0.00259215f
C115 BLB_2 net13_2 0.00134391f
C116 BLB_2 net13_8 0.000586904f
C117 BLB_2 net17 0.0001779f
C118 BLB_2 net17_11 3.94704e-05f
C119 BLB_2 net17_2 5.8412e-05f
C120 BLB_2 net17_3 6.34067e-05f
C121 BLB_2 net17_4 6.38723e-05f
C122 BLB_2 net17_5 2.55094e-05f
C123 BLB_2 net17_6 2.55094e-05f
C124 BLB_2 net17_7 1.27547e-05f
C125 BLB_2 net17_8 2.55094e-05f
C126 BLB_2 net17_9 6.13326e-05f
C127 BLB_2_1 BL_2 0.000187899f
C128 BLB_2_1 BL_2_1 0.000314222f
C129 BLB_2_1 BL_3 0.00167778f
C130 BLB_2_1 P_0_2 0.00180382f
C131 BLB_2_1 P_0_2_1 0.00386406f
C132 BLB_2_1 P_0_2_2 0.00702958f
C133 BLB_2_1 P_0_2_3 0.000779885f
C134 BLB_2_1 VDD_1 0.000927735f
C135 BLB_2_1 VSS_0 0.0212779f
C136 BLB_2_1 WL_0_11 0.00990287f
C137 BLB_2_1 WL_0_20 0.00500798f
C138 BLB_2_1 WL_0_21 0.00500798f
C139 BLB_2_1 WL_0_3 0.00657685f
C140 BLB_2_1 net13 0.00154906f
C141 BLB_2_1 net13_11 0.000908111f
C142 BLB_2_1 net13_3 0.00145882f
C143 BLB_2_1 net13_4 0.00146953f
C144 BLB_2_1 net13_5 0.000586904f
C145 BLB_2_1 net13_6 0.000586904f
C146 BLB_2_1 net13_7 0.000293452f
C147 BLB_2_1 net13_9 0.0014111f
C148 BLB_2_1 net17 0.000127879f
C149 BLB_3 BL_3 0.000150446f
C150 BLB_3 BL_4 0.00320788f
C151 BLB_3 BL_4_1 0.00131137f
C152 BLB_3 P_0_3_4 0.00157215f
C153 BLB_3 P_0_3_5 0.00308771f
C154 BLB_3 VDD_1 0.00109339f
C155 BLB_3 VSS_0 0.019244f
C156 BLB_3 WL_0_13 0.000135318f
C157 BLB_3 WL_0_24 6.22106e-05f
C158 BLB_3 WL_0_25 6.22106e-05f
C159 BLB_3 WL_0_5 8.16996e-05f
C160 BLB_3 XB_0_3 0.00219358f
C161 BLB_3 XB_0_3_1 0.00917f
C162 BLB_3 XB_0_3_2 0.00129607f
C163 BLB_3 XB_0_3_3 0.00259215f
C164 BLB_3 net17_2 0.00134391f
C165 BLB_3 net17_8 0.000586904f
C166 BLB_3 net20 0.0001779f
C167 BLB_3 net20_11 3.94704e-05f
C168 BLB_3 net20_2 5.8412e-05f
C169 BLB_3 net20_3 6.34067e-05f
C170 BLB_3 net20_4 6.38723e-05f
C171 BLB_3 net20_5 2.55094e-05f
C172 BLB_3 net20_6 2.55094e-05f
C173 BLB_3 net20_7 1.27547e-05f
C174 BLB_3 net20_8 2.55094e-05f
C175 BLB_3 net20_9 6.13326e-05f
C176 BLB_3_1 BL_3 0.000187899f
C177 BLB_3_1 BL_3_1 0.000314222f
C178 BLB_3_1 BL_4 0.00167778f
C179 BLB_3_1 P_0_3 0.00180382f
C180 BLB_3_1 P_0_3_1 0.00386406f
C181 BLB_3_1 P_0_3_2 0.00702958f
C182 BLB_3_1 P_0_3_3 0.000779885f
C183 BLB_3_1 VDD_1 0.000927735f
C184 BLB_3_1 VSS_0 0.0212779f
C185 BLB_3_1 WL_0_12 0.0105007f
C186 BLB_3_1 WL_0_22 0.00482755f
C187 BLB_3_1 WL_0_23 0.00482755f
C188 BLB_3_1 WL_0_4 0.0063399f
C189 BLB_3_1 net17 0.00154906f
C190 BLB_3_1 net17_11 0.000908111f
C191 BLB_3_1 net17_3 0.00145882f
C192 BLB_3_1 net17_4 0.00146953f
C193 BLB_3_1 net17_5 0.000586904f
C194 BLB_3_1 net17_6 0.000586904f
C195 BLB_3_1 net17_7 0.000293452f
C196 BLB_3_1 net17_9 0.0014111f
C197 BLB_3_1 net20 0.000127879f
C198 BLB_4 BL_4 0.000150446f
C199 BLB_4 BL_5 0.00320788f
C200 BLB_4 BL_5_1 0.00131137f
C201 BLB_4 P_0_4_4 0.00157215f
C202 BLB_4 P_0_4_5 0.00308771f
C203 BLB_4 VDD_1 0.00109339f
C204 BLB_4 VSS_0 0.019244f
C205 BLB_4 WL_0_14 0.000135318f
C206 BLB_4 WL_0_26 6.22106e-05f
C207 BLB_4 WL_0_27 6.22106e-05f
C208 BLB_4 WL_0_6 8.16996e-05f
C209 BLB_4 XB_0_4 0.00219358f
C210 BLB_4 XB_0_4_1 0.00917f
C211 BLB_4 XB_0_4_2 0.00129607f
C212 BLB_4 XB_0_4_3 0.00259215f
C213 BLB_4 net20_2 0.00134391f
C214 BLB_4 net20_8 0.000586904f
C215 BLB_4 net24 0.0001779f
C216 BLB_4 net24_11 3.94704e-05f
C217 BLB_4 net24_2 5.8412e-05f
C218 BLB_4 net24_3 6.34067e-05f
C219 BLB_4 net24_4 6.38723e-05f
C220 BLB_4 net24_5 2.55094e-05f
C221 BLB_4 net24_6 2.55094e-05f
C222 BLB_4 net24_7 1.27547e-05f
C223 BLB_4 net24_8 2.55094e-05f
C224 BLB_4 net24_9 6.13326e-05f
C225 BLB_4_1 BL_4 0.000187899f
C226 BLB_4_1 BL_4_1 0.000314222f
C227 BLB_4_1 BL_5 0.00167778f
C228 BLB_4_1 P_0_4 0.00180382f
C229 BLB_4_1 P_0_4_1 0.00386406f
C230 BLB_4_1 P_0_4_2 0.00702958f
C231 BLB_4_1 P_0_4_3 0.000779885f
C232 BLB_4_1 VDD_1 0.000927735f
C233 BLB_4_1 VSS_0 0.0212779f
C234 BLB_4_1 WL_0_13 0.0105007f
C235 BLB_4_1 WL_0_24 0.00482755f
C236 BLB_4_1 WL_0_25 0.00482755f
C237 BLB_4_1 WL_0_5 0.0063399f
C238 BLB_4_1 net20 0.00154906f
C239 BLB_4_1 net20_11 0.000908111f
C240 BLB_4_1 net20_3 0.00145882f
C241 BLB_4_1 net20_4 0.00146953f
C242 BLB_4_1 net20_5 0.000586904f
C243 BLB_4_1 net20_6 0.000586904f
C244 BLB_4_1 net20_7 0.000293452f
C245 BLB_4_1 net20_9 0.0014111f
C246 BLB_4_1 net24 0.000127879f
C247 BLB_5 BL_5 0.000150446f
C248 BLB_5 BL_6 0.00320788f
C249 BLB_5 BL_6_1 0.00131137f
C250 BLB_5 P_0_5_4 0.00157215f
C251 BLB_5 P_0_5_5 0.00308771f
C252 BLB_5 VDD_1 0.00109339f
C253 BLB_5 VSS_0 0.019244f
C254 BLB_5 WL_0_15 0.000201065f
C255 BLB_5 WL_0_28 4.2367e-05f
C256 BLB_5 WL_0_29 4.2367e-05f
C257 BLB_5 WL_0_7 5.56395e-05f
C258 BLB_5 XB_0_5 0.00219358f
C259 BLB_5 XB_0_5_1 0.00917f
C260 BLB_5 XB_0_5_2 0.00129607f
C261 BLB_5 XB_0_5_3 0.00259215f
C262 BLB_5 net24_2 0.00134391f
C263 BLB_5 net24_8 0.000586904f
C264 BLB_5 net27 0.0001779f
C265 BLB_5 net27_11 3.94704e-05f
C266 BLB_5 net27_2 5.8412e-05f
C267 BLB_5 net27_3 6.34067e-05f
C268 BLB_5 net27_4 6.38723e-05f
C269 BLB_5 net27_5 2.55094e-05f
C270 BLB_5 net27_6 2.55094e-05f
C271 BLB_5 net27_7 1.27547e-05f
C272 BLB_5 net27_8 2.55094e-05f
C273 BLB_5 net27_9 6.13326e-05f
C274 BLB_5_1 BL_5 0.000187899f
C275 BLB_5_1 BL_5_1 0.000314222f
C276 BLB_5_1 BL_6 0.00167778f
C277 BLB_5_1 P_0_5 0.00180382f
C278 BLB_5_1 P_0_5_1 0.00386406f
C279 BLB_5_1 P_0_5_2 0.00702958f
C280 BLB_5_1 P_0_5_3 0.000779885f
C281 BLB_5_1 VDD_1 0.000927735f
C282 BLB_5_1 VSS_0 0.0212779f
C283 BLB_5_1 WL_0_14 0.0105007f
C284 BLB_5_1 WL_0_26 0.00482755f
C285 BLB_5_1 WL_0_27 0.00482755f
C286 BLB_5_1 WL_0_6 0.0063399f
C287 BLB_5_1 net24 0.00154906f
C288 BLB_5_1 net24_11 0.000908111f
C289 BLB_5_1 net24_3 0.00145882f
C290 BLB_5_1 net24_4 0.00146953f
C291 BLB_5_1 net24_5 0.000586904f
C292 BLB_5_1 net24_6 0.000586904f
C293 BLB_5_1 net24_7 0.000293452f
C294 BLB_5_1 net24_9 0.0014111f
C295 BLB_5_1 net27 0.000127879f
C296 BLB_6 BL_6 0.000150446f
C297 BLB_6 BL_7 0.00321111f
C298 BLB_6 BL_7_1 0.00131378f
C299 BLB_6 P_0_6_4 0.00157215f
C300 BLB_6 P_0_6_5 0.00308771f
C301 BLB_6 VDD_1 0.0011049f
C302 BLB_6 VSS_0 0.0192823f
C303 BLB_6 WL_0_30 0.000104571f
C304 BLB_6 WL_0_31 0.000104571f
C305 BLB_6 WL_0_8 0.00013733f
C306 BLB_6 XB_0_6 0.00219358f
C307 BLB_6 XB_0_6_1 0.00917f
C308 BLB_6 XB_0_6_2 0.00129607f
C309 BLB_6 XB_0_6_3 0.00259215f
C310 BLB_6 net27_2 0.00134391f
C311 BLB_6 net27_8 0.000586904f
C312 BLB_6 net31 0.000177025f
C313 BLB_6 net31_11 3.8957e-05f
C314 BLB_6 net31_2 5.76522e-05f
C315 BLB_6 net31_3 6.25819e-05f
C316 BLB_6 net31_4 6.30414e-05f
C317 BLB_6 net31_5 2.51776e-05f
C318 BLB_6 net31_6 2.51776e-05f
C319 BLB_6 net31_7 1.25888e-05f
C320 BLB_6 net31_8 2.51776e-05f
C321 BLB_6 net31_9 6.05348e-05f
C322 BLB_6_1 BL_6 0.000187899f
C323 BLB_6_1 BL_6_1 0.000314222f
C324 BLB_6_1 BL_7 0.00167778f
C325 BLB_6_1 P_0_6 0.00180382f
C326 BLB_6_1 P_0_6_1 0.00386406f
C327 BLB_6_1 P_0_6_2 0.00702958f
C328 BLB_6_1 P_0_6_3 0.000779885f
C329 BLB_6_1 VDD_1 0.000927735f
C330 BLB_6_1 VSS_0 0.0212231f
C331 BLB_6_1 WL_0_15 0.0156027f
C332 BLB_6_1 WL_0_28 0.00328768f
C333 BLB_6_1 WL_0_29 0.00328768f
C334 BLB_6_1 WL_0_7 0.00431763f
C335 BLB_6_1 net27 0.00154906f
C336 BLB_6_1 net27_11 0.000908111f
C337 BLB_6_1 net27_3 0.00145882f
C338 BLB_6_1 net27_4 0.00146953f
C339 BLB_6_1 net27_5 0.000586904f
C340 BLB_6_1 net27_6 0.000586904f
C341 BLB_6_1 net27_7 0.000293452f
C342 BLB_6_1 net27_9 0.0014111f
C343 BLB_6_1 net31 0.000127879f
C344 BLB_7 BL_7 0.000162133f
C345 BLB_7 P_0_7_4 0.00158282f
C346 BLB_7 P_0_7_5 0.00310867f
C347 BLB_7 VDD_1 0.000940684f
C348 BLB_7 VSS_0 0.0207171f
C349 BLB_7 XB_0_7 0.00229483f
C350 BLB_7 XB_0_7_1 0.00959331f
C351 BLB_7 XB_0_7_2 0.0013559f
C352 BLB_7 XB_0_7_3 0.0027118f
C353 BLB_7 net31_2 0.00137345f
C354 BLB_7 net31_8 0.000599805f
C355 BLB_7_1 BL_7 0.000201152f
C356 BLB_7_1 BL_7_1 0.00033763f
C357 BLB_7_1 P_0_7 0.00181606f
C358 BLB_7_1 P_0_7_1 0.00389028f
C359 BLB_7_1 P_0_7_2 0.00707729f
C360 BLB_7_1 P_0_7_3 0.000785179f
C361 BLB_7_1 VDD_1 0.00108792f
C362 BLB_7_1 VSS_0 0.0239598f
C363 BLB_7_1 WL_0_30 0.00804783f
C364 BLB_7_1 WL_0_31 0.00804783f
C365 BLB_7_1 WL_0_8 0.010569f
C366 BLB_7_1 net31 0.00158311f
C367 BLB_7_1 net31_11 0.000928073f
C368 BLB_7_1 net31_3 0.00149089f
C369 BLB_7_1 net31_4 0.00150184f
C370 BLB_7_1 net31_5 0.000599805f
C371 BLB_7_1 net31_6 0.000599805f
C372 BLB_7_1 net31_7 0.000299903f
C373 BLB_7_1 net31_9 0.00144212f
C374 BL_0 VDD_1 0.00115774f
C375 BL_0 VSS_0 0.0239133f
C376 BL_0 WL_0 0.00261583f
C377 BL_0 WL_0_1 0.00627821f
C378 BL_0 WL_0_9 0.00720468f
C379 BL_0 net4 0.000553856f
C380 BL_0 net4_3 0.000721449f
C381 BL_0 net4_6 0.000522532f
C382 BL_0 net4_7 0.00186747f
C383 BL_0 net5 0.00164054f
C384 BL_0 net5_11 0.000961735f
C385 BL_0 net5_2 0.00142326f
C386 BL_0 net5_3 0.00154496f
C387 BL_0 net5_4 0.00155631f
C388 BL_0 net5_6 0.000621561f
C389 BL_0 net5_8 0.000621561f
C390 BL_0_1 VDD_1 0.000864019f
C391 BL_0_1 VSS_0 0.0178464f
C392 BL_0_1 WL_0_16 0.00520497f
C393 BL_0_1 WL_0_17 0.00520497f
C394 BL_0_1 net4_2 0.000721449f
C395 BL_0_1 net4_4 0.00122822f
C396 BL_0_1 net5_5 0.000621561f
C397 BL_0_1 net5_7 0.00031078f
C398 BL_0_1 net5_9 0.00149443f
C399 BL_1 P_0_0 3.64517e-05f
C400 BL_1 P_0_0_1 7.80852e-05f
C401 BL_1 P_0_0_2 0.000142054f
C402 BL_1 P_0_0_3 1.576e-05f
C403 BL_1 P_0_0_4 0.000232135f
C404 BL_1 P_0_0_5 6.23967e-05f
C405 BL_1 VDD_1 0.00131782f
C406 BL_1 VSS_0 0.0214508f
C407 BL_1 WL_0 4.86067e-05f
C408 BL_1 WL_0_1 0.00011666f
C409 BL_1 WL_0_10 0.010376f
C410 BL_1 WL_0_16 9.67175e-05f
C411 BL_1 WL_0_17 9.67175e-05f
C412 BL_1 WL_0_2 0.00626458f
C413 BL_1 WL_0_9 0.000133876f
C414 BL_1 XB_0_0 0.000165383f
C415 BL_1 XB_0_0_1 0.00133208f
C416 BL_1 XB_0_0_2 9.77162e-05f
C417 BL_1 XB_0_0_3 0.000195432f
C418 BL_1 net8 0.000528329f
C419 BL_1 net8_3 0.000688198f
C420 BL_1 net8_6 0.000498449f
C421 BL_1 net8_7 0.0017814f
C422 BL_1 net9 0.00150534f
C423 BL_1 net9_11 0.000882478f
C424 BL_1 net9_2 0.00130597f
C425 BL_1 net9_3 0.00141764f
C426 BL_1 net9_4 0.00142805f
C427 BL_1 net9_6 0.000570338f
C428 BL_1 net9_8 0.000570338f
C429 BL_1_1 P_0_0_4 0.000149532f
C430 BL_1_1 VDD_1 0.000717832f
C431 BL_1_1 VSS_0 0.0149769f
C432 BL_1_1 WL_0_18 0.0047702f
C433 BL_1_1 WL_0_19 0.0047702f
C434 BL_1_1 XB_0_0_1 0.000478164f
C435 BL_1_1 net8_2 0.000688198f
C436 BL_1_1 net8_4 0.00117161f
C437 BL_1_1 net9_5 0.000570338f
C438 BL_1_1 net9_7 0.000285169f
C439 BL_1_1 net9_9 0.00137127f
C440 BL_2 P_0_1 3.62296e-05f
C441 BL_2 P_0_1_1 7.76095e-05f
C442 BL_2 P_0_1_2 0.000141189f
C443 BL_2 P_0_1_3 1.5664e-05f
C444 BL_2 P_0_1_4 0.000231941f
C445 BL_2 P_0_1_5 6.20165e-05f
C446 BL_2 VDD_1 0.0013009f
C447 BL_2 VSS_0 0.021437f
C448 BL_2 WL_0_10 0.000196911f
C449 BL_2 WL_0_11 0.00978524f
C450 BL_2 WL_0_18 9.05271e-05f
C451 BL_2 WL_0_19 9.05271e-05f
C452 BL_2 WL_0_2 0.000118887f
C453 BL_2 WL_0_3 0.00649873f
C454 BL_2 XB_0_1 0.000163855f
C455 BL_2 XB_0_1_1 0.00132569f
C456 BL_2 XB_0_1_2 9.68137e-05f
C457 BL_2 XB_0_1_3 0.000193627f
C458 BL_2 net12 0.000528329f
C459 BL_2 net12_3 0.000688198f
C460 BL_2 net12_6 0.000498449f
C461 BL_2 net12_7 0.0017814f
C462 BL_2 net13 0.00150534f
C463 BL_2 net13_11 0.000882478f
C464 BL_2 net13_2 0.00130597f
C465 BL_2 net13_3 0.00141764f
C466 BL_2 net13_4 0.00142805f
C467 BL_2 net13_6 0.000570338f
C468 BL_2 net13_8 0.000570338f
C469 BL_2_1 P_0_1_4 0.000149532f
C470 BL_2_1 VDD_1 0.000717832f
C471 BL_2_1 VSS_0 0.0150138f
C472 BL_2_1 WL_0_20 0.00494849f
C473 BL_2_1 WL_0_21 0.00494849f
C474 BL_2_1 XB_0_1_1 0.000478164f
C475 BL_2_1 net12_2 0.000688198f
C476 BL_2_1 net12_4 0.00117161f
C477 BL_2_1 net13_5 0.000570338f
C478 BL_2_1 net13_7 0.000285169f
C479 BL_2_1 net13_9 0.00137127f
C480 BL_3 P_0_2 3.62296e-05f
C481 BL_3 P_0_2_1 7.76095e-05f
C482 BL_3 P_0_2_2 0.000141189f
C483 BL_3 P_0_2_3 1.5664e-05f
C484 BL_3 P_0_2_4 0.000231941f
C485 BL_3 P_0_2_5 6.20165e-05f
C486 BL_3 VDD_1 0.0013009f
C487 BL_3 VSS_0 0.021437f
C488 BL_3 WL_0_11 0.0001857f
C489 BL_3 WL_0_12 0.010376f
C490 BL_3 WL_0_20 9.39106e-05f
C491 BL_3 WL_0_21 9.39106e-05f
C492 BL_3 WL_0_3 0.00012333f
C493 BL_3 WL_0_4 0.00626458f
C494 BL_3 XB_0_2 0.000163855f
C495 BL_3 XB_0_2_1 0.00132569f
C496 BL_3 XB_0_2_2 9.68137e-05f
C497 BL_3 XB_0_2_3 0.000193627f
C498 BL_3 net16 0.000528329f
C499 BL_3 net16_3 0.000688198f
C500 BL_3 net16_6 0.000498449f
C501 BL_3 net16_7 0.0017814f
C502 BL_3 net17 0.00150534f
C503 BL_3 net17_11 0.000882478f
C504 BL_3 net17_2 0.00130597f
C505 BL_3 net17_3 0.00141764f
C506 BL_3 net17_4 0.00142805f
C507 BL_3 net17_6 0.000570338f
C508 BL_3 net17_8 0.000570338f
C509 BL_3_1 P_0_2_4 0.000149532f
C510 BL_3_1 VDD_1 0.000717832f
C511 BL_3_1 VSS_0 0.0150138f
C512 BL_3_1 WL_0_22 0.0047702f
C513 BL_3_1 WL_0_23 0.0047702f
C514 BL_3_1 XB_0_2_1 0.000478164f
C515 BL_3_1 net16_2 0.000688198f
C516 BL_3_1 net16_4 0.00117161f
C517 BL_3_1 net17_5 0.000570338f
C518 BL_3_1 net17_7 0.000285169f
C519 BL_3_1 net17_9 0.00137127f
C520 BL_4 P_0_3 3.62296e-05f
C521 BL_4 P_0_3_1 7.76095e-05f
C522 BL_4 P_0_3_2 0.000141189f
C523 BL_4 P_0_3_3 1.5664e-05f
C524 BL_4 P_0_3_4 0.000231941f
C525 BL_4 P_0_3_5 6.20165e-05f
C526 BL_4 VDD_1 0.0013009f
C527 BL_4 VSS_0 0.021437f
C528 BL_4 WL_0_12 0.000196911f
C529 BL_4 WL_0_13 0.010376f
C530 BL_4 WL_0_22 9.05271e-05f
C531 BL_4 WL_0_23 9.05271e-05f
C532 BL_4 WL_0_4 0.000118887f
C533 BL_4 WL_0_5 0.00626458f
C534 BL_4 XB_0_3 0.000163855f
C535 BL_4 XB_0_3_1 0.00132569f
C536 BL_4 XB_0_3_2 9.68137e-05f
C537 BL_4 XB_0_3_3 0.000193627f
C538 BL_4 net19 0.000528329f
C539 BL_4 net19_3 0.000688198f
C540 BL_4 net19_6 0.000498449f
C541 BL_4 net19_7 0.0017814f
C542 BL_4 net20 0.00150534f
C543 BL_4 net20_11 0.000882478f
C544 BL_4 net20_2 0.00130597f
C545 BL_4 net20_3 0.00141764f
C546 BL_4 net20_4 0.00142805f
C547 BL_4 net20_6 0.000570338f
C548 BL_4 net20_8 0.000570338f
C549 BL_4_1 P_0_3_4 0.000149532f
C550 BL_4_1 VDD_1 0.000717832f
C551 BL_4_1 VSS_0 0.0150138f
C552 BL_4_1 WL_0_24 0.0047702f
C553 BL_4_1 WL_0_25 0.0047702f
C554 BL_4_1 XB_0_3_1 0.000478164f
C555 BL_4_1 net19_2 0.000688198f
C556 BL_4_1 net19_4 0.00117161f
C557 BL_4_1 net20_5 0.000570338f
C558 BL_4_1 net20_7 0.000285169f
C559 BL_4_1 net20_9 0.00137127f
C560 BL_5 P_0_4 3.62296e-05f
C561 BL_5 P_0_4_1 7.76095e-05f
C562 BL_5 P_0_4_2 0.000141189f
C563 BL_5 P_0_4_3 1.5664e-05f
C564 BL_5 P_0_4_4 0.000231941f
C565 BL_5 P_0_4_5 6.20165e-05f
C566 BL_5 VDD_1 0.0013009f
C567 BL_5 VSS_0 0.021437f
C568 BL_5 WL_0_13 0.000196911f
C569 BL_5 WL_0_14 0.010376f
C570 BL_5 WL_0_24 9.05271e-05f
C571 BL_5 WL_0_25 9.05271e-05f
C572 BL_5 WL_0_5 0.000118887f
C573 BL_5 WL_0_6 0.00626458f
C574 BL_5 XB_0_4 0.000163855f
C575 BL_5 XB_0_4_1 0.00132569f
C576 BL_5 XB_0_4_2 9.68137e-05f
C577 BL_5 XB_0_4_3 0.000193627f
C578 BL_5 net23 0.000528329f
C579 BL_5 net23_3 0.000688198f
C580 BL_5 net23_6 0.000498449f
C581 BL_5 net23_7 0.0017814f
C582 BL_5 net24 0.00150534f
C583 BL_5 net24_11 0.000882478f
C584 BL_5 net24_2 0.00130597f
C585 BL_5 net24_3 0.00141764f
C586 BL_5 net24_4 0.00142805f
C587 BL_5 net24_6 0.000570338f
C588 BL_5 net24_8 0.000570338f
C589 BL_5_1 P_0_4_4 0.000149532f
C590 BL_5_1 VDD_1 0.000717832f
C591 BL_5_1 VSS_0 0.0150138f
C592 BL_5_1 WL_0_26 0.0047702f
C593 BL_5_1 WL_0_27 0.0047702f
C594 BL_5_1 XB_0_4_1 0.000478164f
C595 BL_5_1 net23_2 0.000688198f
C596 BL_5_1 net23_4 0.00117161f
C597 BL_5_1 net24_5 0.000570338f
C598 BL_5_1 net24_7 0.000285169f
C599 BL_5_1 net24_9 0.00137127f
C600 BL_6 P_0_5 3.62296e-05f
C601 BL_6 P_0_5_1 7.76095e-05f
C602 BL_6 P_0_5_2 0.000141189f
C603 BL_6 P_0_5_3 1.5664e-05f
C604 BL_6 P_0_5_4 0.000231941f
C605 BL_6 P_0_5_5 6.20165e-05f
C606 BL_6 VDD_1 0.0013009f
C607 BL_6 VSS_0 0.021437f
C608 BL_6 WL_0_14 0.000196911f
C609 BL_6 WL_0_15 0.0154173f
C610 BL_6 WL_0_26 9.05271e-05f
C611 BL_6 WL_0_27 9.05271e-05f
C612 BL_6 WL_0_6 0.000118887f
C613 BL_6 WL_0_7 0.00426634f
C614 BL_6 XB_0_5 0.000163855f
C615 BL_6 XB_0_5_1 0.00132569f
C616 BL_6 XB_0_5_2 9.68137e-05f
C617 BL_6 XB_0_5_3 0.000193627f
C618 BL_6 net26 0.000528329f
C619 BL_6 net26_3 0.000688198f
C620 BL_6 net26_6 0.000498449f
C621 BL_6 net26_7 0.0017814f
C622 BL_6 net27 0.00150534f
C623 BL_6 net27_11 0.000882478f
C624 BL_6 net27_2 0.00130597f
C625 BL_6 net27_3 0.00141764f
C626 BL_6 net27_4 0.00142805f
C627 BL_6 net27_6 0.000570338f
C628 BL_6 net27_8 0.000570338f
C629 BL_6_1 P_0_5_4 0.000149532f
C630 BL_6_1 VDD_1 0.000717832f
C631 BL_6_1 VSS_0 0.0150138f
C632 BL_6_1 WL_0_28 0.00324863f
C633 BL_6_1 WL_0_29 0.00324863f
C634 BL_6_1 XB_0_5_1 0.000478164f
C635 BL_6_1 net26_2 0.000688198f
C636 BL_6_1 net26_4 0.00117161f
C637 BL_6_1 net27_5 0.000570338f
C638 BL_6_1 net27_7 0.000285169f
C639 BL_6_1 net27_9 0.00137127f
C640 BL_7 P_0_6 3.62296e-05f
C641 BL_7 P_0_6_1 7.76095e-05f
C642 BL_7 P_0_6_2 0.000141189f
C643 BL_7 P_0_6_3 1.5664e-05f
C644 BL_7 P_0_6_4 0.000236179f
C645 BL_7 P_0_6_5 6.20165e-05f
C646 BL_7 VDD_1 0.00124576f
C647 BL_7 VSS_0 0.0213419f
C648 BL_7 WL_0_15 0.000292585f
C649 BL_7 WL_0_28 6.16512e-05f
C650 BL_7 WL_0_29 6.16512e-05f
C651 BL_7 WL_0_7 8.0965e-05f
C652 BL_7 WL_0_8 0.0103202f
C653 BL_7 XB_0_6 0.000163855f
C654 BL_7 XB_0_6_1 0.00132385f
C655 BL_7 XB_0_6_2 9.68137e-05f
C656 BL_7 XB_0_6_3 0.000193627f
C657 BL_7 net30 0.000554743f
C658 BL_7 net30_3 0.000722605f
C659 BL_7 net30_6 0.000523369f
C660 BL_7 net30_7 0.00187046f
C661 BL_7 net31 0.00148959f
C662 BL_7 net31_11 0.000873246f
C663 BL_7 net31_2 0.00129231f
C664 BL_7 net31_3 0.00140281f
C665 BL_7 net31_4 0.00141311f
C666 BL_7 net31_6 0.000564371f
C667 BL_7 net31_8 0.000564371f
C668 BL_7_1 P_0_6_4 0.000152694f
C669 BL_7_1 VDD_1 0.000676687f
C670 BL_7_1 VSS_0 0.0149428f
C671 BL_7_1 WL_0_30 0.00785837f
C672 BL_7_1 WL_0_31 0.00785837f
C673 BL_7_1 XB_0_6_1 0.00047679f
C674 BL_7_1 net30_2 0.000722605f
C675 BL_7_1 net30_4 0.00123019f
C676 BL_7_1 net31_5 0.000564371f
C677 BL_7_1 net31_7 0.000282186f
C678 BL_7_1 net31_9 0.00135693f
C679 P_0_0 VDD_1 0.00102632f
C680 P_0_0 VSS_0 0.00782373f
C681 P_0_0 WL_0_17 0.000637221f
C682 P_0_0 XB_0_0 0.00183286f
C683 P_0_0 net5 0.0086121f
C684 P_0_0 net5_11 0.00504869f
C685 P_0_0 net5_3 0.00811039f
C686 P_0_0 net5_4 0.00816995f
C687 P_0_0 net5_6 0.00326293f
C688 P_0_0 net68 0.000302415f
C689 P_0_0_1 VDD_1 0.00219853f
C690 P_0_0_1 VSS_0 0.0167597f
C691 P_0_0_1 WL_0_17 0.00136503f
C692 P_0_0_1 XB_0_0 0.00392628f
C693 P_0_0_1 net5_2 0.00747152f
C694 P_0_0_1 net68 0.00064782f
C695 P_0_0_2 VDD_1 0.00399961f
C696 P_0_0_2 VSS_0 0.0304895f
C697 P_0_0_2 WL_0_17 0.00248329f
C698 P_0_0_2 XB_0_0 0.00714277f
C699 P_0_0_2 net5_5 0.00326293f
C700 P_0_0_2 net5_9 0.0078451f
C701 P_0_0_2 net68 0.00117853f
C702 P_0_0_3 VDD_1 0.000443731f
C703 P_0_0_3 VSS_0 0.00338261f
C704 P_0_0_3 WL_0_17 0.000275504f
C705 P_0_0_3 XB_0_0 0.000792443f
C706 P_0_0_3 net5_7 0.00163146f
C707 P_0_0_3 net68 0.00013075f
C708 P_0_0_4 VDD_1 0.000927793f
C709 P_0_0_4 VSS_0 0.00727377f
C710 P_0_0_4 WL_0_17 0.000555381f
C711 P_0_0_4 XB_0_0_2 0.00159747f
C712 P_0_0_4 net68 0.000263575f
C713 P_0_0_5 VDD_1 0.00175681f
C714 P_0_0_5 VSS_0 0.0133924f
C715 P_0_0_5 WL_0_17 0.00109077f
C716 P_0_0_5 XB_0_0_3 0.00313743f
C717 P_0_0_5 net5_8 0.00326293f
C718 P_0_0_5 net68 0.000517663f
C719 P_0_1 VDD_1 0.00102678f
C720 P_0_1 VSS_0 0.00781243f
C721 P_0_1 WL_0_19 0.000640002f
C722 P_0_1 XB_0_1 0.00183338f
C723 P_0_1 net69 0.000298895f
C724 P_0_1 net9 0.00862208f
C725 P_0_1 net9_11 0.00505454f
C726 P_0_1 net9_3 0.00811979f
C727 P_0_1 net9_4 0.00817941f
C728 P_0_1 net9_6 0.00326671f
C729 P_0_1_1 VDD_1 0.00219953f
C730 P_0_1_1 VSS_0 0.0167355f
C731 P_0_1_1 WL_0_19 0.00137098f
C732 P_0_1_1 XB_0_1 0.00392739f
C733 P_0_1_1 net69 0.000640279f
C734 P_0_1_1 net9_2 0.00748018f
C735 P_0_1_2 VDD_1 0.00400144f
C736 P_0_1_2 VSS_0 0.0304455f
C737 P_0_1_2 WL_0_19 0.00249413f
C738 P_0_1_2 XB_0_1 0.00714479f
C739 P_0_1_2 net69 0.00116481f
C740 P_0_1_2 net9_5 0.00326671f
C741 P_0_1_2 net9_9 0.00785419f
C742 P_0_1_3 VDD_1 0.000443933f
C743 P_0_1_3 VSS_0 0.00337773f
C744 P_0_1_3 WL_0_19 0.000276707f
C745 P_0_1_3 XB_0_1 0.000792667f
C746 P_0_1_3 net69 0.000129228f
C747 P_0_1_3 net9_7 0.00163335f
C748 P_0_1_4 VDD_1 0.000928202f
C749 P_0_1_4 VSS_0 0.00726392f
C750 P_0_1_4 WL_0_19 0.000557806f
C751 P_0_1_4 XB_0_1_2 0.00159792f
C752 P_0_1_4 net69 0.000260507f
C753 P_0_1_5 VDD_1 0.00175761f
C754 P_0_1_5 VSS_0 0.013373f
C755 P_0_1_5 WL_0_19 0.00109553f
C756 P_0_1_5 XB_0_1_3 0.00313831f
C757 P_0_1_5 net69 0.000511637f
C758 P_0_1_5 net9_8 0.00326671f
C759 P_0_2 VDD_1 0.00102678f
C760 P_0_2 VSS_0 0.00781243f
C761 P_0_2 WL_0_21 0.000640002f
C762 P_0_2 XB_0_2 0.00183338f
C763 P_0_2 net13 0.00862208f
C764 P_0_2 net13_11 0.00505454f
C765 P_0_2 net13_3 0.00811979f
C766 P_0_2 net13_4 0.00817941f
C767 P_0_2 net13_6 0.00326671f
C768 P_0_2 net70 0.000298895f
C769 P_0_2_1 VDD_1 0.00219953f
C770 P_0_2_1 VSS_0 0.0167355f
C771 P_0_2_1 WL_0_21 0.00137098f
C772 P_0_2_1 XB_0_2 0.00392739f
C773 P_0_2_1 net13_2 0.00748018f
C774 P_0_2_1 net70 0.000640279f
C775 P_0_2_2 VDD_1 0.00400144f
C776 P_0_2_2 VSS_0 0.0304455f
C777 P_0_2_2 WL_0_21 0.00249413f
C778 P_0_2_2 XB_0_2 0.00714479f
C779 P_0_2_2 net13_5 0.00326671f
C780 P_0_2_2 net13_9 0.00785419f
C781 P_0_2_2 net70 0.00116481f
C782 P_0_2_3 VDD_1 0.000443933f
C783 P_0_2_3 VSS_0 0.00337773f
C784 P_0_2_3 WL_0_21 0.000276707f
C785 P_0_2_3 XB_0_2 0.000792667f
C786 P_0_2_3 net13_7 0.00163335f
C787 P_0_2_3 net70 0.000129228f
C788 P_0_2_4 VDD_1 0.000928202f
C789 P_0_2_4 VSS_0 0.00726392f
C790 P_0_2_4 WL_0_21 0.000557806f
C791 P_0_2_4 XB_0_2_2 0.00159792f
C792 P_0_2_4 net70 0.000260507f
C793 P_0_2_5 VDD_1 0.00175761f
C794 P_0_2_5 VSS_0 0.013373f
C795 P_0_2_5 WL_0_21 0.00109553f
C796 P_0_2_5 XB_0_2_3 0.00313831f
C797 P_0_2_5 net13_8 0.00326671f
C798 P_0_2_5 net70 0.000511637f
C799 P_0_3 VDD_1 0.00102678f
C800 P_0_3 VSS_0 0.00781243f
C801 P_0_3 WL_0_23 0.000640002f
C802 P_0_3 XB_0_3 0.00183338f
C803 P_0_3 net17 0.00862208f
C804 P_0_3 net17_11 0.00505454f
C805 P_0_3 net17_3 0.00811979f
C806 P_0_3 net17_4 0.00817941f
C807 P_0_3 net17_6 0.00326671f
C808 P_0_3 net71 0.000298895f
C809 P_0_3_1 VDD_1 0.00219953f
C810 P_0_3_1 VSS_0 0.0167355f
C811 P_0_3_1 WL_0_23 0.00137098f
C812 P_0_3_1 XB_0_3 0.00392739f
C813 P_0_3_1 net17_2 0.00748018f
C814 P_0_3_1 net71 0.000640279f
C815 P_0_3_2 VDD_1 0.00400144f
C816 P_0_3_2 VSS_0 0.0304455f
C817 P_0_3_2 WL_0_23 0.00249413f
C818 P_0_3_2 XB_0_3 0.00714479f
C819 P_0_3_2 net17_5 0.00326671f
C820 P_0_3_2 net17_9 0.00785419f
C821 P_0_3_2 net71 0.00116481f
C822 P_0_3_3 VDD_1 0.000443933f
C823 P_0_3_3 VSS_0 0.00337773f
C824 P_0_3_3 WL_0_23 0.000276707f
C825 P_0_3_3 XB_0_3 0.000792667f
C826 P_0_3_3 net17_7 0.00163335f
C827 P_0_3_3 net71 0.000129228f
C828 P_0_3_4 VDD_1 0.000928202f
C829 P_0_3_4 VSS_0 0.00726392f
C830 P_0_3_4 WL_0_23 0.000557806f
C831 P_0_3_4 XB_0_3_2 0.00159792f
C832 P_0_3_4 net71 0.000260507f
C833 P_0_3_5 VDD_1 0.00175761f
C834 P_0_3_5 VSS_0 0.013373f
C835 P_0_3_5 WL_0_23 0.00109553f
C836 P_0_3_5 XB_0_3_3 0.00313831f
C837 P_0_3_5 net17_8 0.00326671f
C838 P_0_3_5 net71 0.000511637f
C839 P_0_4 VDD_1 0.00102678f
C840 P_0_4 VSS_0 0.00781243f
C841 P_0_4 WL_0_25 0.000640002f
C842 P_0_4 XB_0_4 0.00183338f
C843 P_0_4 net20 0.00862208f
C844 P_0_4 net20_11 0.00505454f
C845 P_0_4 net20_3 0.00811979f
C846 P_0_4 net20_4 0.00817941f
C847 P_0_4 net20_6 0.00326671f
C848 P_0_4 net72 0.000298895f
C849 P_0_4_1 VDD_1 0.00219953f
C850 P_0_4_1 VSS_0 0.0167355f
C851 P_0_4_1 WL_0_25 0.00137098f
C852 P_0_4_1 XB_0_4 0.00392739f
C853 P_0_4_1 net20_2 0.00748018f
C854 P_0_4_1 net72 0.000640279f
C855 P_0_4_2 VDD_1 0.00400144f
C856 P_0_4_2 VSS_0 0.0304455f
C857 P_0_4_2 WL_0_25 0.00249413f
C858 P_0_4_2 XB_0_4 0.00714479f
C859 P_0_4_2 net20_5 0.00326671f
C860 P_0_4_2 net20_9 0.00785419f
C861 P_0_4_2 net72 0.00116481f
C862 P_0_4_3 VDD_1 0.000443933f
C863 P_0_4_3 VSS_0 0.00337773f
C864 P_0_4_3 WL_0_25 0.000276707f
C865 P_0_4_3 XB_0_4 0.000792667f
C866 P_0_4_3 net20_7 0.00163335f
C867 P_0_4_3 net72 0.000129228f
C868 P_0_4_4 VDD_1 0.000928202f
C869 P_0_4_4 VSS_0 0.00726392f
C870 P_0_4_4 WL_0_25 0.000557806f
C871 P_0_4_4 XB_0_4_2 0.00159792f
C872 P_0_4_4 net72 0.000260507f
C873 P_0_4_5 VDD_1 0.00175761f
C874 P_0_4_5 VSS_0 0.013373f
C875 P_0_4_5 WL_0_25 0.00109553f
C876 P_0_4_5 XB_0_4_3 0.00313831f
C877 P_0_4_5 net20_8 0.00326671f
C878 P_0_4_5 net72 0.000511637f
C879 P_0_5 VDD_1 0.00102678f
C880 P_0_5 VSS_0 0.00781243f
C881 P_0_5 WL_0_27 0.000640002f
C882 P_0_5 XB_0_5 0.00183338f
C883 P_0_5 net24 0.00862208f
C884 P_0_5 net24_11 0.00505454f
C885 P_0_5 net24_3 0.00811979f
C886 P_0_5 net24_4 0.00817941f
C887 P_0_5 net24_6 0.00326671f
C888 P_0_5 net73 0.000298895f
C889 P_0_5_1 VDD_1 0.00219953f
C890 P_0_5_1 VSS_0 0.0167355f
C891 P_0_5_1 WL_0_27 0.00137098f
C892 P_0_5_1 XB_0_5 0.00392739f
C893 P_0_5_1 net24_2 0.00748018f
C894 P_0_5_1 net73 0.000640279f
C895 P_0_5_2 VDD_1 0.00400144f
C896 P_0_5_2 VSS_0 0.0304455f
C897 P_0_5_2 WL_0_27 0.00249413f
C898 P_0_5_2 XB_0_5 0.00714479f
C899 P_0_5_2 net24_5 0.00326671f
C900 P_0_5_2 net24_9 0.00785419f
C901 P_0_5_2 net73 0.00116481f
C902 P_0_5_3 VDD_1 0.000443933f
C903 P_0_5_3 VSS_0 0.00337773f
C904 P_0_5_3 WL_0_27 0.000276707f
C905 P_0_5_3 XB_0_5 0.000792667f
C906 P_0_5_3 net24_7 0.00163335f
C907 P_0_5_3 net73 0.000129228f
C908 P_0_5_4 VDD_1 0.000928202f
C909 P_0_5_4 VSS_0 0.00726392f
C910 P_0_5_4 WL_0_27 0.000557806f
C911 P_0_5_4 XB_0_5_2 0.00159792f
C912 P_0_5_4 net73 0.000260507f
C913 P_0_5_5 VDD_1 0.00175761f
C914 P_0_5_5 VSS_0 0.013373f
C915 P_0_5_5 WL_0_27 0.00109553f
C916 P_0_5_5 XB_0_5_3 0.00313831f
C917 P_0_5_5 net24_8 0.00326671f
C918 P_0_5_5 net73 0.000511637f
C919 P_0_6 VDD_1 0.00102678f
C920 P_0_6 VSS_0 0.00780902f
C921 P_0_6 WL_0_29 0.000640002f
C922 P_0_6 XB_0_6 0.00183338f
C923 P_0_6 net27 0.00862208f
C924 P_0_6 net27_11 0.00505454f
C925 P_0_6 net27_3 0.00811979f
C926 P_0_6 net27_4 0.00817941f
C927 P_0_6 net27_6 0.00326671f
C928 P_0_6 net74 0.000298895f
C929 P_0_6_1 VDD_1 0.00219953f
C930 P_0_6_1 VSS_0 0.0167281f
C931 P_0_6_1 WL_0_29 0.00137098f
C932 P_0_6_1 XB_0_6 0.00392739f
C933 P_0_6_1 net27_2 0.00748018f
C934 P_0_6_1 net74 0.000640279f
C935 P_0_6_2 VDD_1 0.00400144f
C936 P_0_6_2 VSS_0 0.0304322f
C937 P_0_6_2 WL_0_29 0.00249413f
C938 P_0_6_2 XB_0_6 0.00714479f
C939 P_0_6_2 net27_5 0.00326671f
C940 P_0_6_2 net27_9 0.00785419f
C941 P_0_6_2 net74 0.00116481f
C942 P_0_6_3 VDD_1 0.000443933f
C943 P_0_6_3 VSS_0 0.00337625f
C944 P_0_6_3 WL_0_29 0.000276707f
C945 P_0_6_3 XB_0_6 0.000792667f
C946 P_0_6_3 net27_7 0.00163335f
C947 P_0_6_3 net74 0.000129228f
C948 P_0_6_4 VDD_1 0.000948129f
C949 P_0_6_4 VSS_0 0.00726653f
C950 P_0_6_4 WL_0_29 0.000557806f
C951 P_0_6_4 XB_0_6_2 0.00159792f
C952 P_0_6_4 net74 0.000260507f
C953 P_0_6_5 VDD_1 0.00175761f
C954 P_0_6_5 VSS_0 0.0133672f
C955 P_0_6_5 WL_0_29 0.00109553f
C956 P_0_6_5 XB_0_6_3 0.00313831f
C957 P_0_6_5 net27_8 0.00326671f
C958 P_0_6_5 net74 0.000511637f
C959 P_0_7 VDD_1 0.00103207f
C960 P_0_7 VSS_0 0.00781988f
C961 P_0_7 WL_0_31 0.000638442f
C962 P_0_7 XB_0_7 0.00186124f
C963 P_0_7 net31 0.00862855f
C964 P_0_7 net31_11 0.00505833f
C965 P_0_7 net31_3 0.00812588f
C966 P_0_7 net31_4 0.00818555f
C967 P_0_7 net31_6 0.00326916f
C968 P_0_7 net75 0.000296739f
C969 P_0_7_1 VDD_1 0.00221085f
C970 P_0_7_1 VSS_0 0.0167514f
C971 P_0_7_1 WL_0_31 0.00136764f
C972 P_0_7_1 XB_0_7 0.00398707f
C973 P_0_7_1 net31_2 0.00748579f
C974 P_0_7_1 net75 0.000635662f
C975 P_0_7_2 VDD_1 0.00402202f
C976 P_0_7_2 VSS_0 0.0304745f
C977 P_0_7_2 WL_0_31 0.00248805f
C978 P_0_7_2 XB_0_7 0.00725337f
C979 P_0_7_2 net31_5 0.00326916f
C980 P_0_7_2 net31_9 0.00786008f
C981 P_0_7_2 net75 0.00115641f
C982 P_0_7_3 VDD_1 0.000446217f
C983 P_0_7_3 VSS_0 0.00338095f
C984 P_0_7_3 WL_0_31 0.000276032f
C985 P_0_7_3 XB_0_7 0.000804713f
C986 P_0_7_3 net31_7 0.00163458f
C987 P_0_7_3 net75 0.000128296f
C988 P_0_7_4 VDD_1 0.000899516f
C989 P_0_7_4 VSS_0 0.00681556f
C990 P_0_7_4 WL_0_31 0.000556446f
C991 P_0_7_4 XB_0_7_2 0.0016222f
C992 P_0_7_4 net75 0.000258629f
C993 P_0_7_5 VDD_1 0.00176665f
C994 P_0_7_5 VSS_0 0.0133858f
C995 P_0_7_5 WL_0_31 0.00109286f
C996 P_0_7_5 XB_0_7_3 0.00318601f
C997 P_0_7_5 net31_8 0.00326916f
C998 P_0_7_5 net75 0.000507948f
C999 VDD_1 VSS_0 0.49906f
C1000 VDD_1 WL_0 0.00162777f
C1001 VDD_1 WL_0_1 0.00390679f
C1002 VDD_1 WL_0_10 0.0064984f
C1003 VDD_1 WL_0_11 0.00612844f
C1004 VDD_1 WL_0_12 0.0064984f
C1005 VDD_1 WL_0_13 0.0064984f
C1006 VDD_1 WL_0_14 0.0064984f
C1007 VDD_1 WL_0_15 0.0096558f
C1008 VDD_1 WL_0_16 0.00323894f
C1009 VDD_1 WL_0_17 0.00323894f
C1010 VDD_1 WL_0_18 0.00298755f
C1011 VDD_1 WL_0_19 0.00298755f
C1012 VDD_1 WL_0_2 0.00392347f
C1013 VDD_1 WL_0_20 0.00309921f
C1014 VDD_1 WL_0_21 0.00309921f
C1015 VDD_1 WL_0_22 0.00298755f
C1016 VDD_1 WL_0_23 0.00298755f
C1017 VDD_1 WL_0_24 0.00298755f
C1018 VDD_1 WL_0_25 0.00298755f
C1019 VDD_1 WL_0_26 0.00298755f
C1020 VDD_1 WL_0_27 0.00298755f
C1021 VDD_1 WL_0_28 0.0020346f
C1022 VDD_1 WL_0_29 0.0020346f
C1023 VDD_1 WL_0_3 0.00407012f
C1024 VDD_1 WL_0_30 0.00503898f
C1025 VDD_1 WL_0_31 0.00503898f
C1026 VDD_1 WL_0_4 0.00392347f
C1027 VDD_1 WL_0_5 0.00392347f
C1028 VDD_1 WL_0_6 0.00392347f
C1029 VDD_1 WL_0_7 0.00267198f
C1030 VDD_1 WL_0_8 0.00661757f
C1031 VDD_1 WL_0_9 0.00448332f
C1032 VDD_1 XB_0_0 0.00359103f
C1033 VDD_1 XB_0_0_1 0.0150413f
C1034 VDD_1 XB_0_0_2 0.00212176f
C1035 VDD_1 XB_0_0_3 0.00424352f
C1036 VDD_1 XB_0_1 0.00358647f
C1037 VDD_1 XB_0_1_1 0.0150223f
C1038 VDD_1 XB_0_1_2 0.00211906f
C1039 VDD_1 XB_0_1_3 0.00423813f
C1040 VDD_1 XB_0_2 0.00358647f
C1041 VDD_1 XB_0_2_1 0.0150223f
C1042 VDD_1 XB_0_2_2 0.00211906f
C1043 VDD_1 XB_0_2_3 0.00423813f
C1044 VDD_1 XB_0_3 0.00358647f
C1045 VDD_1 XB_0_3_1 0.0150223f
C1046 VDD_1 XB_0_3_2 0.00211906f
C1047 VDD_1 XB_0_3_3 0.00423813f
C1048 VDD_1 XB_0_4 0.00358647f
C1049 VDD_1 XB_0_4_1 0.0150223f
C1050 VDD_1 XB_0_4_2 0.00211906f
C1051 VDD_1 XB_0_4_3 0.00423813f
C1052 VDD_1 XB_0_5 0.00358647f
C1053 VDD_1 XB_0_5_1 0.0150223f
C1054 VDD_1 XB_0_5_2 0.00211906f
C1055 VDD_1 XB_0_5_3 0.00423813f
C1056 VDD_1 XB_0_6 0.00358647f
C1057 VDD_1 XB_0_6_1 0.0150211f
C1058 VDD_1 XB_0_6_2 0.00211906f
C1059 VDD_1 XB_0_6_3 0.00423813f
C1060 VDD_1 XB_0_7 0.00363543f
C1061 VDD_1 XB_0_7_1 0.0151975f
C1062 VDD_1 XB_0_7_2 0.00214799f
C1063 VDD_1 XB_0_7_3 0.00429598f
C1064 VDD_1 net12 0.00252063f
C1065 VDD_1 net12_2 0.00328336f
C1066 VDD_1 net12_3 0.00328336f
C1067 VDD_1 net12_4 0.00565677f
C1068 VDD_1 net12_6 0.00237807f
C1069 VDD_1 net12_7 0.00849895f
C1070 VDD_1 net13 0.00484076f
C1071 VDD_1 net13_11 0.00269871f
C1072 VDD_1 net13_2 0.00399381f
C1073 VDD_1 net13_3 0.00433531f
C1074 VDD_1 net13_4 0.00436714f
C1075 VDD_1 net13_5 0.00174416f
C1076 VDD_1 net13_6 0.00174416f
C1077 VDD_1 net13_7 0.000872078f
C1078 VDD_1 net13_8 0.00174416f
C1079 VDD_1 net13_9 0.0041935f
C1080 VDD_1 net16 0.00252063f
C1081 VDD_1 net16_2 0.00328336f
C1082 VDD_1 net16_3 0.00328336f
C1083 VDD_1 net16_4 0.00565677f
C1084 VDD_1 net16_6 0.00237807f
C1085 VDD_1 net16_7 0.00849895f
C1086 VDD_1 net17 0.00484076f
C1087 VDD_1 net17_11 0.00269871f
C1088 VDD_1 net17_2 0.00399381f
C1089 VDD_1 net17_3 0.00433531f
C1090 VDD_1 net17_4 0.00436714f
C1091 VDD_1 net17_5 0.00174416f
C1092 VDD_1 net17_6 0.00174416f
C1093 VDD_1 net17_7 0.000872078f
C1094 VDD_1 net17_8 0.00174416f
C1095 VDD_1 net17_9 0.0041935f
C1096 VDD_1 net19 0.00252063f
C1097 VDD_1 net19_2 0.00328336f
C1098 VDD_1 net19_3 0.00328336f
C1099 VDD_1 net19_4 0.00565677f
C1100 VDD_1 net19_6 0.00237807f
C1101 VDD_1 net19_7 0.00849895f
C1102 VDD_1 net20 0.00484076f
C1103 VDD_1 net20_11 0.00269871f
C1104 VDD_1 net20_2 0.00399381f
C1105 VDD_1 net20_3 0.00433531f
C1106 VDD_1 net20_4 0.00436714f
C1107 VDD_1 net20_5 0.00174416f
C1108 VDD_1 net20_6 0.00174416f
C1109 VDD_1 net20_7 0.000872078f
C1110 VDD_1 net20_8 0.00174416f
C1111 VDD_1 net20_9 0.0041935f
C1112 VDD_1 net23 0.00252063f
C1113 VDD_1 net23_2 0.00328336f
C1114 VDD_1 net23_3 0.00328336f
C1115 VDD_1 net23_4 0.00565677f
C1116 VDD_1 net23_6 0.00237807f
C1117 VDD_1 net23_7 0.00849895f
C1118 VDD_1 net24 0.00484076f
C1119 VDD_1 net24_11 0.00269871f
C1120 VDD_1 net24_2 0.00399381f
C1121 VDD_1 net24_3 0.00433531f
C1122 VDD_1 net24_4 0.00436714f
C1123 VDD_1 net24_5 0.00174416f
C1124 VDD_1 net24_6 0.00174416f
C1125 VDD_1 net24_7 0.000872078f
C1126 VDD_1 net24_8 0.00174416f
C1127 VDD_1 net24_9 0.0041935f
C1128 VDD_1 net26 0.00252063f
C1129 VDD_1 net26_2 0.00328336f
C1130 VDD_1 net26_3 0.00328336f
C1131 VDD_1 net26_4 0.00565677f
C1132 VDD_1 net26_6 0.00237807f
C1133 VDD_1 net26_7 0.00849895f
C1134 VDD_1 net27 0.00484076f
C1135 VDD_1 net27_11 0.00269871f
C1136 VDD_1 net27_2 0.00399381f
C1137 VDD_1 net27_3 0.00433531f
C1138 VDD_1 net27_4 0.00436714f
C1139 VDD_1 net27_5 0.00174416f
C1140 VDD_1 net27_6 0.00174416f
C1141 VDD_1 net27_7 0.000872078f
C1142 VDD_1 net27_8 0.00174416f
C1143 VDD_1 net27_9 0.0041935f
C1144 VDD_1 net30 0.00248013f
C1145 VDD_1 net30_2 0.00323061f
C1146 VDD_1 net30_3 0.00323061f
C1147 VDD_1 net30_4 0.00556697f
C1148 VDD_1 net30_6 0.00233987f
C1149 VDD_1 net30_7 0.00836241f
C1150 VDD_1 net31 0.00481892f
C1151 VDD_1 net31_11 0.00268591f
C1152 VDD_1 net31_2 0.00397485f
C1153 VDD_1 net31_3 0.00431473f
C1154 VDD_1 net31_4 0.00434642f
C1155 VDD_1 net31_5 0.00173588f
C1156 VDD_1 net31_6 0.00173588f
C1157 VDD_1 net31_7 0.000867939f
C1158 VDD_1 net31_8 0.00173588f
C1159 VDD_1 net31_9 0.0041736f
C1160 VDD_1 net4 0.00249111f
C1161 VDD_1 net4_2 0.00324491f
C1162 VDD_1 net4_3 0.00324491f
C1163 VDD_1 net4_4 0.00552424f
C1164 VDD_1 net4_6 0.00235022f
C1165 VDD_1 net4_7 0.00839943f
C1166 VDD_1 net5 0.00458924f
C1167 VDD_1 net5_11 0.00269036f
C1168 VDD_1 net5_2 0.00398145f
C1169 VDD_1 net5_3 0.00432189f
C1170 VDD_1 net5_4 0.00435363f
C1171 VDD_1 net5_5 0.00173876f
C1172 VDD_1 net5_6 0.00173876f
C1173 VDD_1 net5_7 0.000869379f
C1174 VDD_1 net5_8 0.00173876f
C1175 VDD_1 net5_9 0.00418052f
C1176 VDD_1 net68 0.00902507f
C1177 VDD_1 net69 0.00891745f
C1178 VDD_1 net70 0.00891745f
C1179 VDD_1 net71 0.00891745f
C1180 VDD_1 net72 0.00891745f
C1181 VDD_1 net73 0.00891745f
C1182 VDD_1 net74 0.00891745f
C1183 VDD_1 net75 0.00898882f
C1184 VDD_1 net8 0.00252063f
C1185 VDD_1 net8_2 0.00328336f
C1186 VDD_1 net8_3 0.00328336f
C1187 VDD_1 net8_4 0.00564887f
C1188 VDD_1 net8_6 0.00237807f
C1189 VDD_1 net8_7 0.00849895f
C1190 VDD_1 net9 0.00488731f
C1191 VDD_1 net9_11 0.00269871f
C1192 VDD_1 net9_2 0.00399381f
C1193 VDD_1 net9_3 0.00433531f
C1194 VDD_1 net9_4 0.00436714f
C1195 VDD_1 net9_5 0.00174416f
C1196 VDD_1 net9_6 0.00174416f
C1197 VDD_1 net9_7 0.000872078f
C1198 VDD_1 net9_8 0.00174416f
C1199 VDD_1 net9_9 0.0041935f
C1200 VSS_0 WL_0 0.00938716f
C1201 VSS_0 WL_0_1 0.02253f
C1202 VSS_0 WL_0_10 0.0367617f
C1203 VSS_0 WL_0_11 0.0346596f
C1204 VSS_0 WL_0_12 0.0367519f
C1205 VSS_0 WL_0_13 0.0367519f
C1206 VSS_0 WL_0_14 0.0367519f
C1207 VSS_0 WL_0_15 0.0546087f
C1208 VSS_0 WL_0_16 0.0186786f
C1209 VSS_0 WL_0_17 0.0186786f
C1210 VSS_0 WL_0_18 0.0169007f
C1211 VSS_0 WL_0_19 0.0169007f
C1212 VSS_0 WL_0_2 0.0221952f
C1213 VSS_0 WL_0_20 0.0175277f
C1214 VSS_0 WL_0_21 0.0175277f
C1215 VSS_0 WL_0_22 0.0168962f
C1216 VSS_0 WL_0_23 0.0168962f
C1217 VSS_0 WL_0_24 0.0168962f
C1218 VSS_0 WL_0_25 0.0168962f
C1219 VSS_0 WL_0_26 0.0168962f
C1220 VSS_0 WL_0_27 0.0168962f
C1221 VSS_0 WL_0_28 0.0115067f
C1222 VSS_0 WL_0_29 0.0115067f
C1223 VSS_0 WL_0_3 0.0230187f
C1224 VSS_0 WL_0_30 0.0284183f
C1225 VSS_0 WL_0_31 0.0284183f
C1226 VSS_0 WL_0_4 0.0221893f
C1227 VSS_0 WL_0_5 0.0221893f
C1228 VSS_0 WL_0_6 0.0221893f
C1229 VSS_0 WL_0_7 0.0151115f
C1230 VSS_0 WL_0_8 0.0373211f
C1231 VSS_0 WL_0_9 0.0258547f
C1232 VSS_0 XB_0_0 0.00896208f
C1233 VSS_0 XB_0_0_1 0.0383786f
C1234 VSS_0 XB_0_0_2 0.00529524f
C1235 VSS_0 XB_0_0_3 0.0105905f
C1236 VSS_0 XB_0_1 0.00903465f
C1237 VSS_0 XB_0_1_1 0.0386819f
C1238 VSS_0 XB_0_1_2 0.00533812f
C1239 VSS_0 XB_0_1_3 0.0106762f
C1240 VSS_0 XB_0_2 0.00903465f
C1241 VSS_0 XB_0_2_1 0.0386819f
C1242 VSS_0 XB_0_2_2 0.00533812f
C1243 VSS_0 XB_0_2_3 0.0106762f
C1244 VSS_0 XB_0_3 0.00903465f
C1245 VSS_0 XB_0_3_1 0.0386819f
C1246 VSS_0 XB_0_3_2 0.00533812f
C1247 VSS_0 XB_0_3_3 0.0106762f
C1248 VSS_0 XB_0_4 0.00903465f
C1249 VSS_0 XB_0_4_1 0.0386819f
C1250 VSS_0 XB_0_4_2 0.00533812f
C1251 VSS_0 XB_0_4_3 0.0106762f
C1252 VSS_0 XB_0_5 0.00903465f
C1253 VSS_0 XB_0_5_1 0.0386819f
C1254 VSS_0 XB_0_5_2 0.00533812f
C1255 VSS_0 XB_0_5_3 0.0106762f
C1256 VSS_0 XB_0_6 0.00903465f
C1257 VSS_0 XB_0_6_1 0.0387065f
C1258 VSS_0 XB_0_6_2 0.00533812f
C1259 VSS_0 XB_0_6_3 0.0106762f
C1260 VSS_0 XB_0_7 0.00965731f
C1261 VSS_0 XB_0_7_1 0.0403713f
C1262 VSS_0 XB_0_7_2 0.00570602f
C1263 VSS_0 XB_0_7_3 0.011412f
C1264 VSS_0 net12 0.00636671f
C1265 VSS_0 net12_2 0.00829324f
C1266 VSS_0 net12_3 0.00829324f
C1267 VSS_0 net12_4 0.0144403f
C1268 VSS_0 net12_6 0.00600664f
C1269 VSS_0 net12_7 0.021467f
C1270 VSS_0 net13 0.0204087f
C1271 VSS_0 net13_11 0.0115938f
C1272 VSS_0 net13_2 0.0174108f
C1273 VSS_0 net13_3 0.0186246f
C1274 VSS_0 net13_4 0.0187614f
C1275 VSS_0 net13_5 0.00749294f
C1276 VSS_0 net13_6 0.00749294f
C1277 VSS_0 net13_7 0.00374647f
C1278 VSS_0 net13_8 0.00749294f
C1279 VSS_0 net13_9 0.0180154f
C1280 VSS_0 net16 0.00636671f
C1281 VSS_0 net16_2 0.00829324f
C1282 VSS_0 net16_3 0.00829324f
C1283 VSS_0 net16_4 0.0144403f
C1284 VSS_0 net16_6 0.00600664f
C1285 VSS_0 net16_7 0.021467f
C1286 VSS_0 net17 0.0204087f
C1287 VSS_0 net17_11 0.0115938f
C1288 VSS_0 net17_2 0.0174108f
C1289 VSS_0 net17_3 0.0186246f
C1290 VSS_0 net17_4 0.0187614f
C1291 VSS_0 net17_5 0.00749294f
C1292 VSS_0 net17_6 0.00749294f
C1293 VSS_0 net17_7 0.00374647f
C1294 VSS_0 net17_8 0.00749294f
C1295 VSS_0 net17_9 0.0180154f
C1296 VSS_0 net19 0.00636671f
C1297 VSS_0 net19_2 0.00829324f
C1298 VSS_0 net19_3 0.00829324f
C1299 VSS_0 net19_4 0.0144403f
C1300 VSS_0 net19_6 0.00600664f
C1301 VSS_0 net19_7 0.021467f
C1302 VSS_0 net20 0.0204087f
C1303 VSS_0 net20_11 0.0115938f
C1304 VSS_0 net20_2 0.0174108f
C1305 VSS_0 net20_3 0.0186246f
C1306 VSS_0 net20_4 0.0187614f
C1307 VSS_0 net20_5 0.00749294f
C1308 VSS_0 net20_6 0.00749294f
C1309 VSS_0 net20_7 0.00374647f
C1310 VSS_0 net20_8 0.00749294f
C1311 VSS_0 net20_9 0.0180154f
C1312 VSS_0 net23 0.00636671f
C1313 VSS_0 net23_2 0.00829324f
C1314 VSS_0 net23_3 0.00829324f
C1315 VSS_0 net23_4 0.0144403f
C1316 VSS_0 net23_6 0.00600664f
C1317 VSS_0 net23_7 0.021467f
C1318 VSS_0 net24 0.0204087f
C1319 VSS_0 net24_11 0.0115938f
C1320 VSS_0 net24_2 0.0174108f
C1321 VSS_0 net24_3 0.0186246f
C1322 VSS_0 net24_4 0.0187614f
C1323 VSS_0 net24_5 0.00749294f
C1324 VSS_0 net24_6 0.00749294f
C1325 VSS_0 net24_7 0.00374647f
C1326 VSS_0 net24_8 0.00749294f
C1327 VSS_0 net24_9 0.0180154f
C1328 VSS_0 net26 0.00636671f
C1329 VSS_0 net26_2 0.00829324f
C1330 VSS_0 net26_3 0.00829324f
C1331 VSS_0 net26_4 0.0144403f
C1332 VSS_0 net26_6 0.00600664f
C1333 VSS_0 net26_7 0.021467f
C1334 VSS_0 net27 0.0204015f
C1335 VSS_0 net27_11 0.0115895f
C1336 VSS_0 net27_2 0.0174605f
C1337 VSS_0 net27_3 0.0186178f
C1338 VSS_0 net27_4 0.0187545f
C1339 VSS_0 net27_5 0.00749022f
C1340 VSS_0 net27_6 0.00749022f
C1341 VSS_0 net27_7 0.00374511f
C1342 VSS_0 net27_8 0.00749022f
C1343 VSS_0 net27_9 0.0180088f
C1344 VSS_0 net30 0.00640585f
C1345 VSS_0 net30_2 0.00834422f
C1346 VSS_0 net30_3 0.00834422f
C1347 VSS_0 net30_4 0.0145271f
C1348 VSS_0 net30_6 0.00604356f
C1349 VSS_0 net30_7 0.021599f
C1350 VSS_0 net31 0.0203792f
C1351 VSS_0 net31_11 0.0115765f
C1352 VSS_0 net31_2 0.0171319f
C1353 VSS_0 net31_3 0.0185968f
C1354 VSS_0 net31_4 0.0187334f
C1355 VSS_0 net31_5 0.00748177f
C1356 VSS_0 net31_6 0.00748177f
C1357 VSS_0 net31_7 0.00374088f
C1358 VSS_0 net31_8 0.00748177f
C1359 VSS_0 net31_9 0.0179885f
C1360 VSS_0 net4 0.00632951f
C1361 VSS_0 net4_2 0.00824478f
C1362 VSS_0 net4_3 0.00824478f
C1363 VSS_0 net4_4 0.0140362f
C1364 VSS_0 net4_6 0.00597154f
C1365 VSS_0 net4_7 0.0213416f
C1366 VSS_0 net5 0.020087f
C1367 VSS_0 net5_11 0.0117756f
C1368 VSS_0 net5_2 0.01768f
C1369 VSS_0 net5_3 0.0189168f
C1370 VSS_0 net5_4 0.0190557f
C1371 VSS_0 net5_5 0.00761049f
C1372 VSS_0 net5_6 0.00761049f
C1373 VSS_0 net5_7 0.00380525f
C1374 VSS_0 net5_8 0.00761049f
C1375 VSS_0 net5_9 0.018298f
C1376 VSS_0 net68 0.000367056f
C1377 VSS_0 net69 0.000416268f
C1378 VSS_0 net70 0.000416268f
C1379 VSS_0 net71 0.000416268f
C1380 VSS_0 net72 0.000416268f
C1381 VSS_0 net73 0.000416268f
C1382 VSS_0 net74 0.000418175f
C1383 VSS_0 net75 0.000255217f
C1384 VSS_0 net8 0.00636731f
C1385 VSS_0 net8_2 0.00829401f
C1386 VSS_0 net8_3 0.00829401f
C1387 VSS_0 net8_4 0.0144143f
C1388 VSS_0 net8_6 0.00600719f
C1389 VSS_0 net8_7 0.021469f
C1390 VSS_0 net9 0.0204505f
C1391 VSS_0 net9_11 0.0115841f
C1392 VSS_0 net9_2 0.0173965f
C1393 VSS_0 net9_3 0.0186091f
C1394 VSS_0 net9_4 0.0187457f
C1395 VSS_0 net9_5 0.0074867f
C1396 VSS_0 net9_6 0.0074867f
C1397 VSS_0 net9_7 0.00374335f
C1398 VSS_0 net9_8 0.0074867f
C1399 VSS_0 net9_9 0.0180004f
C1400 WL_0 XB_0_0 0.000507851f
C1401 WL_0 net68 5.57132e-05f
C1402 WL_0 net9 4.16885e-05f
C1403 WL_0_1 XB_0_0 0.00121889f
C1404 WL_0_1 net4 0.00651418f
C1405 WL_0_1 net4_3 0.00848533f
C1406 WL_0_1 net4_6 0.00614577f
C1407 WL_0_1 net4_7 0.0219642f
C1408 WL_0_1 net5 0.0143537f
C1409 WL_0_1 net5_11 0.00841457f
C1410 WL_0_1 net5_4 0.0136167f
C1411 WL_0_1 net5_6 0.00543827f
C1412 WL_0_1 net68 0.000133716f
C1413 WL_0_1 net9 0.000100056f
C1414 WL_0_10 XB_0_0_1 3.36443e-05f
C1415 WL_0_10 XB_0_1 0.000987285f
C1416 WL_0_10 net13 0.000157274f
C1417 WL_0_10 net5_2 2.22607e-05f
C1418 WL_0_10 net68 2.45146e-05f
C1419 WL_0_10 net69 0.00021711f
C1420 WL_0_11 XB_0_1_1 3.17289e-05f
C1421 WL_0_11 XB_0_2 0.000931078f
C1422 WL_0_11 net17 0.00014832f
C1423 WL_0_11 net69 2.31189e-05f
C1424 WL_0_11 net70 0.00020475f
C1425 WL_0_11 net9_2 2.09934e-05f
C1426 WL_0_12 XB_0_2_1 3.36443e-05f
C1427 WL_0_12 XB_0_3 0.000987285f
C1428 WL_0_12 net13_2 2.22607e-05f
C1429 WL_0_12 net20 0.000157274f
C1430 WL_0_12 net70 2.45146e-05f
C1431 WL_0_12 net71 0.00021711f
C1432 WL_0_13 XB_0_3_1 3.36443e-05f
C1433 WL_0_13 XB_0_4 0.000987285f
C1434 WL_0_13 net17_2 2.22607e-05f
C1435 WL_0_13 net24 0.000157274f
C1436 WL_0_13 net71 2.45146e-05f
C1437 WL_0_13 net72 0.00021711f
C1438 WL_0_14 XB_0_4_1 3.36443e-05f
C1439 WL_0_14 XB_0_5 0.000987285f
C1440 WL_0_14 net20_2 2.22607e-05f
C1441 WL_0_14 net27 0.000157274f
C1442 WL_0_14 net72 2.45146e-05f
C1443 WL_0_14 net73 0.00021711f
C1444 WL_0_15 XB_0_5_1 4.99912e-05f
C1445 WL_0_15 XB_0_6 0.00146698f
C1446 WL_0_15 net24_2 3.30766e-05f
C1447 WL_0_15 net31 0.00023369f
C1448 WL_0_15 net73 3.64256e-05f
C1449 WL_0_15 net74 0.000322598f
C1450 WL_0_16 XB_0_0 0.00101052f
C1451 WL_0_16 net4_4 0.0144457f
C1452 WL_0_16 net5_5 0.00543827f
C1453 WL_0_16 net68 0.000110858f
C1454 WL_0_16 net9 8.29517e-05f
C1455 WL_0_17 XB_0_0 0.00101052f
C1456 WL_0_17 net4_2 0.00848533f
C1457 WL_0_17 net5_2 0.0124527f
C1458 WL_0_17 net5_3 0.0135175f
C1459 WL_0_17 net5_7 0.00271913f
C1460 WL_0_17 net5_8 0.00543827f
C1461 WL_0_17 net5_9 0.0130753f
C1462 WL_0_17 net68 0.000110858f
C1463 WL_0_17 net9 8.29517e-05f
C1464 WL_0_18 XB_0_0_1 1.54675e-05f
C1465 WL_0_18 XB_0_1 0.000453891f
C1466 WL_0_18 net13 7.23047e-05f
C1467 WL_0_18 net5_2 1.02341e-05f
C1468 WL_0_18 net68 1.12702e-05f
C1469 WL_0_18 net69 9.98134e-05f
C1470 WL_0_18 net8_4 0.0145174f
C1471 WL_0_18 net9_5 0.00541969f
C1472 WL_0_19 XB_0_0_1 1.54675e-05f
C1473 WL_0_19 XB_0_1 0.000834355f
C1474 WL_0_19 XB_0_1_1 0.00159049f
C1475 WL_0_19 XB_0_1_2 0.000224797f
C1476 WL_0_19 XB_0_1_3 0.000449595f
C1477 WL_0_19 net13 7.23047e-05f
C1478 WL_0_19 net5_2 1.02341e-05f
C1479 WL_0_19 net68 1.12702e-05f
C1480 WL_0_19 net69 9.98134e-05f
C1481 WL_0_19 net8_2 0.00852742f
C1482 WL_0_19 net9_2 0.0124101f
C1483 WL_0_19 net9_3 0.0134713f
C1484 WL_0_19 net9_7 0.00270984f
C1485 WL_0_19 net9_8 0.00541969f
C1486 WL_0_19 net9_9 0.0130306f
C1487 WL_0_2 XB_0_0_1 2.03131e-05f
C1488 WL_0_2 XB_0_1 0.000596083f
C1489 WL_0_2 net13 9.49559e-05f
C1490 WL_0_2 net5_2 1.34401e-05f
C1491 WL_0_2 net68 1.48009e-05f
C1492 WL_0_2 net69 0.000131082f
C1493 WL_0_2 net8 0.00654649f
C1494 WL_0_2 net8_3 0.00852742f
C1495 WL_0_2 net8_6 0.00617625f
C1496 WL_0_2 net8_7 0.0220732f
C1497 WL_0_2 net9 0.0143046f
C1498 WL_0_2 net9_11 0.00838583f
C1499 WL_0_2 net9_4 0.0135702f
C1500 WL_0_2 net9_6 0.00541969f
C1501 WL_0_20 XB_0_1_1 1.60456e-05f
C1502 WL_0_20 XB_0_2 0.000470855f
C1503 WL_0_20 net12_4 0.0145174f
C1504 WL_0_20 net13_5 0.00541969f
C1505 WL_0_20 net17 7.50071e-05f
C1506 WL_0_20 net69 1.16915e-05f
C1507 WL_0_20 net70 0.000103544f
C1508 WL_0_20 net9_2 1.06166e-05f
C1509 WL_0_21 XB_0_1_1 1.60456e-05f
C1510 WL_0_21 XB_0_2 0.00085132f
C1511 WL_0_21 XB_0_2_1 0.00159049f
C1512 WL_0_21 XB_0_2_2 0.000224797f
C1513 WL_0_21 XB_0_2_3 0.000449595f
C1514 WL_0_21 net12_2 0.00852742f
C1515 WL_0_21 net13_2 0.0124101f
C1516 WL_0_21 net13_3 0.0134713f
C1517 WL_0_21 net13_7 0.00270984f
C1518 WL_0_21 net13_8 0.00541969f
C1519 WL_0_21 net13_9 0.0130306f
C1520 WL_0_21 net17 7.50071e-05f
C1521 WL_0_21 net69 1.16915e-05f
C1522 WL_0_21 net70 0.000103544f
C1523 WL_0_21 net9_2 1.06166e-05f
C1524 WL_0_22 XB_0_2_1 1.54675e-05f
C1525 WL_0_22 XB_0_3 0.000453891f
C1526 WL_0_22 net13_2 1.02341e-05f
C1527 WL_0_22 net16_4 0.0145174f
C1528 WL_0_22 net17_5 0.00541969f
C1529 WL_0_22 net20 7.23047e-05f
C1530 WL_0_22 net70 1.12702e-05f
C1531 WL_0_22 net71 9.98134e-05f
C1532 WL_0_23 XB_0_2_1 1.54675e-05f
C1533 WL_0_23 XB_0_3 0.000834355f
C1534 WL_0_23 XB_0_3_1 0.00159049f
C1535 WL_0_23 XB_0_3_2 0.000224797f
C1536 WL_0_23 XB_0_3_3 0.000449595f
C1537 WL_0_23 net13_2 1.02341e-05f
C1538 WL_0_23 net16_2 0.00852742f
C1539 WL_0_23 net17_2 0.0124101f
C1540 WL_0_23 net17_3 0.0134713f
C1541 WL_0_23 net17_7 0.00270984f
C1542 WL_0_23 net17_8 0.00541969f
C1543 WL_0_23 net17_9 0.0130306f
C1544 WL_0_23 net20 7.23047e-05f
C1545 WL_0_23 net70 1.12702e-05f
C1546 WL_0_23 net71 9.98134e-05f
C1547 WL_0_24 XB_0_3_1 1.54675e-05f
C1548 WL_0_24 XB_0_4 0.000453891f
C1549 WL_0_24 net17_2 1.02341e-05f
C1550 WL_0_24 net19_4 0.0145174f
C1551 WL_0_24 net20_5 0.00541969f
C1552 WL_0_24 net24 7.23047e-05f
C1553 WL_0_24 net71 1.12702e-05f
C1554 WL_0_24 net72 9.98134e-05f
C1555 WL_0_25 XB_0_3_1 1.54675e-05f
C1556 WL_0_25 XB_0_4 0.000834355f
C1557 WL_0_25 XB_0_4_1 0.00159049f
C1558 WL_0_25 XB_0_4_2 0.000224797f
C1559 WL_0_25 XB_0_4_3 0.000449595f
C1560 WL_0_25 net17_2 1.02341e-05f
C1561 WL_0_25 net19_2 0.00852742f
C1562 WL_0_25 net20_2 0.0124101f
C1563 WL_0_25 net20_3 0.0134713f
C1564 WL_0_25 net20_7 0.00270984f
C1565 WL_0_25 net20_8 0.00541969f
C1566 WL_0_25 net20_9 0.0130306f
C1567 WL_0_25 net24 7.23047e-05f
C1568 WL_0_25 net71 1.12702e-05f
C1569 WL_0_25 net72 9.98134e-05f
C1570 WL_0_26 XB_0_4_1 1.54675e-05f
C1571 WL_0_26 XB_0_5 0.000453891f
C1572 WL_0_26 net20_2 1.02341e-05f
C1573 WL_0_26 net23_4 0.0145174f
C1574 WL_0_26 net24_5 0.00541969f
C1575 WL_0_26 net27 7.23047e-05f
C1576 WL_0_26 net72 1.12702e-05f
C1577 WL_0_26 net73 9.98134e-05f
C1578 WL_0_27 XB_0_4_1 1.54675e-05f
C1579 WL_0_27 XB_0_5 0.000834355f
C1580 WL_0_27 XB_0_5_1 0.00159049f
C1581 WL_0_27 XB_0_5_2 0.000224797f
C1582 WL_0_27 XB_0_5_3 0.000449595f
C1583 WL_0_27 net20_2 1.02341e-05f
C1584 WL_0_27 net23_2 0.00852742f
C1585 WL_0_27 net24_2 0.0124101f
C1586 WL_0_27 net24_3 0.0134713f
C1587 WL_0_27 net24_7 0.00270984f
C1588 WL_0_27 net24_8 0.00541969f
C1589 WL_0_27 net24_9 0.0130306f
C1590 WL_0_27 net27 7.23047e-05f
C1591 WL_0_27 net72 1.12702e-05f
C1592 WL_0_27 net73 9.98134e-05f
C1593 WL_0_28 XB_0_5_1 1.05338e-05f
C1594 WL_0_28 XB_0_6 0.000309111f
C1595 WL_0_28 net26_4 0.0145174f
C1596 WL_0_28 net27_5 0.00541969f
C1597 WL_0_28 net31 4.92413e-05f
C1598 WL_0_28 net74 6.79754e-05f
C1599 WL_0_29 XB_0_5_1 1.05338e-05f
C1600 WL_0_29 XB_0_6 0.000689576f
C1601 WL_0_29 XB_0_6_1 0.00159049f
C1602 WL_0_29 XB_0_6_2 0.000224797f
C1603 WL_0_29 XB_0_6_3 0.000449595f
C1604 WL_0_29 net26_2 0.00852742f
C1605 WL_0_29 net27_2 0.0124101f
C1606 WL_0_29 net27_3 0.0134713f
C1607 WL_0_29 net27_7 0.00270984f
C1608 WL_0_29 net27_8 0.00541969f
C1609 WL_0_29 net27_9 0.0130306f
C1610 WL_0_29 net31 4.92413e-05f
C1611 WL_0_29 net74 6.79754e-05f
C1612 WL_0_3 XB_0_1_1 2.10723e-05f
C1613 WL_0_3 XB_0_2 0.000618362f
C1614 WL_0_3 net12 0.00654649f
C1615 WL_0_3 net12_3 0.00852742f
C1616 WL_0_3 net12_6 0.00617625f
C1617 WL_0_3 net12_7 0.0220732f
C1618 WL_0_3 net13 0.0143046f
C1619 WL_0_3 net13_11 0.00838583f
C1620 WL_0_3 net13_4 0.0135702f
C1621 WL_0_3 net13_6 0.00541969f
C1622 WL_0_3 net17 9.85049e-05f
C1623 WL_0_3 net69 1.53541e-05f
C1624 WL_0_3 net70 0.000135982f
C1625 WL_0_3 net9_2 1.39425e-05f
C1626 WL_0_30 XB_0_6_1 3.20775e-05f
C1627 WL_0_30 net27_2 2.19203e-05f
C1628 WL_0_30 net30_4 0.0144761f
C1629 WL_0_30 net31_5 0.00541382f
C1630 WL_0_30 net74 1.50052e-05f
C1631 WL_0_30 net75 0.000161544f
C1632 WL_0_31 XB_0_6_1 3.20775e-05f
C1633 WL_0_31 XB_0_7 0.000779815f
C1634 WL_0_31 XB_0_7_1 0.00325993f
C1635 WL_0_31 XB_0_7_2 0.000460753f
C1636 WL_0_31 XB_0_7_3 0.000921507f
C1637 WL_0_31 net27_2 2.19203e-05f
C1638 WL_0_31 net30_2 0.00850318f
C1639 WL_0_31 net31_2 0.0123967f
C1640 WL_0_31 net31_3 0.0134567f
C1641 WL_0_31 net31_7 0.00270691f
C1642 WL_0_31 net31_8 0.00541382f
C1643 WL_0_31 net31_9 0.0130165f
C1644 WL_0_31 net74 1.50052e-05f
C1645 WL_0_31 net75 0.000161544f
C1646 WL_0_4 XB_0_2_1 2.03131e-05f
C1647 WL_0_4 XB_0_3 0.000596083f
C1648 WL_0_4 net13_2 1.34401e-05f
C1649 WL_0_4 net16 0.00654649f
C1650 WL_0_4 net16_3 0.00852742f
C1651 WL_0_4 net16_6 0.00617625f
C1652 WL_0_4 net16_7 0.0220732f
C1653 WL_0_4 net17 0.0143046f
C1654 WL_0_4 net17_11 0.00838583f
C1655 WL_0_4 net17_4 0.0135702f
C1656 WL_0_4 net17_6 0.00541969f
C1657 WL_0_4 net20 9.49559e-05f
C1658 WL_0_4 net70 1.48009e-05f
C1659 WL_0_4 net71 0.000131082f
C1660 WL_0_5 XB_0_3_1 2.03131e-05f
C1661 WL_0_5 XB_0_4 0.000596083f
C1662 WL_0_5 net17_2 1.34401e-05f
C1663 WL_0_5 net19 0.00654649f
C1664 WL_0_5 net19_3 0.00852742f
C1665 WL_0_5 net19_6 0.00617625f
C1666 WL_0_5 net19_7 0.0220732f
C1667 WL_0_5 net20 0.0143046f
C1668 WL_0_5 net20_11 0.00838583f
C1669 WL_0_5 net20_4 0.0135702f
C1670 WL_0_5 net20_6 0.00541969f
C1671 WL_0_5 net24 9.49559e-05f
C1672 WL_0_5 net71 1.48009e-05f
C1673 WL_0_5 net72 0.000131082f
C1674 WL_0_6 XB_0_4_1 2.03131e-05f
C1675 WL_0_6 XB_0_5 0.000596083f
C1676 WL_0_6 net20_2 1.34401e-05f
C1677 WL_0_6 net23 0.00654649f
C1678 WL_0_6 net23_3 0.00852742f
C1679 WL_0_6 net23_6 0.00617625f
C1680 WL_0_6 net23_7 0.0220732f
C1681 WL_0_6 net24 0.0143046f
C1682 WL_0_6 net24_11 0.00838583f
C1683 WL_0_6 net24_4 0.0135702f
C1684 WL_0_6 net24_6 0.00541969f
C1685 WL_0_6 net27 9.49559e-05f
C1686 WL_0_6 net72 1.48009e-05f
C1687 WL_0_6 net73 0.000131082f
C1688 WL_0_7 XB_0_5_1 1.38337e-05f
C1689 WL_0_7 XB_0_6 0.000405948f
C1690 WL_0_7 net26 0.00654649f
C1691 WL_0_7 net26_3 0.00852742f
C1692 WL_0_7 net26_6 0.00617625f
C1693 WL_0_7 net26_7 0.0220732f
C1694 WL_0_7 net27 0.0143046f
C1695 WL_0_7 net27_11 0.00838583f
C1696 WL_0_7 net27_4 0.0135702f
C1697 WL_0_7 net27_6 0.00541969f
C1698 WL_0_7 net31 6.46673e-05f
C1699 WL_0_7 net73 1.00798e-05f
C1700 WL_0_7 net74 8.92704e-05f
C1701 WL_0_8 XB_0_6_1 4.21265e-05f
C1702 WL_0_8 net27_2 2.87874e-05f
C1703 WL_0_8 net30 0.00652788f
C1704 WL_0_8 net30_3 0.00850318f
C1705 WL_0_8 net30_6 0.00615869f
C1706 WL_0_8 net30_7 0.0220104f
C1707 WL_0_8 net31 0.0142891f
C1708 WL_0_8 net31_11 0.00837674f
C1709 WL_0_8 net31_4 0.0135555f
C1710 WL_0_8 net31_6 0.00541382f
C1711 WL_0_8 net74 1.97059e-05f
C1712 WL_0_8 net75 0.000212152f
C1713 WL_0_9 XB_0_0 0.00139876f
C1714 WL_0_9 net68 0.000153449f
C1715 WL_0_9 net9 0.000114821f
C1716 XB_0_0 net5 0.00220698f
C1717 XB_0_0 net5_2 0.00191469f
C1718 XB_0_0 net5_3 0.00207841f
C1719 XB_0_0 net5_4 0.00209367f
C1720 XB_0_0 net5_5 0.000836174f
C1721 XB_0_0 net5_9 0.00201043f
C1722 XB_0_0 net68 0.00324039f
C1723 XB_0_0 net9 0.000249309f
C1724 XB_0_0_1 net68 0.0135461f
C1725 XB_0_0_1 net9 0.00131438f
C1726 XB_0_0_1 net9_11 0.000159557f
C1727 XB_0_0_1 net9_2 0.000236127f
C1728 XB_0_0_1 net9_3 0.000256317f
C1729 XB_0_0_1 net9_4 0.000258199f
C1730 XB_0_0_1 net9_5 0.00010312f
C1731 XB_0_0_1 net9_6 0.00010312f
C1732 XB_0_0_1 net9_7 5.156e-05f
C1733 XB_0_0_1 net9_8 0.00010312f
C1734 XB_0_0_1 net9_9 0.000247933f
C1735 XB_0_0_2 net5_7 0.000418087f
C1736 XB_0_0_2 net68 0.00191458f
C1737 XB_0_0_2 net9 0.000147304f
C1738 XB_0_0_3 net5_11 0.0012938f
C1739 XB_0_0_3 net5_6 0.000836174f
C1740 XB_0_0_3 net5_8 0.000836174f
C1741 XB_0_0_3 net68 0.00382917f
C1742 XB_0_0_3 net9 0.000294608f
C1743 XB_0_1 net13 0.000253376f
C1744 XB_0_1 net69 0.00324903f
C1745 XB_0_1 net9 0.00216993f
C1746 XB_0_1 net9_2 0.00188255f
C1747 XB_0_1 net9_3 0.00204352f
C1748 XB_0_1 net9_4 0.00205852f
C1749 XB_0_1 net9_5 0.000822136f
C1750 XB_0_1 net9_9 0.00197667f
C1751 XB_0_1_1 net13 0.00133138f
C1752 XB_0_1_1 net13_11 0.000159557f
C1753 XB_0_1_1 net13_2 0.000236127f
C1754 XB_0_1_1 net13_3 0.000256317f
C1755 XB_0_1_1 net13_4 0.000258199f
C1756 XB_0_1_1 net13_5 0.00010312f
C1757 XB_0_1_1 net13_6 0.00010312f
C1758 XB_0_1_1 net13_7 5.156e-05f
C1759 XB_0_1_1 net13_8 0.00010312f
C1760 XB_0_1_1 net13_9 0.000247933f
C1761 XB_0_1_1 net69 0.0135822f
C1762 XB_0_1_2 net13 0.000149707f
C1763 XB_0_1_2 net69 0.00191969f
C1764 XB_0_1_2 net9_7 0.000411068f
C1765 XB_0_1_3 net13 0.000299414f
C1766 XB_0_1_3 net69 0.00383937f
C1767 XB_0_1_3 net9_11 0.00127208f
C1768 XB_0_1_3 net9_6 0.000822136f
C1769 XB_0_1_3 net9_8 0.000822136f
C1770 XB_0_2 net13 0.00216993f
C1771 XB_0_2 net13_2 0.00188255f
C1772 XB_0_2 net13_3 0.00204352f
C1773 XB_0_2 net13_4 0.00205852f
C1774 XB_0_2 net13_5 0.000822136f
C1775 XB_0_2 net13_9 0.00197667f
C1776 XB_0_2 net17 0.000253376f
C1777 XB_0_2 net70 0.00324903f
C1778 XB_0_2_1 net17 0.00133138f
C1779 XB_0_2_1 net17_11 0.000159557f
C1780 XB_0_2_1 net17_2 0.000236127f
C1781 XB_0_2_1 net17_3 0.000256317f
C1782 XB_0_2_1 net17_4 0.000258199f
C1783 XB_0_2_1 net17_5 0.00010312f
C1784 XB_0_2_1 net17_6 0.00010312f
C1785 XB_0_2_1 net17_7 5.156e-05f
C1786 XB_0_2_1 net17_8 0.00010312f
C1787 XB_0_2_1 net17_9 0.000247933f
C1788 XB_0_2_1 net70 0.0135822f
C1789 XB_0_2_2 net13_7 0.000411068f
C1790 XB_0_2_2 net17 0.000149707f
C1791 XB_0_2_2 net70 0.00191969f
C1792 XB_0_2_3 net13_11 0.00127208f
C1793 XB_0_2_3 net13_6 0.000822136f
C1794 XB_0_2_3 net13_8 0.000822136f
C1795 XB_0_2_3 net17 0.000299414f
C1796 XB_0_2_3 net70 0.00383937f
C1797 XB_0_3 net17 0.00216993f
C1798 XB_0_3 net17_2 0.00188255f
C1799 XB_0_3 net17_3 0.00204352f
C1800 XB_0_3 net17_4 0.00205852f
C1801 XB_0_3 net17_5 0.000822136f
C1802 XB_0_3 net17_9 0.00197667f
C1803 XB_0_3 net20 0.000253376f
C1804 XB_0_3 net71 0.00324903f
C1805 XB_0_3_1 net20 0.00133138f
C1806 XB_0_3_1 net20_11 0.000159557f
C1807 XB_0_3_1 net20_2 0.000236127f
C1808 XB_0_3_1 net20_3 0.000256317f
C1809 XB_0_3_1 net20_4 0.000258199f
C1810 XB_0_3_1 net20_5 0.00010312f
C1811 XB_0_3_1 net20_6 0.00010312f
C1812 XB_0_3_1 net20_7 5.156e-05f
C1813 XB_0_3_1 net20_8 0.00010312f
C1814 XB_0_3_1 net20_9 0.000247933f
C1815 XB_0_3_1 net71 0.0135822f
C1816 XB_0_3_2 net17_7 0.000411068f
C1817 XB_0_3_2 net20 0.000149707f
C1818 XB_0_3_2 net71 0.00191969f
C1819 XB_0_3_3 net17_11 0.00127208f
C1820 XB_0_3_3 net17_6 0.000822136f
C1821 XB_0_3_3 net17_8 0.000822136f
C1822 XB_0_3_3 net20 0.000299414f
C1823 XB_0_3_3 net71 0.00383937f
C1824 XB_0_4 net20 0.00216993f
C1825 XB_0_4 net20_2 0.00188255f
C1826 XB_0_4 net20_3 0.00204352f
C1827 XB_0_4 net20_4 0.00205852f
C1828 XB_0_4 net20_5 0.000822136f
C1829 XB_0_4 net20_9 0.00197667f
C1830 XB_0_4 net24 0.000253376f
C1831 XB_0_4 net72 0.00324903f
C1832 XB_0_4_1 net24 0.00133138f
C1833 XB_0_4_1 net24_11 0.000159557f
C1834 XB_0_4_1 net24_2 0.000236127f
C1835 XB_0_4_1 net24_3 0.000256317f
C1836 XB_0_4_1 net24_4 0.000258199f
C1837 XB_0_4_1 net24_5 0.00010312f
C1838 XB_0_4_1 net24_6 0.00010312f
C1839 XB_0_4_1 net24_7 5.156e-05f
C1840 XB_0_4_1 net24_8 0.00010312f
C1841 XB_0_4_1 net24_9 0.000247933f
C1842 XB_0_4_1 net72 0.0135822f
C1843 XB_0_4_2 net20_7 0.000411068f
C1844 XB_0_4_2 net24 0.000149707f
C1845 XB_0_4_2 net72 0.00191969f
C1846 XB_0_4_3 net20_11 0.00127208f
C1847 XB_0_4_3 net20_6 0.000822136f
C1848 XB_0_4_3 net20_8 0.000822136f
C1849 XB_0_4_3 net24 0.000299414f
C1850 XB_0_4_3 net72 0.00383937f
C1851 XB_0_5 net24 0.00216993f
C1852 XB_0_5 net24_2 0.00188255f
C1853 XB_0_5 net24_3 0.00204352f
C1854 XB_0_5 net24_4 0.00205852f
C1855 XB_0_5 net24_5 0.000822136f
C1856 XB_0_5 net24_9 0.00197667f
C1857 XB_0_5 net27 0.000253376f
C1858 XB_0_5 net73 0.00324903f
C1859 XB_0_5_1 net27 0.00133138f
C1860 XB_0_5_1 net27_11 0.000159557f
C1861 XB_0_5_1 net27_2 0.000236127f
C1862 XB_0_5_1 net27_3 0.000256317f
C1863 XB_0_5_1 net27_4 0.000258199f
C1864 XB_0_5_1 net27_5 0.00010312f
C1865 XB_0_5_1 net27_6 0.00010312f
C1866 XB_0_5_1 net27_7 5.156e-05f
C1867 XB_0_5_1 net27_8 0.00010312f
C1868 XB_0_5_1 net27_9 0.000247933f
C1869 XB_0_5_1 net73 0.0135822f
C1870 XB_0_5_2 net24_7 0.000411068f
C1871 XB_0_5_2 net27 0.000149707f
C1872 XB_0_5_2 net73 0.00191969f
C1873 XB_0_5_3 net24_11 0.00127208f
C1874 XB_0_5_3 net24_6 0.000822136f
C1875 XB_0_5_3 net24_8 0.000822136f
C1876 XB_0_5_3 net27 0.000299414f
C1877 XB_0_5_3 net73 0.00383937f
C1878 XB_0_6 net27 0.00216993f
C1879 XB_0_6 net27_2 0.00188255f
C1880 XB_0_6 net27_3 0.00204352f
C1881 XB_0_6 net27_4 0.00205852f
C1882 XB_0_6 net27_5 0.000822136f
C1883 XB_0_6 net27_9 0.00197667f
C1884 XB_0_6 net31 0.000253376f
C1885 XB_0_6 net74 0.00324903f
C1886 XB_0_6_1 net31 0.00133406f
C1887 XB_0_6_1 net31_11 0.000161128f
C1888 XB_0_6_1 net31_2 0.000238452f
C1889 XB_0_6_1 net31_3 0.000258841f
C1890 XB_0_6_1 net31_4 0.000260742f
C1891 XB_0_6_1 net31_5 0.000104136f
C1892 XB_0_6_1 net31_6 0.000104136f
C1893 XB_0_6_1 net31_7 5.20678e-05f
C1894 XB_0_6_1 net31_8 0.000104136f
C1895 XB_0_6_1 net31_9 0.000250374f
C1896 XB_0_6_1 net74 0.0135822f
C1897 XB_0_6_2 net27_7 0.000411068f
C1898 XB_0_6_2 net31 0.000149707f
C1899 XB_0_6_2 net74 0.00191969f
C1900 XB_0_6_3 net27_11 0.00127208f
C1901 XB_0_6_3 net27_6 0.000822136f
C1902 XB_0_6_3 net27_8 0.000822136f
C1903 XB_0_6_3 net31 0.000299414f
C1904 XB_0_6_3 net74 0.00383937f
C1905 XB_0_7 net31 0.00211397f
C1906 XB_0_7 net31_2 0.001834f
C1907 XB_0_7 net31_3 0.00199082f
C1908 XB_0_7 net31_4 0.00200543f
C1909 XB_0_7 net31_5 0.000800933f
C1910 XB_0_7 net31_9 0.0019257f
C1911 XB_0_7 net75 0.00325567f
C1912 XB_0_7_1 net75 0.01361f
C1913 XB_0_7_2 net31_7 0.000400467f
C1914 XB_0_7_2 net75 0.00192361f
C1915 XB_0_7_3 net31_11 0.00123928f
C1916 XB_0_7_3 net31_6 0.000800933f
C1917 XB_0_7_3 net31_8 0.000800933f
C1918 XB_0_7_3 net75 0.00384723f
C1919 net12 net13_2 0.0125964f
C1920 net12 net13_3 0.0136735f
C1921 net12 net13_4 0.0137739f
C1922 net12_2 net13_7 0.00275053f
C1923 net12_2 net13_9 0.0132263f
C1924 net12_3 net13_11 0.00851172f
C1925 net12_3 net13_8 0.00550105f
C1926 net12_4 net13_5 0.00550105f
C1927 net12_6 net13_6 0.00550105f
C1928 net12_7 net13 0.0145194f
C1929 net13 net70 0.00344773f
C1930 net13_11 net70 0.00202117f
C1931 net13_2 net70 0.00299111f
C1932 net13_3 net70 0.00324688f
C1933 net13_4 net70 0.00327072f
C1934 net13_5 net70 0.00130626f
C1935 net13_6 net70 0.00130626f
C1936 net13_7 net70 0.000653132f
C1937 net13_8 net70 0.00130626f
C1938 net13_9 net70 0.00314067f
C1939 net16 net17_2 0.0125964f
C1940 net16 net17_3 0.0136735f
C1941 net16 net17_4 0.0137739f
C1942 net16_2 net17_7 0.00275053f
C1943 net16_2 net17_9 0.0132263f
C1944 net16_3 net17_11 0.00851172f
C1945 net16_3 net17_8 0.00550105f
C1946 net16_4 net17_5 0.00550105f
C1947 net16_6 net17_6 0.00550105f
C1948 net16_7 net17 0.0145194f
C1949 net17 net71 0.00344773f
C1950 net17_11 net71 0.00202117f
C1951 net17_2 net71 0.00299111f
C1952 net17_3 net71 0.00324688f
C1953 net17_4 net71 0.00327072f
C1954 net17_5 net71 0.00130626f
C1955 net17_6 net71 0.00130626f
C1956 net17_7 net71 0.000653132f
C1957 net17_8 net71 0.00130626f
C1958 net17_9 net71 0.00314067f
C1959 net19 net20_2 0.0125964f
C1960 net19 net20_3 0.0136735f
C1961 net19 net20_4 0.0137739f
C1962 net19_2 net20_7 0.00275053f
C1963 net19_2 net20_9 0.0132263f
C1964 net19_3 net20_11 0.00851172f
C1965 net19_3 net20_8 0.00550105f
C1966 net19_4 net20_5 0.00550105f
C1967 net19_6 net20_6 0.00550105f
C1968 net19_7 net20 0.0145194f
C1969 net20 net72 0.00344773f
C1970 net20_11 net72 0.00202117f
C1971 net20_2 net72 0.00299111f
C1972 net20_3 net72 0.00324688f
C1973 net20_4 net72 0.00327072f
C1974 net20_5 net72 0.00130626f
C1975 net20_6 net72 0.00130626f
C1976 net20_7 net72 0.000653132f
C1977 net20_8 net72 0.00130626f
C1978 net20_9 net72 0.00314067f
C1979 net23 net24_2 0.0125964f
C1980 net23 net24_3 0.0136735f
C1981 net23 net24_4 0.0137739f
C1982 net23_2 net24_7 0.00275053f
C1983 net23_2 net24_9 0.0132263f
C1984 net23_3 net24_11 0.00851172f
C1985 net23_3 net24_8 0.00550105f
C1986 net23_4 net24_5 0.00550105f
C1987 net23_6 net24_6 0.00550105f
C1988 net23_7 net24 0.0145194f
C1989 net24 net73 0.00344773f
C1990 net24_11 net73 0.00202117f
C1991 net24_2 net73 0.00299111f
C1992 net24_3 net73 0.00324688f
C1993 net24_4 net73 0.00327072f
C1994 net24_5 net73 0.00130626f
C1995 net24_6 net73 0.00130626f
C1996 net24_7 net73 0.000653132f
C1997 net24_8 net73 0.00130626f
C1998 net24_9 net73 0.00314067f
C1999 net26 net27_2 0.0125964f
C2000 net26 net27_3 0.0136735f
C2001 net26 net27_4 0.0137739f
C2002 net26_2 net27_7 0.00275053f
C2003 net26_2 net27_9 0.0132263f
C2004 net26_3 net27_11 0.00851172f
C2005 net26_3 net27_8 0.00550105f
C2006 net26_4 net27_5 0.00550105f
C2007 net26_6 net27_6 0.00550105f
C2008 net26_7 net27 0.0145194f
C2009 net27 net74 0.00344773f
C2010 net27_11 net74 0.00202117f
C2011 net27_2 net74 0.00299111f
C2012 net27_3 net74 0.00324688f
C2013 net27_4 net74 0.00327072f
C2014 net27_5 net74 0.00130626f
C2015 net27_6 net74 0.00130626f
C2016 net27_7 net74 0.000653132f
C2017 net27_8 net74 0.00130626f
C2018 net27_9 net74 0.00314067f
C2019 net30 net31_2 0.0125898f
C2020 net30 net31_3 0.0136664f
C2021 net30 net31_4 0.0137667f
C2022 net30_2 net31_7 0.00274909f
C2023 net30_2 net31_9 0.0132193f
C2024 net30_3 net31_11 0.00850727f
C2025 net30_3 net31_8 0.00549818f
C2026 net30_4 net31_5 0.00549818f
C2027 net30_6 net31_6 0.00549818f
C2028 net30_7 net31 0.0145118f
C2029 net31 net75 0.00343493f
C2030 net31_11 net75 0.00201366f
C2031 net31_2 net75 0.00298001f
C2032 net31_3 net75 0.00323482f
C2033 net31_4 net75 0.00325857f
C2034 net31_5 net75 0.00130141f
C2035 net31_6 net75 0.00130141f
C2036 net31_7 net75 0.000650707f
C2037 net31_8 net75 0.00130141f
C2038 net31_9 net75 0.00312901f
C2039 net4 net5_2 0.0126391f
C2040 net4 net5_3 0.0137199f
C2041 net4 net5_4 0.0138206f
C2042 net4_2 net5_7 0.00275985f
C2043 net4_2 net5_9 0.0132711f
C2044 net4_3 net5_11 0.00854057f
C2045 net4_3 net5_8 0.00551969f
C2046 net4_4 net5_5 0.00551969f
C2047 net4_6 net5_6 0.00551969f
C2048 net4_7 net5 0.0145686f
C2049 net5 net68 0.00343543f
C2050 net5_11 net68 0.00201396f
C2051 net5_2 net68 0.00298044f
C2052 net5_3 net68 0.00323529f
C2053 net5_4 net68 0.00325905f
C2054 net5_5 net68 0.0013016f
C2055 net5_6 net68 0.0013016f
C2056 net5_7 net68 0.000650802f
C2057 net5_8 net68 0.0013016f
C2058 net5_9 net68 0.00312946f
C2059 net69 net9 0.00344773f
C2060 net69 net9_11 0.00202117f
C2061 net69 net9_2 0.00299111f
C2062 net69 net9_3 0.00324688f
C2063 net69 net9_4 0.00327072f
C2064 net69 net9_5 0.00130626f
C2065 net69 net9_6 0.00130626f
C2066 net69 net9_7 0.000653132f
C2067 net69 net9_8 0.00130626f
C2068 net69 net9_9 0.00314067f
C2069 net8 net9_2 0.0125964f
C2070 net8 net9_3 0.0136735f
C2071 net8 net9_4 0.0137739f
C2072 net8_2 net9_7 0.00275053f
C2073 net8_2 net9_9 0.0132263f
C2074 net8_3 net9_11 0.00851172f
C2075 net8_3 net9_8 0.00550105f
C2076 net8_4 net9_5 0.00550105f
C2077 net8_6 net9_6 0.00550105f
C2078 net8_7 net9 0.0145194f
.ends
