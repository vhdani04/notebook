* A2x8 - parasitic extraction by OpenLayout (openlayout pex, mode rc)
* layout: /tmp/xs/a2x8.gds
* C: FasterCap 3D field solver (k = 4.6 front end, 3.23 above z = 0.074 um); R: KLayout RNetExtractor, reference sheet / via resistances
* 160 transistors, 446 resistors, 10749 capacitors
* total capacitance per net (fF): BLB_0 0.2355, BLB_1 0.2359, BLB_2 0.2357, BLB_3 0.2361, BLB_4 0.2358, BLB_5 0.2362, BLB_6 0.2358, BLB_7 0.2323, BL_0 0.1678, BL_1 0.1744, BL_2 0.1742, BL_3 0.1744, BL_4 0.1747, BL_5 0.1746, BL_6 0.1752, BL_7 0.1744, P_0_0 0.1916, P_0_1 0.1915, P_0_2 0.1916, P_0_3 0.1916, P_0_4 0.1920, P_0_5 0.1918, P_0_6 0.1924, P_0_7 0.1912, P_1_0 0.1928, P_1_1 0.1929, P_1_2 0.1931, P_1_3 0.1939, P_1_4 0.1932, P_1_5 0.1935, P_1_6 0.1928, P_1_7 0.1922, VDD_1 2.3545, VSS_0 6.7128, VSS_2 1.6024, WL_0 2.6742, WL_1 2.6782, XB_0_0 0.1701, XB_0_1 0.1708, XB_0_2 0.1697, XB_0_3 0.1716, XB_0_4 0.1704, XB_0_5 0.1708, XB_0_6 0.1716, XB_0_7 0.1703, XB_1_0 0.1714, XB_1_1 0.1714, XB_1_2 0.1705, XB_1_3 0.1716, XB_1_4 0.1710, XB_1_5 0.1708, XB_1_6 0.1715, XB_1_7 0.1718, net10 0.2577, net11 0.4686, net13 0.2585, net130 0.4681, net132 0.4690, net134 0.4684, net135 0.4700, net137 0.4703, net139 0.4691, net14 0.4703, net141 0.4701, net142 0.4713, net16 0.2578, net17 0.4698, net19 0.2569, net2 0.2565, net20 0.4693, net23 0.2582, net24 0.4697, net27 0.2575, net28 0.4690, net3 0.4671, net6 0.2578, net67 0.0594, net68 0.0591, net69 0.0589, net7 0.4693, net70 0.0592, net71 0.0590, net72 0.0593, net73 0.0596, net74 0.0592, net76 0.2565, net78 0.0583, net79 0.2567, net80 0.0586, net81 0.2568, net83 0.0587, net84 0.2574, net85 0.0587, net86 0.2569, net87 0.0586, net88 0.2562, net90 0.0587, net91 0.2573, net93 0.0592, net94 0.2567, net96 0.0587

.subckt A2x8 BLB_0 BLB_1 BLB_2 BLB_3 BLB_4 BLB_5 BLB_6 BLB_7 BL_0 BL_1 BL_2 BL_3 BL_4 BL_5 BL_6 BL_7 P_0_0 P_0_1 P_0_2 P_0_3 P_0_4 P_0_5 P_0_6 P_0_7 P_1_0 P_1_1 P_1_2 P_1_3 P_1_4 P_1_5 P_1_6 P_1_7 VDD_1 VSS_0 VSS_2 WL_0 WL_1 XB_0_0 XB_0_1 XB_0_2 XB_0_3 XB_0_4 XB_0_5 XB_0_6 XB_0_7 XB_1_0 XB_1_1 XB_1_2 XB_1_3 XB_1_4 XB_1_5 XB_1_6 XB_1_7
N1 net2_4 WL_0_16 BL_0_1 VSS_0 nmos_sram l=20n nfin=2
N2 VSS_0 net3_5 net2_4 VSS_0 nmos_sram l=20n nfin=2
N3 net3_9 net2_2 VSS_0 VSS_0 nmos_sram l=20n nfin=2
N4 BLB_0_1 WL_0_17 net3_9 VSS_0 nmos_sram l=20n nfin=2
N5 VSS_0 net3_7 P_0_0_3 VSS_0 nmos_sram l=20n nfin=1
N6 P_0_0_4 XB_0_0_2 VSS_0 VSS_0 nmos_sram l=20n nfin=1
N7 net6_4 WL_0_18 BL_1_1 VSS_0 nmos_sram l=20n nfin=2
N8 VSS_0 net7_5 net6_4 VSS_0 nmos_sram l=20n nfin=2
N9 net7_9 net6_2 VSS_0 VSS_0 nmos_sram l=20n nfin=2
N10 BLB_1_1 WL_0_19 net7_9 VSS_0 nmos_sram l=20n nfin=2
N11 VSS_0 net7_7 P_0_1_3 VSS_0 nmos_sram l=20n nfin=1
N12 P_0_1_4 XB_0_1_2 VSS_0 VSS_0 nmos_sram l=20n nfin=1
N13 net10_4 WL_0_20 BL_2_1 VSS_0 nmos_sram l=20n nfin=2
N14 VSS_0 net11_5 net10_4 VSS_0 nmos_sram l=20n nfin=2
N15 net11_9 net10_2 VSS_0 VSS_0 nmos_sram l=20n nfin=2
N16 BLB_2_1 WL_0_21 net11_9 VSS_0 nmos_sram l=20n nfin=2
N17 VSS_0 net11_7 P_0_2_3 VSS_0 nmos_sram l=20n nfin=1
N18 P_0_2_4 XB_0_2_2 VSS_0 VSS_0 nmos_sram l=20n nfin=1
N19 net13_4 WL_0_22 BL_3_1 VSS_0 nmos_sram l=20n nfin=2
N20 VSS_0 net14_5 net13_4 VSS_0 nmos_sram l=20n nfin=2
N21 net14_9 net13_2 VSS_0 VSS_0 nmos_sram l=20n nfin=2
N22 BLB_3_1 WL_0_23 net14_9 VSS_0 nmos_sram l=20n nfin=2
N23 VSS_0 net14_7 P_0_3_3 VSS_0 nmos_sram l=20n nfin=1
N24 P_0_3_4 XB_0_3_2 VSS_0 VSS_0 nmos_sram l=20n nfin=1
N25 net16_4 WL_0_24 BL_4_1 VSS_0 nmos_sram l=20n nfin=2
N26 VSS_0 net17_5 net16_4 VSS_0 nmos_sram l=20n nfin=2
N27 net17_9 net16_2 VSS_0 VSS_0 nmos_sram l=20n nfin=2
N28 BLB_4_1 WL_0_25 net17_9 VSS_0 nmos_sram l=20n nfin=2
N29 VSS_0 net17_7 P_0_4_3 VSS_0 nmos_sram l=20n nfin=1
N30 P_0_4_4 XB_0_4_2 VSS_0 VSS_0 nmos_sram l=20n nfin=1
N31 net19_4 WL_0_26 BL_5_1 VSS_0 nmos_sram l=20n nfin=2
N32 VSS_0 net20_5 net19_4 VSS_0 nmos_sram l=20n nfin=2
N33 net20_9 net19_2 VSS_0 VSS_0 nmos_sram l=20n nfin=2
N34 BLB_5_1 WL_0_27 net20_9 VSS_0 nmos_sram l=20n nfin=2
N35 VSS_0 net20_7 P_0_5_3 VSS_0 nmos_sram l=20n nfin=1
N36 P_0_5_4 XB_0_5_2 VSS_0 VSS_0 nmos_sram l=20n nfin=1
N37 net23_4 WL_0_28 BL_6_1 VSS_0 nmos_sram l=20n nfin=2
N38 VSS_0 net24_5 net23_4 VSS_0 nmos_sram l=20n nfin=2
N39 net24_9 net23_2 VSS_0 VSS_0 nmos_sram l=20n nfin=2
N40 BLB_6_1 WL_0_29 net24_9 VSS_0 nmos_sram l=20n nfin=2
N41 VSS_0 net24_7 P_0_6_3 VSS_0 nmos_sram l=20n nfin=1
N42 P_0_6_4 XB_0_6_2 VSS_0 VSS_0 nmos_sram l=20n nfin=1
N43 net27_4 WL_0_30 BL_7_1 VSS_0 nmos_sram l=20n nfin=2
N44 VSS_0 net28_5 net27_4 VSS_0 nmos_sram l=20n nfin=2
N45 net28_9 net27_2 VSS_0 VSS_0 nmos_sram l=20n nfin=2
N46 BLB_7_1 WL_0_31 net28_9 VSS_0 nmos_sram l=20n nfin=2
N47 VSS_0 net28_7 P_0_7_3 VSS_0 nmos_sram l=20n nfin=1
N48 P_0_7_4 XB_0_7_2 VSS_0 VSS_0 nmos_sram l=20n nfin=1
N49 net76_5 WL_1_16 BL_0_2 VSS_0 nmos_sram l=20n nfin=2
N50 VSS_2 net130_5 net76_5 VSS_0 nmos_sram l=20n nfin=2
N51 net130_10 net76_2 VSS_2 VSS_0 nmos_sram l=20n nfin=2
N52 BLB_0_2 WL_1_17 net130_10 VSS_0 nmos_sram l=20n nfin=2
N53 net79_5 WL_1_18 BL_1_2 VSS_0 nmos_sram l=20n nfin=2
N54 VSS_2 net132_5 net79_5 VSS_0 nmos_sram l=20n nfin=2
N55 net132_10 net79_2 VSS_2 VSS_0 nmos_sram l=20n nfin=2
N56 BLB_1_2 WL_1_19 net132_10 VSS_0 nmos_sram l=20n nfin=2
N57 net81_5 WL_1_20 BL_2_2 VSS_0 nmos_sram l=20n nfin=2
N58 VSS_2 net134_5 net81_5 VSS_0 nmos_sram l=20n nfin=2
N59 net134_10 net81_2 VSS_2 VSS_0 nmos_sram l=20n nfin=2
N60 BLB_2_2 WL_1_21 net134_10 VSS_0 nmos_sram l=20n nfin=2
N61 net84_5 WL_1_22 BL_3_2 VSS_0 nmos_sram l=20n nfin=2
N62 VSS_2 net135_5 net84_5 VSS_0 nmos_sram l=20n nfin=2
N63 net135_10 net84_2 VSS_2 VSS_0 nmos_sram l=20n nfin=2
N64 BLB_3_2 WL_1_23 net135_10 VSS_0 nmos_sram l=20n nfin=2
N65 net86_5 WL_1_24 BL_4_2 VSS_0 nmos_sram l=20n nfin=2
N66 VSS_2 net137_5 net86_5 VSS_0 nmos_sram l=20n nfin=2
N67 net137_10 net86_2 VSS_2 VSS_0 nmos_sram l=20n nfin=2
N68 BLB_4_2 WL_1_25 net137_10 VSS_0 nmos_sram l=20n nfin=2
N69 net88_5 WL_1_26 BL_5_2 VSS_0 nmos_sram l=20n nfin=2
N70 VSS_2 net139_5 net88_5 VSS_0 nmos_sram l=20n nfin=2
N71 net139_10 net88_2 VSS_2 VSS_0 nmos_sram l=20n nfin=2
N72 BLB_5_2 WL_1_27 net139_10 VSS_0 nmos_sram l=20n nfin=2
N73 net91_5 WL_1_28 BL_6_2 VSS_0 nmos_sram l=20n nfin=2
N74 VSS_2 net141_5 net91_5 VSS_0 nmos_sram l=20n nfin=2
N75 net141_10 net91_2 VSS_2 VSS_0 nmos_sram l=20n nfin=2
N76 BLB_6_2 WL_1_29 net141_10 VSS_0 nmos_sram l=20n nfin=2
N77 net94_5 WL_1_30 BL_7_2 VSS_0 nmos_sram l=20n nfin=2
N78 VSS_2 net142_5 net94_5 VSS_0 nmos_sram l=20n nfin=2
N79 net142_10 net94_2 VSS_2 VSS_0 nmos_sram l=20n nfin=2
N80 BLB_7_2 WL_1_31 net142_10 VSS_0 nmos_sram l=20n nfin=2
N81 VSS_2 net130_7 P_1_0_4 VSS_0 nmos_sram l=20n nfin=1
N82 P_1_0_5 XB_1_0_2 VSS_2 VSS_0 nmos_sram l=20n nfin=1
N83 VSS_2 net132_7 P_1_1_4 VSS_0 nmos_sram l=20n nfin=1
N84 P_1_1_5 XB_1_1_2 VSS_2 VSS_0 nmos_sram l=20n nfin=1
N85 VSS_2 net134_7 P_1_2_4 VSS_0 nmos_sram l=20n nfin=1
N86 P_1_2_5 XB_1_2_2 VSS_2 VSS_0 nmos_sram l=20n nfin=1
N87 VSS_2 net135_7 P_1_3_4 VSS_0 nmos_sram l=20n nfin=1
N88 P_1_3_5 XB_1_3_2 VSS_2 VSS_0 nmos_sram l=20n nfin=1
N89 VSS_2 net137_7 P_1_4_4 VSS_0 nmos_sram l=20n nfin=1
N90 P_1_4_5 XB_1_4_2 VSS_2 VSS_0 nmos_sram l=20n nfin=1
N91 VSS_2 net139_7 P_1_5_4 VSS_0 nmos_sram l=20n nfin=1
N92 P_1_5_5 XB_1_5_2 VSS_2 VSS_0 nmos_sram l=20n nfin=1
N93 VSS_2 net141_7 P_1_6_4 VSS_0 nmos_sram l=20n nfin=1
N94 P_1_6_5 XB_1_6_2 VSS_2 VSS_0 nmos_sram l=20n nfin=1
N95 VSS_2 net142_7 P_1_7_4 VSS_0 nmos_sram l=20n nfin=1
N96 P_1_7_5 XB_1_7_2 VSS_2 VSS_0 nmos_sram l=20n nfin=1
N97 VDD_1 net3_6 net2_6 VDD_1 pmos_sram l=20n nfin=1
N98 net3_11 net2_3 VDD_1 VDD_1 pmos_sram l=20n nfin=1
N99 net67 net3_8 P_0_0_5 VDD_1 pmos_sram l=20n nfin=2
N100 VDD_1 XB_0_0_3 net67 VDD_1 pmos_sram l=20n nfin=2
N101 VDD_1 net7_6 net6_6 VDD_1 pmos_sram l=20n nfin=1
N102 net7_11 net6_3 VDD_1 VDD_1 pmos_sram l=20n nfin=1
N103 net68 net7_8 P_0_1_5 VDD_1 pmos_sram l=20n nfin=2
N104 VDD_1 XB_0_1_3 net68 VDD_1 pmos_sram l=20n nfin=2
N105 VDD_1 net11_6 net10_6 VDD_1 pmos_sram l=20n nfin=1
N106 net11_11 net10_3 VDD_1 VDD_1 pmos_sram l=20n nfin=1
N107 net69 net11_8 P_0_2_5 VDD_1 pmos_sram l=20n nfin=2
N108 VDD_1 XB_0_2_3 net69 VDD_1 pmos_sram l=20n nfin=2
N109 VDD_1 net14_6 net13_6 VDD_1 pmos_sram l=20n nfin=1
N110 net14_11 net13_3 VDD_1 VDD_1 pmos_sram l=20n nfin=1
N111 net70 net14_8 P_0_3_5 VDD_1 pmos_sram l=20n nfin=2
N112 VDD_1 XB_0_3_3 net70 VDD_1 pmos_sram l=20n nfin=2
N113 VDD_1 net17_6 net16_6 VDD_1 pmos_sram l=20n nfin=1
N114 net17_11 net16_3 VDD_1 VDD_1 pmos_sram l=20n nfin=1
N115 net71 net17_8 P_0_4_5 VDD_1 pmos_sram l=20n nfin=2
N116 VDD_1 XB_0_4_3 net71 VDD_1 pmos_sram l=20n nfin=2
N117 VDD_1 net20_6 net19_6 VDD_1 pmos_sram l=20n nfin=1
N118 net20_11 net19_3 VDD_1 VDD_1 pmos_sram l=20n nfin=1
N119 net72 net20_8 P_0_5_5 VDD_1 pmos_sram l=20n nfin=2
N120 VDD_1 XB_0_5_3 net72 VDD_1 pmos_sram l=20n nfin=2
N121 VDD_1 net24_6 net23_6 VDD_1 pmos_sram l=20n nfin=1
N122 net24_11 net23_3 VDD_1 VDD_1 pmos_sram l=20n nfin=1
N123 net73 net24_8 P_0_6_5 VDD_1 pmos_sram l=20n nfin=2
N124 VDD_1 XB_0_6_3 net73 VDD_1 pmos_sram l=20n nfin=2
N125 VDD_1 net28_6 net27_6 VDD_1 pmos_sram l=20n nfin=1
N126 net28_11 net27_3 VDD_1 VDD_1 pmos_sram l=20n nfin=1
N127 net74 net28_8 P_0_7_5 VDD_1 pmos_sram l=20n nfin=2
N128 VDD_1 XB_0_7_3 net74 VDD_1 pmos_sram l=20n nfin=2
N129 VDD_1 net130_6 net76_4 VDD_1 pmos_sram l=20n nfin=1
N130 net130_9 net76_3 VDD_1 VDD_1 pmos_sram l=20n nfin=1
N131 net78 net130_8 P_1_0_3 VDD_1 pmos_sram l=20n nfin=2
N132 VDD_1 XB_1_0_3 net78 VDD_1 pmos_sram l=20n nfin=2
N133 VDD_1 net132_6 net79_4 VDD_1 pmos_sram l=20n nfin=1
N134 net132_9 net79_3 VDD_1 VDD_1 pmos_sram l=20n nfin=1
N135 net80 net132_8 P_1_1_3 VDD_1 pmos_sram l=20n nfin=2
N136 VDD_1 XB_1_1_3 net80 VDD_1 pmos_sram l=20n nfin=2
N137 VDD_1 net134_6 net81_4 VDD_1 pmos_sram l=20n nfin=1
N138 net134_9 net81_3 VDD_1 VDD_1 pmos_sram l=20n nfin=1
N139 net83 net134_8 P_1_2_3 VDD_1 pmos_sram l=20n nfin=2
N140 VDD_1 XB_1_2_3 net83 VDD_1 pmos_sram l=20n nfin=2
N141 VDD_1 net135_6 net84_4 VDD_1 pmos_sram l=20n nfin=1
N142 net135_9 net84_3 VDD_1 VDD_1 pmos_sram l=20n nfin=1
N143 net85 net135_8 P_1_3_3 VDD_1 pmos_sram l=20n nfin=2
N144 VDD_1 XB_1_3_3 net85 VDD_1 pmos_sram l=20n nfin=2
N145 VDD_1 net137_6 net86_4 VDD_1 pmos_sram l=20n nfin=1
N146 net137_9 net86_3 VDD_1 VDD_1 pmos_sram l=20n nfin=1
N147 net87 net137_8 P_1_4_3 VDD_1 pmos_sram l=20n nfin=2
N148 VDD_1 XB_1_4_3 net87 VDD_1 pmos_sram l=20n nfin=2
N149 VDD_1 net139_6 net88_4 VDD_1 pmos_sram l=20n nfin=1
N150 net139_9 net88_3 VDD_1 VDD_1 pmos_sram l=20n nfin=1
N151 net90 net139_8 P_1_5_3 VDD_1 pmos_sram l=20n nfin=2
N152 VDD_1 XB_1_5_3 net90 VDD_1 pmos_sram l=20n nfin=2
N153 VDD_1 net141_6 net91_4 VDD_1 pmos_sram l=20n nfin=1
N154 net141_9 net91_3 VDD_1 VDD_1 pmos_sram l=20n nfin=1
N155 net93 net141_8 P_1_6_3 VDD_1 pmos_sram l=20n nfin=2
N156 VDD_1 XB_1_6_3 net93 VDD_1 pmos_sram l=20n nfin=2
N157 VDD_1 net142_6 net94_4 VDD_1 pmos_sram l=20n nfin=1
N158 net142_9 net94_3 VDD_1 VDD_1 pmos_sram l=20n nfin=1
N159 net96 net142_8 P_1_7_3 VDD_1 pmos_sram l=20n nfin=2
N160 VDD_1 XB_1_7_3 net96 VDD_1 pmos_sram l=20n nfin=2
R1 net2_3 net2 34.1846
R2 net2 net2_2 25.5109
R3 net2_4 net2_7 39.8169
R4 net2_6 net2_7 43.642
R5 net2_7 net2 44.6984
R6 net3_6 net3 34.1846
R7 net3 net3_5 25.5109
R8 net3_8 net3_2 29.5926
R9 net3_2 net3_7 30.1028
R10 net3_4 net3_3 6.2952
R11 net3 net3_4 127.497
R12 net3_2 net3_3 90.749
R13 net3_9 net3_4 98.7906
R14 net3_3 net3_11 70.7246
R15 BLB_0_1 BLB_0 151.187
R16 BLB_0_2 BLB_0 174.968
R17 BL_1 BL_1_1 68.2426
R18 BL_1 BL_1_2 149.381
R19 net6_3 net6 34.1846
R20 net6 net6_2 25.5109
R21 net6_4 net6_7 39.8169
R22 net6_6 net6_7 43.642
R23 net6_7 net6 44.6984
R24 net7_6 net7 34.1846
R25 net7 net7_5 25.5109
R26 net7_8 net7_2 29.5926
R27 net7_2 net7_7 30.1028
R28 net7_4 net7_3 6.2952
R29 net7 net7_4 127.497
R30 net7_2 net7_3 90.749
R31 net7_9 net7_4 98.7906
R32 net7_3 net7_11 70.7246
R33 BLB_1_1 BLB_1 151.187
R34 BLB_1_2 BLB_1 174.968
R35 BL_2 BL_2_1 68.2426
R36 BL_2 BL_2_2 149.381
R37 net10_3 net10 34.1846
R38 net10 net10_2 25.5109
R39 net10_4 net10_7 39.8169
R40 net10_6 net10_7 43.642
R41 net10_7 net10 44.6984
R42 net11_6 net11 34.1846
R43 net11 net11_5 25.5109
R44 net11_8 net11_2 29.5926
R45 net11_2 net11_7 30.1028
R46 net11_4 net11_3 6.2952
R47 net11 net11_4 127.497
R48 net11_2 net11_3 90.749
R49 net11_9 net11_4 98.7906
R50 net11_3 net11_11 70.7246
R51 BLB_2_1 BLB_2 151.187
R52 BLB_2_2 BLB_2 174.968
R53 net13_3 net13 34.1846
R54 net13 net13_2 25.5109
R55 net13_4 net13_7 39.8169
R56 net13_6 net13_7 43.642
R57 net13_7 net13 44.6984
R58 net14_6 net14 34.1846
R59 net14 net14_5 25.5109
R60 net14_8 net14_2 29.5926
R61 net14_2 net14_7 30.1028
R62 net14_4 net14_3 6.2952
R63 net14 net14_4 127.497
R64 net14_2 net14_3 90.749
R65 net14_9 net14_4 98.7906
R66 net14_3 net14_11 70.7246
R67 BLB_3_1 BLB_3 151.187
R68 BLB_3_2 BLB_3 174.968
R69 net16_3 net16 34.1846
R70 net16 net16_2 25.5109
R71 net16_4 net16_7 39.8169
R72 net16_6 net16_7 43.642
R73 net16_7 net16 44.6984
R74 net17_6 net17 34.1846
R75 net17 net17_5 25.5109
R76 net17_8 net17_2 29.5926
R77 net17_2 net17_7 30.1028
R78 net17_4 net17_3 6.2952
R79 net17 net17_4 127.497
R80 net17_2 net17_3 90.749
R81 net17_9 net17_4 98.7906
R82 net17_3 net17_11 70.7246
R83 BLB_4_1 BLB_4 151.187
R84 BLB_4_2 BLB_4 174.968
R85 net19_3 net19 34.1846
R86 net19 net19_2 25.5109
R87 net19_4 net19_7 39.8169
R88 net19_6 net19_7 43.642
R89 net19_7 net19 44.6984
R90 net20_6 net20 34.1846
R91 net20 net20_5 25.5109
R92 net20_8 net20_2 29.5926
R93 net20_2 net20_7 30.1028
R94 net20_4 net20_3 6.2952
R95 net20 net20_4 127.497
R96 net20_2 net20_3 90.749
R97 net20_9 net20_4 98.7906
R98 net20_3 net20_11 70.7246
R99 BLB_5_1 BLB_5 151.187
R100 BLB_5_2 BLB_5 174.968
R101 BL_6 BL_6_1 68.2426
R102 BL_6 BL_6_2 149.381
R103 net23_3 net23 34.1846
R104 net23 net23_2 25.5109
R105 net23_4 net23_7 39.8169
R106 net23_6 net23_7 43.642
R107 net23_7 net23 44.6984
R108 net24_6 net24 34.1846
R109 net24 net24_5 25.5109
R110 net24_8 net24_2 29.5926
R111 net24_2 net24_7 30.1028
R112 net24_4 net24_3 6.2952
R113 net24 net24_4 127.497
R114 net24_2 net24_3 90.749
R115 net24_9 net24_4 98.7906
R116 net24_3 net24_11 70.7246
R117 BLB_6_1 BLB_6 151.187
R118 BLB_6_2 BLB_6 174.968
R119 BL_7 BL_7_1 68.2426
R120 BL_7 BL_7_2 149.381
R121 net27_3 net27 34.1846
R122 net27 net27_2 25.5109
R123 net27_4 net27_7 39.8169
R124 net27_6 net27_7 43.642
R125 net27_7 net27 44.6984
R126 net28_6 net28 34.1846
R127 net28 net28_5 25.5109
R128 net28_8 net28_2 29.5926
R129 net28_2 net28_7 30.1028
R130 net28_4 net28_3 6.2952
R131 net28 net28_4 127.497
R132 net28_2 net28_3 90.749
R133 net28_9 net28_4 98.7906
R134 net28_3 net28_11 70.7246
R135 BLB_7_1 BLB_7 151.187
R136 BLB_7_2 BLB_7 174.968
R137 BL_0 BL_0_1 68.2426
R138 BL_0 BL_0_2 149.381
R139 P_0_0_1 P_0_0_2 27.5015
R140 P_0_0_1 P_0_0_3 20.424
R141 P_0_0_4 P_0_0_1 45.6048
R142 P_0_0_5 P_0_0_2 68.5329
R143 P_0_0 P_0_0_2 43.5
R144 XB_0_0_3 XB_0_0_1 36.7357
R145 XB_0_0_1 XB_0_0_2 22.9598
R146 XB_0_0 XB_0_0_1 109.677
R147 P_0_1_1 P_0_1_2 27.5015
R148 P_0_1_1 P_0_1_3 20.424
R149 P_0_1_4 P_0_1_1 45.6048
R150 P_0_1_5 P_0_1_2 68.5329
R151 P_0_1 P_0_1_2 43.5
R152 XB_0_1_3 XB_0_1_1 36.7357
R153 XB_0_1_1 XB_0_1_2 22.9598
R154 XB_0_1 XB_0_1_1 109.677
R155 P_0_2_2 P_0_2_1 27.5015
R156 P_0_2_1 P_0_2_3 20.424
R157 P_0_2_4 P_0_2_1 45.6048
R158 P_0_2_5 P_0_2_2 68.5329
R159 P_0_2 P_0_2_2 43.5
R160 XB_0_2_3 XB_0_2_1 36.7357
R161 XB_0_2_1 XB_0_2_2 22.9598
R162 XB_0_2 XB_0_2_1 109.677
R163 BL_3 BL_3_1 68.2426
R164 BL_3 BL_3_2 149.381
R165 P_0_3_1 P_0_3_2 27.5015
R166 P_0_3_1 P_0_3_3 20.424
R167 P_0_3_4 P_0_3_1 45.6048
R168 P_0_3_5 P_0_3_2 68.5329
R169 P_0_3 P_0_3_2 43.5
R170 XB_0_3_3 XB_0_3_1 36.7357
R171 XB_0_3_1 XB_0_3_2 22.9598
R172 XB_0_3 XB_0_3_1 109.677
R173 BL_4 BL_4_1 68.2426
R174 BL_4 BL_4_2 149.381
R175 P_0_4_2 P_0_4_1 27.5015
R176 P_0_4_1 P_0_4_3 20.424
R177 P_0_4_4 P_0_4_1 45.6048
R178 P_0_4_5 P_0_4_2 68.5329
R179 P_0_4 P_0_4_2 43.5
R180 XB_0_4_3 XB_0_4_1 36.7357
R181 XB_0_4_1 XB_0_4_2 22.9598
R182 XB_0_4 XB_0_4_1 109.677
R183 BL_5 BL_5_1 68.2426
R184 BL_5 BL_5_2 149.381
R185 P_0_5_1 P_0_5_2 27.5015
R186 P_0_5_1 P_0_5_3 20.424
R187 P_0_5_4 P_0_5_1 45.6048
R188 P_0_5_5 P_0_5_2 68.5329
R189 P_0_5 P_0_5_2 43.5
R190 XB_0_5_3 XB_0_5_1 36.7357
R191 XB_0_5_1 XB_0_5_2 22.9598
R192 XB_0_5 XB_0_5_1 109.677
R193 P_0_6_1 P_0_6_2 27.5015
R194 P_0_6_1 P_0_6_3 20.424
R195 P_0_6_4 P_0_6_1 45.6048
R196 P_0_6_5 P_0_6_2 68.5329
R197 P_0_6 P_0_6_2 43.5
R198 XB_0_6_3 XB_0_6_1 36.7357
R199 XB_0_6_1 XB_0_6_2 22.9598
R200 XB_0_6 XB_0_6_1 109.677
R201 P_0_7_1 P_0_7_2 27.5015
R202 P_0_7_1 P_0_7_3 20.424
R203 P_0_7_4 P_0_7_1 45.6048
R204 P_0_7_5 P_0_7_2 68.5329
R205 P_0_7 P_0_7_2 43.5
R206 XB_0_7_3 XB_0_7_1 36.7357
R207 XB_0_7_1 XB_0_7_2 22.9598
R208 XB_0_7 XB_0_7_1 109.677
R209 WL_0 WL_0_9 35.4396
R210 WL_0_9 WL_0_10 125.904
R211 WL_0_10 WL_0_11 125.904
R212 WL_0_11 WL_0_12 125.904
R213 WL_0_12 WL_0_13 125.904
R214 WL_0_13 WL_0_14 125.904
R215 WL_0_14 WL_0_15 125.904
R216 WL_0_1 WL_0_9 38.915
R217 WL_0_2 WL_0_10 38.915
R218 WL_0_3 WL_0_11 38.915
R219 WL_0_4 WL_0_12 38.915
R220 WL_0_5 WL_0_13 38.915
R221 WL_0_6 WL_0_14 38.915
R222 WL_0_7 WL_0_15 38.915
R223 WL_0_16 WL_0_1 83.7722
R224 WL_0_17 WL_0_1 84.6073
R225 WL_0_18 WL_0_2 83.7722
R226 WL_0_19 WL_0_2 84.6073
R227 WL_0_20 WL_0_3 83.7722
R228 WL_0_21 WL_0_3 84.6073
R229 WL_0_22 WL_0_4 83.7722
R230 WL_0_23 WL_0_4 84.6073
R231 WL_0_24 WL_0_5 83.7722
R232 WL_0_25 WL_0_5 84.6073
R233 WL_0_26 WL_0_6 83.7722
R234 WL_0_27 WL_0_6 84.6073
R235 WL_0_28 WL_0_7 83.7722
R236 WL_0_29 WL_0_7 84.6073
R237 WL_0_30 WL_0_8 83.7722
R238 WL_0_31 WL_0_8 84.6073
R239 WL_0_15 WL_0_8 164.819
R240 net76_2 net76 25.5109
R241 net76 net76_3 34.1846
R242 net76_4 net76_7 43.642
R243 net76_5 net76_7 39.8169
R244 net76_7 net76 44.6984
R245 P_1_0_2 P_1_0_1 27.5015
R246 P_1_0_3 P_1_0_2 68.5329
R247 P_1_0_1 P_1_0_4 20.424
R248 P_1_0_5 P_1_0_1 45.6048
R249 P_1_0 P_1_0_2 43.5
R250 net79_2 net79 25.5109
R251 net79 net79_3 34.1846
R252 net79_4 net79_7 43.642
R253 net79_5 net79_7 39.8169
R254 net79_7 net79 44.6984
R255 net81_2 net81 25.5109
R256 net81 net81_3 34.1846
R257 net81_4 net81_7 43.642
R258 net81_5 net81_7 39.8169
R259 net81_7 net81 44.6984
R260 P_1_2_2 P_1_2_1 27.5015
R261 P_1_2_3 P_1_2_2 68.5329
R262 P_1_2_1 P_1_2_4 20.424
R263 P_1_2_5 P_1_2_1 45.6048
R264 P_1_2 P_1_2_2 43.5
R265 net84_2 net84 25.5109
R266 net84 net84_3 34.1846
R267 net84_4 net84_7 43.642
R268 net84_5 net84_7 39.8169
R269 net84_7 net84 44.6984
R270 net86_2 net86 25.5109
R271 net86 net86_3 34.1846
R272 net86_4 net86_7 43.642
R273 net86_5 net86_7 39.8169
R274 net86_7 net86 44.6984
R275 net88_2 net88 25.5109
R276 net88 net88_3 34.1846
R277 net88_4 net88_7 43.642
R278 net88_5 net88_7 39.8169
R279 net88_7 net88 44.6984
R280 P_1_5_2 P_1_5_1 27.5015
R281 P_1_5_3 P_1_5_2 68.5329
R282 P_1_5_1 P_1_5_4 20.424
R283 P_1_5_5 P_1_5_1 45.6048
R284 P_1_5 P_1_5_2 43.5
R285 net91_2 net91 25.5109
R286 net91 net91_3 34.1846
R287 net91_4 net91_7 43.642
R288 net91_5 net91_7 39.8169
R289 net91_7 net91 44.6984
R290 P_1_6_2 P_1_6_1 27.5015
R291 P_1_6_3 P_1_6_2 68.5329
R292 P_1_6_1 P_1_6_4 20.424
R293 P_1_6_5 P_1_6_1 45.6048
R294 P_1_6 P_1_6_2 43.5
R295 net94_2 net94 25.5109
R296 net94 net94_3 34.1846
R297 net94_4 net94_7 43.642
R298 net94_5 net94_7 39.8169
R299 net94_7 net94 44.6984
R300 P_1_7_2 P_1_7_1 27.5015
R301 P_1_7_3 P_1_7_2 68.5329
R302 P_1_7_1 P_1_7_4 20.424
R303 P_1_7_5 P_1_7_1 45.6048
R304 P_1_7 P_1_7_2 43.5
R305 WL_1 WL_1_9 35.4396
R306 WL_1_9 WL_1_10 125.904
R307 WL_1_10 WL_1_11 125.904
R308 WL_1_11 WL_1_12 125.904
R309 WL_1_12 WL_1_13 125.904
R310 WL_1_13 WL_1_14 125.904
R311 WL_1_14 WL_1_15 125.904
R312 WL_1_1 WL_1_9 38.915
R313 WL_1_2 WL_1_10 38.915
R314 WL_1_3 WL_1_11 38.915
R315 WL_1_4 WL_1_12 38.915
R316 WL_1_5 WL_1_13 38.915
R317 WL_1_6 WL_1_14 38.915
R318 WL_1_7 WL_1_15 38.915
R319 WL_1_16 WL_1_1 83.7722
R320 WL_1_17 WL_1_1 84.6073
R321 WL_1_18 WL_1_2 83.7722
R322 WL_1_19 WL_1_2 84.6073
R323 WL_1_20 WL_1_3 83.7722
R324 WL_1_21 WL_1_3 84.6073
R325 WL_1_22 WL_1_4 83.7722
R326 WL_1_23 WL_1_4 84.6073
R327 WL_1_24 WL_1_5 83.7722
R328 WL_1_25 WL_1_5 84.6073
R329 WL_1_26 WL_1_6 83.7722
R330 WL_1_27 WL_1_6 84.6073
R331 WL_1_28 WL_1_7 83.7722
R332 WL_1_29 WL_1_7 84.6073
R333 WL_1_30 WL_1_8 83.7722
R334 WL_1_31 WL_1_8 84.6073
R335 WL_1_15 WL_1_8 164.819
R336 net130_5 net130 25.5109
R337 net130 net130_6 34.1846
R338 net130_7 net130_2 30.1028
R339 net130_2 net130_8 29.5926
R340 net130_4 net130_3 6.2952
R341 net130 net130_4 127.497
R342 net130_2 net130_3 90.749
R343 net130_3 net130_9 70.7246
R344 net130_10 net130_4 98.7906
R345 XB_1_0_2 XB_1_0_1 22.9598
R346 XB_1_0_1 XB_1_0_3 36.7357
R347 XB_1_0 XB_1_0_1 109.677
R348 net132_5 net132 25.5109
R349 net132 net132_6 34.1846
R350 net132_7 net132_2 30.1028
R351 net132_2 net132_8 29.5926
R352 net132_4 net132_3 6.2952
R353 net132 net132_4 127.497
R354 net132_2 net132_3 90.749
R355 net132_3 net132_9 70.7246
R356 net132_10 net132_4 98.7906
R357 XB_1_1_2 XB_1_1_1 22.9598
R358 XB_1_1_1 XB_1_1_3 36.7357
R359 XB_1_1 XB_1_1_1 109.677
R360 net134_5 net134 25.5109
R361 net134 net134_6 34.1846
R362 net134_7 net134_2 30.1028
R363 net134_2 net134_8 29.5926
R364 net134_4 net134_3 6.2952
R365 net134 net134_4 127.497
R366 net134_2 net134_3 90.749
R367 net134_3 net134_9 70.7246
R368 net134_10 net134_4 98.7906
R369 net135_5 net135 25.5109
R370 net135 net135_6 34.1846
R371 net135_7 net135_2 30.1028
R372 net135_2 net135_8 29.5926
R373 net135_4 net135_3 6.2952
R374 net135 net135_4 127.497
R375 net135_2 net135_3 90.749
R376 net135_3 net135_9 70.7246
R377 net135_10 net135_4 98.7906
R378 XB_1_3_2 XB_1_3_1 22.9598
R379 XB_1_3_1 XB_1_3_3 36.7357
R380 XB_1_3 XB_1_3_1 109.677
R381 net137_5 net137 25.5109
R382 net137 net137_6 34.1846
R383 net137_7 net137_2 30.1028
R384 net137_2 net137_8 29.5926
R385 net137_4 net137_3 6.2952
R386 net137 net137_4 127.497
R387 net137_2 net137_3 90.749
R388 net137_3 net137_9 70.7246
R389 net137_10 net137_4 98.7906
R390 XB_1_4_2 XB_1_4_1 22.9598
R391 XB_1_4_1 XB_1_4_3 36.7357
R392 XB_1_4 XB_1_4_1 109.677
R393 net139_5 net139 25.5109
R394 net139 net139_6 34.1846
R395 net139_7 net139_2 30.1028
R396 net139_2 net139_8 29.5926
R397 net139_4 net139_3 6.2952
R398 net139 net139_4 127.497
R399 net139_2 net139_3 90.749
R400 net139_3 net139_9 70.7246
R401 net139_10 net139_4 98.7906
R402 XB_1_5_2 XB_1_5_1 22.9598
R403 XB_1_5_1 XB_1_5_3 36.7357
R404 XB_1_5 XB_1_5_1 109.677
R405 net141_5 net141 25.5109
R406 net141 net141_6 34.1846
R407 net141_7 net141_2 30.1028
R408 net141_2 net141_8 29.5926
R409 net141_4 net141_3 6.2952
R410 net141 net141_4 127.497
R411 net141_2 net141_3 90.749
R412 net141_3 net141_9 70.7246
R413 net141_10 net141_4 98.7906
R414 net142_5 net142 25.5109
R415 net142 net142_6 34.1846
R416 net142_7 net142_2 30.1028
R417 net142_2 net142_8 29.5926
R418 net142_4 net142_3 6.2952
R419 net142 net142_4 127.497
R420 net142_2 net142_3 90.749
R421 net142_3 net142_9 70.7246
R422 net142_10 net142_4 98.7906
R423 XB_1_2_2 XB_1_2_1 22.9598
R424 XB_1_2_1 XB_1_2_3 36.7357
R425 XB_1_2 XB_1_2_1 109.677
R426 XB_1_6_2 XB_1_6_1 22.9598
R427 XB_1_6_1 XB_1_6_3 36.7357
R428 XB_1_6 XB_1_6_1 109.677
R429 XB_1_7_2 XB_1_7_1 22.9598
R430 XB_1_7_1 XB_1_7_3 36.7357
R431 XB_1_7 XB_1_7_1 109.677
R432 P_1_1_2 P_1_1_1 27.5015
R433 P_1_1_3 P_1_1_2 68.5329
R434 P_1_1_1 P_1_1_4 20.424
R435 P_1_1_5 P_1_1_1 45.6048
R436 P_1_1 P_1_1_2 43.5
R437 P_1_3_2 P_1_3_1 27.5015
R438 P_1_3_3 P_1_3_2 68.5329
R439 P_1_3_1 P_1_3_4 20.424
R440 P_1_3_5 P_1_3_1 45.6048
R441 P_1_3 P_1_3_2 43.5
R442 P_1_4_2 P_1_4_1 27.5015
R443 P_1_4_3 P_1_4_2 68.5329
R444 P_1_4_1 P_1_4_4 20.424
R445 P_1_4_5 P_1_4_1 45.6048
R446 P_1_4 P_1_4_2 43.5
C1 BLB_0 BLB_1_1 0.000172152f
C2 BLB_0 BLB_2_1 4.42418e-05f
C3 BLB_0 BLB_3_1 2.13131e-05f
C4 BLB_0 BLB_4_1 1.18825e-05f
C5 BLB_0 BL_0 0.000569485f
C6 BLB_0 BL_1 0.00525081f
C7 BLB_0 BL_2 8.11484e-05f
C8 BLB_0 BL_3 3.36177e-05f
C9 BLB_0 BL_4 1.24963e-05f
C10 BLB_0 P_0_0_4 0.0015646f
C11 BLB_0 P_0_0_5 0.00307287f
C12 BLB_0 P_0_1 1.56377e-05f
C13 BLB_0 P_0_1_1 3.34985e-05f
C14 BLB_0 P_0_1_2 6.09412e-05f
C15 BLB_0 P_0_1_4 1.36294e-05f
C16 BLB_0 P_0_1_5 2.67681e-05f
C17 BLB_0 P_0_2_2 1.44882e-05f
C18 BLB_0 P_1_0_3 0.00306769f
C19 BLB_0 P_1_1 1.73826e-05f
C20 BLB_0 P_1_1_1 3.72363e-05f
C21 BLB_0 P_1_1_2 6.77411e-05f
C22 BLB_0 P_1_1_3 2.97549e-05f
C23 BLB_0 P_1_1_5 1.51501e-05f
C24 BLB_0 P_1_2_2 1.61253e-05f
C25 BLB_0 VDD_1 0.000758184f
C26 BLB_0 VSS_0 0.025519f
C27 BLB_0 VSS_2 0.00640557f
C28 BLB_0 WL_0_10 0.00132266f
C29 BLB_0 WL_0_11 0.00120241f
C30 BLB_0 WL_0_12 0.00132266f
C31 BLB_0 WL_0_13 0.00132266f
C32 BLB_0 WL_0_14 0.00132266f
C33 BLB_0 WL_0_15 0.00288579f
C34 BLB_0 WL_0_18 0.000608073f
C35 BLB_0 WL_0_19 0.000608073f
C36 BLB_0 WL_0_2 0.000798566f
C37 BLB_0 WL_0_20 0.000608073f
C38 BLB_0 WL_0_21 0.000608073f
C39 BLB_0 WL_0_22 0.000608073f
C40 BLB_0 WL_0_23 0.000608073f
C41 BLB_0 WL_0_24 0.000608073f
C42 BLB_0 WL_0_25 0.000608073f
C43 BLB_0 WL_0_26 0.000608073f
C44 BLB_0 WL_0_27 0.000608073f
C45 BLB_0 WL_0_28 0.000608073f
C46 BLB_0 WL_0_29 0.000608073f
C47 BLB_0 WL_0_3 0.000798566f
C48 BLB_0 WL_0_30 0.000608073f
C49 BLB_0 WL_0_31 0.000608073f
C50 BLB_0 WL_0_4 0.000798566f
C51 BLB_0 WL_0_5 0.000798566f
C52 BLB_0 WL_0_6 0.000798566f
C53 BLB_0 WL_0_7 0.000798566f
C54 BLB_0 WL_0_8 0.000798566f
C55 BLB_0 WL_1_10 0.00133972f
C56 BLB_0 WL_1_11 0.00121793f
C57 BLB_0 WL_1_12 0.00133972f
C58 BLB_0 WL_1_13 0.00133972f
C59 BLB_0 WL_1_14 0.00133972f
C60 BLB_0 WL_1_15 0.00292303f
C61 BLB_0 WL_1_18 0.000615919f
C62 BLB_0 WL_1_19 0.000615919f
C63 BLB_0 WL_1_2 0.00080887f
C64 BLB_0 WL_1_20 0.000615919f
C65 BLB_0 WL_1_21 0.000615919f
C66 BLB_0 WL_1_22 0.000615919f
C67 BLB_0 WL_1_23 0.000615919f
C68 BLB_0 WL_1_24 0.000615919f
C69 BLB_0 WL_1_25 0.000615919f
C70 BLB_0 WL_1_26 0.000615919f
C71 BLB_0 WL_1_27 0.000615919f
C72 BLB_0 WL_1_28 0.000615919f
C73 BLB_0 WL_1_29 0.000615919f
C74 BLB_0 WL_1_3 0.00080887f
C75 BLB_0 WL_1_30 0.000615919f
C76 BLB_0 WL_1_31 0.000615919f
C77 BLB_0 WL_1_4 0.00080887f
C78 BLB_0 WL_1_5 0.00080887f
C79 BLB_0 WL_1_6 0.00080887f
C80 BLB_0 WL_1_7 0.00080887f
C81 BLB_0 WL_1_8 0.00080887f
C82 BLB_0 XB_0_0 0.00219806f
C83 BLB_0 XB_0_0_1 0.00918876f
C84 BLB_0 XB_0_0_2 0.00129872f
C85 BLB_0 XB_0_0_3 0.00259745f
C86 BLB_0 XB_1_0_3 0.00260685f
C87 BLB_0 net130_8 0.000603294f
C88 BLB_0 net132 0.000135649f
C89 BLB_0 net132_10 0.000123568f
C90 BLB_0 net132_2 0.000117683f
C91 BLB_0 net132_3 0.000127746f
C92 BLB_0 net132_4 0.000128684f
C93 BLB_0 net132_5 5.13941e-05f
C94 BLB_0 net132_6 5.13941e-05f
C95 BLB_0 net132_7 2.56971e-05f
C96 BLB_0 net132_8 5.13941e-05f
C97 BLB_0 net132_9 7.95216e-05f
C98 BLB_0 net3_2 0.00138434f
C99 BLB_0 net3_8 0.000604564f
C100 BLB_0 net67 6.80021e-05f
C101 BLB_0 net7 0.000128645f
C102 BLB_0 net78 8.13739e-05f
C103 BLB_0 net7_11 7.54158e-05f
C104 BLB_0 net7_2 0.000111607f
C105 BLB_0 net7_3 0.00012115f
C106 BLB_0 net7_4 0.00012204f
C107 BLB_0 net7_5 4.87406e-05f
C108 BLB_0 net7_6 4.87406e-05f
C109 BLB_0 net7_7 2.43703e-05f
C110 BLB_0 net7_8 4.87406e-05f
C111 BLB_0 net7_9 0.000117188f
C112 BLB_0_1 BLB_1_1 0.0001078f
C113 BLB_0_1 BLB_2_1 2.77037e-05f
C114 BLB_0_1 BLB_3_1 1.3346e-05f
C115 BLB_0_1 BL_0_1 0.000356605f
C116 BLB_0_1 BL_1_1 0.003288f
C117 BLB_0_1 BL_2 5.08142e-05f
C118 BLB_0_1 BL_3 2.10511e-05f
C119 BLB_0_1 P_0_0 0.00179515f
C120 BLB_0_1 P_0_0_1 0.00384549f
C121 BLB_0_1 P_0_0_2 0.0069958f
C122 BLB_0_1 P_0_0_3 0.000776138f
C123 BLB_0_1 VDD_1 0.000474766f
C124 BLB_0_1 VSS_0 0.0159797f
C125 BLB_0_1 VSS_2 0.00401109f
C126 BLB_0_1 WL_0 0.000305595f
C127 BLB_0_1 WL_0_1 0.000733454f
C128 BLB_0_1 WL_0_16 0.000608073f
C129 BLB_0_1 WL_0_17 0.000608073f
C130 BLB_0_1 WL_0_9 0.00084169f
C131 BLB_0_1 net2 2.48546e-05f
C132 BLB_0_1 net2_2 3.23754e-05f
C133 BLB_0_1 net2_3 3.23754e-05f
C134 BLB_0_1 net2_4 5.5117e-05f
C135 BLB_0_1 net2_6 2.34489e-05f
C136 BLB_0_1 net2_7 8.38036e-05f
C137 BLB_0_1 net3 0.00159567f
C138 BLB_0_1 net3_11 0.000935435f
C139 BLB_0_1 net3_3 0.00150272f
C140 BLB_0_1 net3_4 0.00151375f
C141 BLB_0_1 net3_5 0.000604564f
C142 BLB_0_1 net3_6 0.000604564f
C143 BLB_0_1 net3_7 0.000302282f
C144 BLB_0_1 net3_9 0.00145356f
C145 BLB_0_1 net67 4.25822e-05f
C146 BLB_0_1 net78 5.09554e-05f
C147 BLB_0_2 BLB_1_2 0.000122068f
C148 BLB_0_2 BLB_2_2 3.13705e-05f
C149 BLB_0_2 BLB_3_2 1.51125e-05f
C150 BLB_0_2 BL_0_2 0.000403804f
C151 BLB_0_2 BL_1_2 0.00372319f
C152 BLB_0_2 BL_2_2 5.75399e-05f
C153 BLB_0_2 BL_3_2 2.38373e-05f
C154 BLB_0_2 P_1_0 0.00179212f
C155 BLB_0_2 P_1_0_1 0.003839f
C156 BLB_0_2 P_1_0_2 0.006984f
C157 BLB_0_2 P_1_0_4 0.000774829f
C158 BLB_0_2 P_1_0_5 0.00156196f
C159 BLB_0_2 VDD_1 0.000537605f
C160 BLB_0_2 VSS_0 0.0180947f
C161 BLB_0_2 VSS_2 0.00454199f
C162 BLB_0_2 WL_1 0.000309538f
C163 BLB_0_2 WL_1_1 0.000742918f
C164 BLB_0_2 WL_1_16 0.000615919f
C165 BLB_0_2 WL_1_17 0.000615919f
C166 BLB_0_2 WL_1_9 0.00085255f
C167 BLB_0_2 XB_1_0 0.00220602f
C168 BLB_0_2 XB_1_0_1 0.00922201f
C169 BLB_0_2 XB_1_0_2 0.00130342f
C170 BLB_0_2 net130 0.00159232f
C171 BLB_0_2 net130_10 0.00145051f
C172 BLB_0_2 net130_2 0.00138144f
C173 BLB_0_2 net130_3 0.00149956f
C174 BLB_0_2 net130_4 0.00151057f
C175 BLB_0_2 net130_5 0.000603294f
C176 BLB_0_2 net130_6 0.000603294f
C177 BLB_0_2 net130_7 0.000301647f
C178 BLB_0_2 net130_9 0.000933471f
C179 BLB_0_2 net67 4.82182e-05f
C180 BLB_0_2 net76 2.18003e-05f
C181 BLB_0_2 net76_2 2.8397e-05f
C182 BLB_0_2 net76_3 2.8397e-05f
C183 BLB_0_2 net76_4 2.05674e-05f
C184 BLB_0_2 net76_5 4.83439e-05f
C185 BLB_0_2 net76_7 7.35054e-05f
C186 BLB_0_2 net78 5.76997e-05f
C187 BLB_1 BLB_2_1 0.000171772f
C188 BLB_1 BLB_3_1 3.49222e-05f
C189 BLB_1 BLB_4_1 2.11881e-05f
C190 BLB_1 BLB_5_1 1.487e-05f
C191 BLB_1 BL_0 8.02808e-05f
C192 BLB_1 BL_2 0.00526875f
C193 BLB_1 BL_3 7.69529e-05f
C194 BLB_1 BL_4 2.76308e-05f
C195 BLB_1 BL_5 1.43241e-05f
C196 BLB_1 P_0_1_4 0.00156373f
C197 BLB_1 P_0_1_5 0.00307117f
C198 BLB_1 P_0_2 1.35527e-05f
C199 BLB_1 P_0_2_1 2.90321e-05f
C200 BLB_1 P_0_2_2 5.28158e-05f
C201 BLB_1 P_0_2_4 1.18121e-05f
C202 BLB_1 P_0_2_5 2.31991e-05f
C203 BLB_1 P_0_3_2 1.15435e-05f
C204 BLB_1 P_1_1_3 0.00307386f
C205 BLB_1 P_1_2 1.42422e-05f
C206 BLB_1 P_1_2_1 3.0509e-05f
C207 BLB_1 P_1_2_2 5.55027e-05f
C208 BLB_1 P_1_2_3 2.43793e-05f
C209 BLB_1 P_1_2_5 1.24131e-05f
C210 BLB_1 P_1_3_2 1.20791e-05f
C211 BLB_1 VDD_1 0.000603357f
C212 BLB_1 VSS_0 0.0254516f
C213 BLB_1 VSS_2 0.0063651f
C214 BLB_1 WL_0_11 0.00120599f
C215 BLB_1 WL_0_12 0.00132659f
C216 BLB_1 WL_0_13 0.00132659f
C217 BLB_1 WL_0_14 0.00132659f
C218 BLB_1 WL_0_15 0.00289438f
C219 BLB_1 WL_0_20 0.000609881f
C220 BLB_1 WL_0_21 0.000609881f
C221 BLB_1 WL_0_22 0.000609881f
C222 BLB_1 WL_0_23 0.000609881f
C223 BLB_1 WL_0_24 0.000609881f
C224 BLB_1 WL_0_25 0.000609881f
C225 BLB_1 WL_0_26 0.000609881f
C226 BLB_1 WL_0_27 0.000609881f
C227 BLB_1 WL_0_28 0.000609881f
C228 BLB_1 WL_0_29 0.000609881f
C229 BLB_1 WL_0_3 0.000800941f
C230 BLB_1 WL_0_30 0.000609881f
C231 BLB_1 WL_0_31 0.000609881f
C232 BLB_1 WL_0_4 0.000800941f
C233 BLB_1 WL_0_5 0.000800941f
C234 BLB_1 WL_0_6 0.000800941f
C235 BLB_1 WL_0_7 0.000800941f
C236 BLB_1 WL_0_8 0.000800941f
C237 BLB_1 WL_1_11 0.00119494f
C238 BLB_1 WL_1_12 0.00131443f
C239 BLB_1 WL_1_13 0.00131443f
C240 BLB_1 WL_1_14 0.00131443f
C241 BLB_1 WL_1_15 0.00286785f
C242 BLB_1 WL_1_20 0.000604292f
C243 BLB_1 WL_1_21 0.000604292f
C244 BLB_1 WL_1_22 0.000604292f
C245 BLB_1 WL_1_23 0.000604292f
C246 BLB_1 WL_1_24 0.000604292f
C247 BLB_1 WL_1_25 0.000604292f
C248 BLB_1 WL_1_26 0.000604292f
C249 BLB_1 WL_1_27 0.000604292f
C250 BLB_1 WL_1_28 0.000604292f
C251 BLB_1 WL_1_29 0.000604292f
C252 BLB_1 WL_1_3 0.000793601f
C253 BLB_1 WL_1_30 0.000604292f
C254 BLB_1 WL_1_31 0.000604292f
C255 BLB_1 WL_1_4 0.000793601f
C256 BLB_1 WL_1_5 0.000793601f
C257 BLB_1 WL_1_6 0.000793601f
C258 BLB_1 WL_1_7 0.000793601f
C259 BLB_1 WL_1_8 0.000793601f
C260 BLB_1 XB_0_1 0.00221764f
C261 BLB_1 XB_0_1_1 0.00927062f
C262 BLB_1 XB_0_1_2 0.00131029f
C263 BLB_1 XB_0_1_3 0.00262059f
C264 BLB_1 XB_1_1_3 0.00261968f
C265 BLB_1 net10 1.1335e-05f
C266 BLB_1 net10_2 1.47649e-05f
C267 BLB_1 net10_3 1.47649e-05f
C268 BLB_1 net10_4 2.51363e-05f
C269 BLB_1 net10_6 1.06939e-05f
C270 BLB_1 net10_7 3.82189e-05f
C271 BLB_1 net11 0.000149184f
C272 BLB_1 net11_11 8.74562e-05f
C273 BLB_1 net11_2 0.000129426f
C274 BLB_1 net11_3 0.000140493f
C275 BLB_1 net11_4 0.000141524f
C276 BLB_1 net11_5 5.65222e-05f
C277 BLB_1 net11_6 5.65222e-05f
C278 BLB_1 net11_7 2.82611e-05f
C279 BLB_1 net11_8 5.65222e-05f
C280 BLB_1 net11_9 0.000135897f
C281 BLB_1 net132_8 0.000607727f
C282 BLB_1 net134 0.000150827f
C283 BLB_1 net134_10 0.000137394f
C284 BLB_1 net134_2 0.000130851f
C285 BLB_1 net134_3 0.00014204f
C286 BLB_1 net134_4 0.000143083f
C287 BLB_1 net134_5 5.71447e-05f
C288 BLB_1 net134_6 5.71447e-05f
C289 BLB_1 net134_7 2.85723e-05f
C290 BLB_1 net134_8 5.71447e-05f
C291 BLB_1 net134_9 8.84194e-05f
C292 BLB_1 net68 8.80451e-05f
C293 BLB_1 net7_2 0.00139103f
C294 BLB_1 net7_8 0.000607485f
C295 BLB_1 net80 8.77333e-05f
C296 BLB_1 net81_2 1.17822e-05f
C297 BLB_1 net81_3 1.17822e-05f
C298 BLB_1 net81_5 2.00584e-05f
C299 BLB_1 net81_7 3.04981e-05f
C300 BLB_1_1 BLB_2_1 0.000107561f
C301 BLB_1_1 BLB_3_1 2.18679e-05f
C302 BLB_1_1 BLB_4_1 1.32678e-05f
C303 BLB_1_1 BL_0_1 5.0271e-05f
C304 BLB_1_1 BL_1 0.000661626f
C305 BLB_1_1 BL_1_1 0.000246885f
C306 BLB_1_1 BL_2_1 0.00329923f
C307 BLB_1_1 BL_3 4.81871e-05f
C308 BLB_1_1 BL_4 1.73021e-05f
C309 BLB_1_1 P_0_0_2 1.73638e-05f
C310 BLB_1_1 P_0_1 0.00179415f
C311 BLB_1_1 P_0_1_1 0.00384336f
C312 BLB_1_1 P_0_1_2 0.00699193f
C313 BLB_1_1 P_0_1_3 0.000775708f
C314 BLB_1_1 VDD_1 0.000377816f
C315 BLB_1_1 VSS_0 0.0159375f
C316 BLB_1_1 VSS_2 0.00398575f
C317 BLB_1_1 WL_0 0.000306504f
C318 BLB_1_1 WL_0_1 0.000735636f
C319 BLB_1_1 WL_0_10 0.00132659f
C320 BLB_1_1 WL_0_16 0.000609881f
C321 BLB_1_1 WL_0_17 0.000609881f
C322 BLB_1_1 WL_0_18 0.000609881f
C323 BLB_1_1 WL_0_19 0.000609881f
C324 BLB_1_1 WL_0_2 0.000800941f
C325 BLB_1_1 WL_0_9 0.000844193f
C326 BLB_1_1 XB_0_0_1 1.6282e-05f
C327 BLB_1_1 net3 1.04889e-05f
C328 BLB_1_1 net6 3.18497e-05f
C329 BLB_1_1 net68 5.51329e-05f
C330 BLB_1_1 net6_2 4.14872e-05f
C331 BLB_1_1 net6_3 4.14872e-05f
C332 BLB_1_1 net6_4 7.06292e-05f
C333 BLB_1_1 net6_6 3.00484e-05f
C334 BLB_1_1 net6_7 0.000107389f
C335 BLB_1_1 net7 0.00160338f
C336 BLB_1_1 net7_11 0.000939956f
C337 BLB_1_1 net7_3 0.00150998f
C338 BLB_1_1 net7_4 0.00152107f
C339 BLB_1_1 net7_5 0.000607485f
C340 BLB_1_1 net7_6 0.000607485f
C341 BLB_1_1 net7_7 0.000303743f
C342 BLB_1_1 net7_9 0.00146059f
C343 BLB_1_1 net80 5.49376e-05f
C344 BLB_1_2 BLB_2_2 0.000121798f
C345 BLB_1_2 BLB_3_2 2.47623e-05f
C346 BLB_1_2 BLB_4_2 1.50239e-05f
C347 BLB_1_2 BLB_5_2 1.05438e-05f
C348 BLB_1_2 BL_0_2 5.69247e-05f
C349 BLB_1_2 BL_1_2 0.000246885f
C350 BLB_1_2 BL_2_2 0.00373591f
C351 BLB_1_2 BL_3_2 5.4565e-05f
C352 BLB_1_2 BL_4_2 1.95922e-05f
C353 BLB_1_2 BL_5_2 1.01568e-05f
C354 BLB_1_2 P_1_1 0.00179573f
C355 BLB_1_2 P_1_1_1 0.00384673f
C356 BLB_1_2 P_1_1_2 0.00699805f
C357 BLB_1_2 P_1_1_4 0.000776387f
C358 BLB_1_2 P_1_1_5 0.0015651f
C359 BLB_1_2 VDD_1 0.000427822f
C360 BLB_1_2 VSS_0 0.0180469f
C361 BLB_1_2 VSS_2 0.0045133f
C362 BLB_1_2 WL_1 0.000303695f
C363 BLB_1_2 WL_1_1 0.000728894f
C364 BLB_1_2 WL_1_10 0.00131443f
C365 BLB_1_2 WL_1_16 0.000604292f
C366 BLB_1_2 WL_1_17 0.000604292f
C367 BLB_1_2 WL_1_18 0.000604292f
C368 BLB_1_2 WL_1_19 0.000604292f
C369 BLB_1_2 WL_1_2 0.000793601f
C370 BLB_1_2 WL_1_9 0.000836457f
C371 BLB_1_2 XB_1_1 0.00221687f
C372 BLB_1_2 XB_1_1_1 0.00926741f
C373 BLB_1_2 XB_1_1_2 0.00130984f
C374 BLB_1_2 net130 1.55633e-05f
C375 BLB_1_2 net130_10 1.41772e-05f
C376 BLB_1_2 net130_2 1.35021e-05f
C377 BLB_1_2 net130_3 1.46566e-05f
C378 BLB_1_2 net130_4 1.47642e-05f
C379 BLB_1_2 net132 0.00160402f
C380 BLB_1_2 net132_10 0.00146117f
C381 BLB_1_2 net132_2 0.00139159f
C382 BLB_1_2 net132_3 0.00151058f
C383 BLB_1_2 net132_4 0.00152167f
C384 BLB_1_2 net132_5 0.000607727f
C385 BLB_1_2 net132_6 0.000607727f
C386 BLB_1_2 net132_7 0.000303864f
C387 BLB_1_2 net132_9 0.00094033f
C388 BLB_1_2 net68 6.24301e-05f
C389 BLB_1_2 net79 3.06464e-05f
C390 BLB_1_2 net79_2 3.99198e-05f
C391 BLB_1_2 net79_3 3.99198e-05f
C392 BLB_1_2 net79_4 2.89132e-05f
C393 BLB_1_2 net79_5 6.79609e-05f
C394 BLB_1_2 net79_7 0.000103332f
C395 BLB_1_2 net80 6.2209e-05f
C396 BLB_2 BLB_3_1 0.000169753f
C397 BLB_2 BLB_4_1 4.46589e-05f
C398 BLB_2 BLB_5_1 2.28797e-05f
C399 BLB_2 BLB_6_1 1.28133e-05f
C400 BLB_2 BL_0 3.09841e-05f
C401 BLB_2 BL_3 0.00523694f
C402 BLB_2 BL_4 8.76207e-05f
C403 BLB_2 BL_5 3.31026e-05f
C404 BLB_2 BL_6 1.46035e-05f
C405 BLB_2 P_0_2_4 0.00156019f
C406 BLB_2 P_0_2_5 0.00306422f
C407 BLB_2 P_0_3 1.51927e-05f
C408 BLB_2 P_0_3_1 3.25451e-05f
C409 BLB_2 P_0_3_2 5.92068e-05f
C410 BLB_2 P_0_3_4 1.32415e-05f
C411 BLB_2 P_0_3_5 2.60063e-05f
C412 BLB_2 P_0_4_2 1.67848e-05f
C413 BLB_2 P_1_2_3 0.00306095f
C414 BLB_2 P_1_3 1.55007e-05f
C415 BLB_2 P_1_3_1 3.32049e-05f
C416 BLB_2 P_1_3_2 6.04071e-05f
C417 BLB_2 P_1_3_3 2.65335e-05f
C418 BLB_2 P_1_3_5 1.35099e-05f
C419 BLB_2 P_1_4_2 1.7012e-05f
C420 BLB_2 VDD_1 0.000746862f
C421 BLB_2 VSS_0 0.0253601f
C422 BLB_2 VSS_2 0.00648494f
C423 BLB_2 WL_0_12 0.00131866f
C424 BLB_2 WL_0_13 0.00131866f
C425 BLB_2 WL_0_14 0.00131866f
C426 BLB_2 WL_0_15 0.00287708f
C427 BLB_2 WL_0_22 0.000606237f
C428 BLB_2 WL_0_23 0.000606237f
C429 BLB_2 WL_0_24 0.000606237f
C430 BLB_2 WL_0_25 0.000606237f
C431 BLB_2 WL_0_26 0.000606237f
C432 BLB_2 WL_0_27 0.000606237f
C433 BLB_2 WL_0_28 0.000606237f
C434 BLB_2 WL_0_29 0.000606237f
C435 BLB_2 WL_0_30 0.000606237f
C436 BLB_2 WL_0_31 0.000606237f
C437 BLB_2 WL_0_4 0.000796155f
C438 BLB_2 WL_0_5 0.000796155f
C439 BLB_2 WL_0_6 0.000796155f
C440 BLB_2 WL_0_7 0.000796155f
C441 BLB_2 WL_0_8 0.000796155f
C442 BLB_2 WL_1_12 0.00132824f
C443 BLB_2 WL_1_13 0.00132824f
C444 BLB_2 WL_1_14 0.00132824f
C445 BLB_2 WL_1_15 0.00289799f
C446 BLB_2 WL_1_22 0.000610642f
C447 BLB_2 WL_1_23 0.000610642f
C448 BLB_2 WL_1_24 0.000610642f
C449 BLB_2 WL_1_25 0.000610642f
C450 BLB_2 WL_1_26 0.000610642f
C451 BLB_2 WL_1_27 0.000610642f
C452 BLB_2 WL_1_28 0.000610642f
C453 BLB_2 WL_1_29 0.000610642f
C454 BLB_2 WL_1_30 0.000610642f
C455 BLB_2 WL_1_31 0.000610642f
C456 BLB_2 WL_1_4 0.00080194f
C457 BLB_2 WL_1_5 0.00080194f
C458 BLB_2 WL_1_6 0.00080194f
C459 BLB_2 WL_1_7 0.00080194f
C460 BLB_2 WL_1_8 0.00080194f
C461 BLB_2 XB_0_2 0.0022081f
C462 BLB_2 XB_0_2_1 0.00923073f
C463 BLB_2 XB_0_2_2 0.00130466f
C464 BLB_2 XB_0_2_3 0.00260931f
C465 BLB_2 XB_1_2_3 0.00260353f
C466 BLB_2 net11_2 0.00137927f
C467 BLB_2 net11_8 0.000602347f
C468 BLB_2 net134_8 0.00059558f
C469 BLB_2 net135 0.000136485f
C470 BLB_2 net135_10 0.00012433f
C471 BLB_2 net135_2 0.000118409f
C472 BLB_2 net135_3 0.000128534f
C473 BLB_2 net135_4 0.000129478f
C474 BLB_2 net135_5 5.17111e-05f
C475 BLB_2 net135_6 5.17111e-05f
C476 BLB_2 net135_7 2.58556e-05f
C477 BLB_2 net135_8 5.17111e-05f
C478 BLB_2 net135_9 8.00121e-05f
C479 BLB_2 net13_7 1.08371e-05f
C480 BLB_2 net14 0.000133909f
C481 BLB_2 net14_11 7.8502e-05f
C482 BLB_2 net14_2 0.000116175f
C483 BLB_2 net14_3 0.000126108f
C484 BLB_2 net14_4 0.000127034f
C485 BLB_2 net14_5 5.07352e-05f
C486 BLB_2 net14_6 5.07352e-05f
C487 BLB_2 net14_7 2.53676e-05f
C488 BLB_2 net14_8 5.07352e-05f
C489 BLB_2 net14_9 0.000121983f
C490 BLB_2 net69 6.6777e-05f
C491 BLB_2 net83 7.22738e-05f
C492 BLB_2 net84_5 1.28322e-05f
C493 BLB_2 net84_7 1.95109e-05f
C494 BLB_2_1 BLB_3_1 0.000106298f
C495 BLB_2_1 BLB_4_1 2.79649e-05f
C496 BLB_2_1 BLB_5_1 1.4327e-05f
C497 BLB_2_1 BL_0_1 1.94019e-05f
C498 BLB_2_1 BL_1 6.6002e-05f
C499 BLB_2_1 BL_1_1 2.46285e-05f
C500 BLB_2_1 BL_2 0.000648278f
C501 BLB_2_1 BL_2_1 0.000241904f
C502 BLB_2_1 BL_3_1 0.00327931f
C503 BLB_2_1 BL_4 5.48671e-05f
C504 BLB_2_1 BL_5 2.07284e-05f
C505 BLB_2_1 P_0_0_2 1.15841e-05f
C506 BLB_2_1 P_0_1_2 1.45817e-05f
C507 BLB_2_1 P_0_2 0.00179009f
C508 BLB_2_1 P_0_2_1 0.00383466f
C509 BLB_2_1 P_0_2_2 0.00697609f
C510 BLB_2_1 P_0_2_3 0.000773952f
C511 BLB_2_1 VDD_1 0.000467677f
C512 BLB_2_1 VSS_0 0.0158802f
C513 BLB_2_1 VSS_2 0.00406079f
C514 BLB_2_1 WL_0 0.000304672f
C515 BLB_2_1 WL_0_1 0.00073124f
C516 BLB_2_1 WL_0_10 0.00131866f
C517 BLB_2_1 WL_0_11 0.00119878f
C518 BLB_2_1 WL_0_16 0.000606237f
C519 BLB_2_1 WL_0_17 0.000606237f
C520 BLB_2_1 WL_0_18 0.000606237f
C521 BLB_2_1 WL_0_19 0.000606237f
C522 BLB_2_1 WL_0_2 0.000796155f
C523 BLB_2_1 WL_0_20 0.000606237f
C524 BLB_2_1 WL_0_21 0.000606237f
C525 BLB_2_1 WL_0_3 0.000796155f
C526 BLB_2_1 WL_0_9 0.000839149f
C527 BLB_2_1 net10 3.18722e-05f
C528 BLB_2_1 net10_2 4.15165e-05f
C529 BLB_2_1 net10_3 4.15165e-05f
C530 BLB_2_1 net10_4 7.06792e-05f
C531 BLB_2_1 net10_6 3.00696e-05f
C532 BLB_2_1 net10_7 0.000107465f
C533 BLB_2_1 net11 0.00158982f
C534 BLB_2_1 net11_11 0.000932006f
C535 BLB_2_1 net11_3 0.00149721f
C536 BLB_2_1 net11_4 0.0015082f
C537 BLB_2_1 net11_5 0.000602347f
C538 BLB_2_1 net11_6 0.000602347f
C539 BLB_2_1 net11_7 0.000301174f
C540 BLB_2_1 net11_9 0.00144823f
C541 BLB_2_1 net69 4.1815e-05f
C542 BLB_2_1 net7 1.07334e-05f
C543 BLB_2_1 net7_3 1.01081e-05f
C544 BLB_2_1 net7_4 1.01823e-05f
C545 BLB_2_1 net83 4.52571e-05f
C546 BLB_2_2 BLB_3_2 0.000120367f
C547 BLB_2_2 BLB_4_2 3.16662e-05f
C548 BLB_2_2 BLB_5_2 1.62233e-05f
C549 BLB_2_2 BL_0_2 2.19699e-05f
C550 BLB_2_2 BL_1_2 2.46285e-05f
C551 BLB_2_2 BL_2_2 0.000241904f
C552 BLB_2_2 BL_3_2 0.00371335f
C553 BLB_2_2 BL_4_2 6.21292e-05f
C554 BLB_2_2 BL_5_2 2.3472e-05f
C555 BLB_2_2 BL_6_2 1.03549e-05f
C556 BLB_2_2 P_1_0_2 1.35404e-05f
C557 BLB_2_2 P_1_1_2 1.29956e-05f
C558 BLB_2_2 P_1_2 0.00178818f
C559 BLB_2_2 P_1_2_1 0.00383057f
C560 BLB_2_2 P_1_2_2 0.00696865f
C561 BLB_2_2 P_1_2_4 0.000773126f
C562 BLB_2_2 P_1_2_5 0.00155852f
C563 BLB_2_2 VDD_1 0.000529577f
C564 BLB_2_2 VSS_0 0.0179821f
C565 BLB_2_2 VSS_2 0.00459827f
C566 BLB_2_2 WL_1 0.000306886f
C567 BLB_2_2 WL_1_1 0.000736553f
C568 BLB_2_2 WL_1_10 0.00132824f
C569 BLB_2_2 WL_1_11 0.00120749f
C570 BLB_2_2 WL_1_16 0.000610642f
C571 BLB_2_2 WL_1_17 0.000610642f
C572 BLB_2_2 WL_1_18 0.000610642f
C573 BLB_2_2 WL_1_19 0.000610642f
C574 BLB_2_2 WL_1_2 0.00080194f
C575 BLB_2_2 WL_1_20 0.000610642f
C576 BLB_2_2 WL_1_21 0.000610642f
C577 BLB_2_2 WL_1_3 0.00080194f
C578 BLB_2_2 WL_1_9 0.000845246f
C579 BLB_2_2 XB_1_1_1 2.6728e-05f
C580 BLB_2_2 XB_1_2 0.0022032f
C581 BLB_2_2 XB_1_2_1 0.00921026f
C582 BLB_2_2 XB_1_2_2 0.00130176f
C583 BLB_2_2 net132 1.18572e-05f
C584 BLB_2_2 net132_10 1.08012e-05f
C585 BLB_2_2 net132_2 1.02869e-05f
C586 BLB_2_2 net132_3 1.11665e-05f
C587 BLB_2_2 net132_4 1.12485e-05f
C588 BLB_2_2 net134 0.00157196f
C589 BLB_2_2 net134_10 0.00143196f
C590 BLB_2_2 net134_2 0.00136377f
C591 BLB_2_2 net134_3 0.00148038f
C592 BLB_2_2 net134_4 0.00149126f
C593 BLB_2_2 net134_5 0.00059558f
C594 BLB_2_2 net134_6 0.00059558f
C595 BLB_2_2 net134_7 0.00029779f
C596 BLB_2_2 net134_9 0.000921535f
C597 BLB_2_2 net69 4.73495e-05f
C598 BLB_2_2 net81 2.79483e-05f
C599 BLB_2_2 net81_2 3.64053e-05f
C600 BLB_2_2 net81_3 3.64053e-05f
C601 BLB_2_2 net81_4 2.63677e-05f
C602 BLB_2_2 net81_5 6.19776e-05f
C603 BLB_2_2 net81_7 9.42349e-05f
C604 BLB_2_2 net83 5.12471e-05f
C605 BLB_3 BLB_4_1 0.000163343f
C606 BLB_3 BLB_5_1 2.74762e-05f
C607 BLB_3 BLB_6_1 2.21784e-05f
C608 BLB_3 BLB_7_1 1.84316e-05f
C609 BLB_3 BL_0 1.74106e-05f
C610 BLB_3 BL_3 0.000498536f
C611 BLB_3 BL_4 0.00524542f
C612 BLB_3 BL_5 7.34589e-05f
C613 BLB_3 BL_6 3.09049e-05f
C614 BLB_3 BL_7 1.48594e-05f
C615 BLB_3 P_0_3_4 0.00156056f
C616 BLB_3 P_0_3_5 0.00306494f
C617 BLB_3 P_0_4 1.45886e-05f
C618 BLB_3 P_0_4_1 3.1251e-05f
C619 BLB_3 P_0_4_2 5.68525e-05f
C620 BLB_3 P_0_4_4 1.27149e-05f
C621 BLB_3 P_0_4_5 2.49722e-05f
C622 BLB_3 P_0_5_2 1.09624e-05f
C623 BLB_3 P_1_3_3 0.00306125f
C624 BLB_3 P_1_4 1.49533e-05f
C625 BLB_3 P_1_4_1 3.20323e-05f
C626 BLB_3 P_1_4_2 5.82739e-05f
C627 BLB_3 P_1_4_3 2.55965e-05f
C628 BLB_3 P_1_4_5 1.30328e-05f
C629 BLB_3 P_1_5_2 1.1087e-05f
C630 BLB_3 VDD_1 0.00053399f
C631 BLB_3 VSS_0 0.0253057f
C632 BLB_3 VSS_2 0.00637625f
C633 BLB_3 WL_0_13 0.00131308f
C634 BLB_3 WL_0_14 0.00131308f
C635 BLB_3 WL_0_15 0.0028649f
C636 BLB_3 WL_0_24 0.00060367f
C637 BLB_3 WL_0_25 0.00060367f
C638 BLB_3 WL_0_26 0.00060367f
C639 BLB_3 WL_0_27 0.00060367f
C640 BLB_3 WL_0_28 0.00060367f
C641 BLB_3 WL_0_29 0.00060367f
C642 BLB_3 WL_0_30 0.00060367f
C643 BLB_3 WL_0_31 0.00060367f
C644 BLB_3 WL_0_5 0.000792784f
C645 BLB_3 WL_0_6 0.000792784f
C646 BLB_3 WL_0_7 0.000792784f
C647 BLB_3 WL_0_8 0.000792784f
C648 BLB_3 WL_1_13 0.00132828f
C649 BLB_3 WL_1_14 0.00132828f
C650 BLB_3 WL_1_15 0.00289807f
C651 BLB_3 WL_1_24 0.000610659f
C652 BLB_3 WL_1_25 0.000610659f
C653 BLB_3 WL_1_26 0.000610659f
C654 BLB_3 WL_1_27 0.000610659f
C655 BLB_3 WL_1_28 0.000610659f
C656 BLB_3 WL_1_29 0.000610659f
C657 BLB_3 WL_1_30 0.000610659f
C658 BLB_3 WL_1_31 0.000610659f
C659 BLB_3 WL_1_5 0.000801963f
C660 BLB_3 WL_1_6 0.000801963f
C661 BLB_3 WL_1_7 0.000801963f
C662 BLB_3 WL_1_8 0.000801963f
C663 BLB_3 XB_0_3 0.00221877f
C664 BLB_3 XB_0_3_1 0.00927531f
C665 BLB_3 XB_0_3_2 0.00131096f
C666 BLB_3 XB_0_3_3 0.00262191f
C667 BLB_3 XB_0_4_1 2.22399e-05f
C668 BLB_3 XB_1_3_3 0.00263066f
C669 BLB_3 net135_8 0.000605076f
C670 BLB_3 net137 0.000157665f
C671 BLB_3 net137_10 0.000143623f
C672 BLB_3 net137_2 0.000136784f
C673 BLB_3 net137_3 0.00014848f
C674 BLB_3 net137_4 0.000149571f
C675 BLB_3 net137_5 5.97357e-05f
C676 BLB_3 net137_6 5.97357e-05f
C677 BLB_3 net137_7 2.98679e-05f
C678 BLB_3 net137_8 5.97357e-05f
C679 BLB_3 net137_9 9.24285e-05f
C680 BLB_3 net14_2 0.00140516f
C681 BLB_3 net14_8 0.000613654f
C682 BLB_3 net16_2 1.26406e-05f
C683 BLB_3 net16_3 1.26406e-05f
C684 BLB_3 net16_4 2.15198e-05f
C685 BLB_3 net16_7 3.27202e-05f
C686 BLB_3 net17 0.000146322f
C687 BLB_3 net17_11 8.57786e-05f
C688 BLB_3 net17_2 0.000126943f
C689 BLB_3 net17_3 0.000137798f
C690 BLB_3 net17_4 0.00013881f
C691 BLB_3 net17_5 5.5438e-05f
C692 BLB_3 net17_6 5.5438e-05f
C693 BLB_3 net17_7 2.7719e-05f
C694 BLB_3 net17_8 5.5438e-05f
C695 BLB_3 net17_9 0.00013329f
C696 BLB_3 net70 8.84592e-05f
C697 BLB_3 net85 0.000105457f
C698 BLB_3 net86_2 1.28063e-05f
C699 BLB_3 net86_3 1.28063e-05f
C700 BLB_3 net86_5 2.18019e-05f
C701 BLB_3 net86_7 3.31491e-05f
C702 BLB_3_1 BLB_4_1 0.000102284f
C703 BLB_3_1 BLB_5_1 1.72053e-05f
C704 BLB_3_1 BLB_6_1 1.38879e-05f
C705 BLB_3_1 BLB_7_1 1.15417e-05f
C706 BLB_3_1 BL_0_1 1.09023e-05f
C707 BLB_3_1 BL_1 2.57782e-05f
C708 BLB_3_1 BL_2 8.96555e-05f
C709 BLB_3_1 BL_2_1 3.34548e-05f
C710 BLB_3_1 BL_3_1 0.000312178f
C711 BLB_3_1 BL_4_1 0.00328462f
C712 BLB_3_1 BL_5 4.59991e-05f
C713 BLB_3_1 BL_6 1.93523e-05f
C714 BLB_3_1 P_0_1_2 1.15883e-05f
C715 BLB_3_1 P_0_3 0.00179051f
C716 BLB_3_1 P_0_3_1 0.00383556f
C717 BLB_3_1 P_0_3_2 0.00697774f
C718 BLB_3_1 P_0_3_3 0.000774134f
C719 BLB_3_1 VDD_1 0.000334379f
C720 BLB_3_1 VSS_0 0.0158461f
C721 BLB_3_1 VSS_2 0.00399274f
C722 BLB_3_1 WL_0 0.000303382f
C723 BLB_3_1 WL_0_1 0.000728143f
C724 BLB_3_1 WL_0_10 0.00131308f
C725 BLB_3_1 WL_0_11 0.00119371f
C726 BLB_3_1 WL_0_12 0.00131308f
C727 BLB_3_1 WL_0_16 0.00060367f
C728 BLB_3_1 WL_0_17 0.00060367f
C729 BLB_3_1 WL_0_18 0.00060367f
C730 BLB_3_1 WL_0_19 0.00060367f
C731 BLB_3_1 WL_0_2 0.000792784f
C732 BLB_3_1 WL_0_20 0.00060367f
C733 BLB_3_1 WL_0_21 0.00060367f
C734 BLB_3_1 WL_0_22 0.00060367f
C735 BLB_3_1 WL_0_23 0.00060367f
C736 BLB_3_1 WL_0_3 0.000792784f
C737 BLB_3_1 WL_0_4 0.000792784f
C738 BLB_3_1 WL_0_9 0.000835596f
C739 BLB_3_1 XB_0_1_1 1.42699e-05f
C740 BLB_3_1 net10_2 1.14132e-05f
C741 BLB_3_1 net10_3 1.14132e-05f
C742 BLB_3_1 net10_4 1.94303e-05f
C743 BLB_3_1 net10_7 2.95431e-05f
C744 BLB_3_1 net11 3.07954e-05f
C745 BLB_3_1 net11_11 1.80532e-05f
C746 BLB_3_1 net11_2 2.67168e-05f
C747 BLB_3_1 net11_3 2.90013e-05f
C748 BLB_3_1 net11_4 2.92143e-05f
C749 BLB_3_1 net11_5 1.16676e-05f
C750 BLB_3_1 net11_6 1.16676e-05f
C751 BLB_3_1 net11_8 1.16676e-05f
C752 BLB_3_1 net11_9 2.80527e-05f
C753 BLB_3_1 net13 4.45384e-05f
C754 BLB_3_1 net13_2 5.80155e-05f
C755 BLB_3_1 net13_3 5.80155e-05f
C756 BLB_3_1 net13_4 9.87675e-05f
C757 BLB_3_1 net13_6 4.20195e-05f
C758 BLB_3_1 net13_7 0.000150173f
C759 BLB_3_1 net14 0.00161967f
C760 BLB_3_1 net14_11 0.0009495f
C761 BLB_3_1 net14_3 0.00152531f
C762 BLB_3_1 net14_4 0.00153651f
C763 BLB_3_1 net14_5 0.000613654f
C764 BLB_3_1 net14_6 0.000613654f
C765 BLB_3_1 net14_7 0.000306827f
C766 BLB_3_1 net14_9 0.00147542f
C767 BLB_3_1 net70 5.53921e-05f
C768 BLB_3_1 net85 6.60362e-05f
C769 BLB_3_2 BLB_4_2 0.000115821f
C770 BLB_3_2 BLB_5_2 1.94825e-05f
C771 BLB_3_2 BLB_6_2 1.5726e-05f
C772 BLB_3_2 BLB_7_2 1.30693e-05f
C773 BLB_3_2 BL_0_2 1.23453e-05f
C774 BLB_3_2 BL_2_2 3.34548e-05f
C775 BLB_3_2 BL_3_2 0.000353496f
C776 BLB_3_2 BL_4_2 0.00371936f
C777 BLB_3_2 BL_5_2 5.20875e-05f
C778 BLB_3_2 BL_6_2 2.19137e-05f
C779 BLB_3_2 BL_7_2 1.05364e-05f
C780 BLB_3_2 P_1_3 0.00178836f
C781 BLB_3_2 P_1_3_1 0.00383095f
C782 BLB_3_2 P_1_3_2 0.00696935f
C783 BLB_3_2 P_1_3_4 0.000773203f
C784 BLB_3_2 P_1_3_5 0.00155868f
C785 BLB_3_2 VDD_1 0.000378636f
C786 BLB_3_2 VSS_0 0.0179435f
C787 BLB_3_2 VSS_2 0.00452121f
C788 BLB_3_2 WL_1 0.000306895f
C789 BLB_3_2 WL_1_1 0.000736574f
C790 BLB_3_2 WL_1_10 0.00132828f
C791 BLB_3_2 WL_1_11 0.00120753f
C792 BLB_3_2 WL_1_12 0.00132828f
C793 BLB_3_2 WL_1_16 0.000610659f
C794 BLB_3_2 WL_1_17 0.000610659f
C795 BLB_3_2 WL_1_18 0.000610659f
C796 BLB_3_2 WL_1_19 0.000610659f
C797 BLB_3_2 WL_1_2 0.000801963f
C798 BLB_3_2 WL_1_20 0.000610659f
C799 BLB_3_2 WL_1_21 0.000610659f
C800 BLB_3_2 WL_1_22 0.000610659f
C801 BLB_3_2 WL_1_23 0.000610659f
C802 BLB_3_2 WL_1_3 0.000801963f
C803 BLB_3_2 WL_1_4 0.000801963f
C804 BLB_3_2 WL_1_9 0.00084527f
C805 BLB_3_2 XB_1_3 0.00222617f
C806 BLB_3_2 XB_1_3_1 0.00930625f
C807 BLB_3_2 XB_1_3_2 0.00131533f
C808 BLB_3_2 net134 1.92985e-05f
C809 BLB_3_2 net134_10 1.75798e-05f
C810 BLB_3_2 net134_2 1.67426e-05f
C811 BLB_3_2 net134_3 1.81743e-05f
C812 BLB_3_2 net134_4 1.83077e-05f
C813 BLB_3_2 net134_9 1.13134e-05f
C814 BLB_3_2 net135 0.00159703f
C815 BLB_3_2 net135_10 0.00145479f
C816 BLB_3_2 net135_2 0.00138552f
C817 BLB_3_2 net135_3 0.00150399f
C818 BLB_3_2 net135_4 0.00151503f
C819 BLB_3_2 net135_5 0.000605076f
C820 BLB_3_2 net135_6 0.000605076f
C821 BLB_3_2 net135_7 0.000302538f
C822 BLB_3_2 net135_9 0.000936228f
C823 BLB_3_2 net70 6.27237e-05f
C824 BLB_3_2 net81_5 1.21039e-05f
C825 BLB_3_2 net81_7 1.84036e-05f
C826 BLB_3_2 net84 3.58269e-05f
C827 BLB_3_2 net84_2 4.66678e-05f
C828 BLB_3_2 net84_3 4.66678e-05f
C829 BLB_3_2 net84_4 3.38006e-05f
C830 BLB_3_2 net84_5 7.94489e-05f
C831 BLB_3_2 net84_7 0.000120799f
C832 BLB_3_2 net85 7.47765e-05f
C833 BLB_4 BLB_5_1 0.000167272f
C834 BLB_4 BLB_6_1 3.75502e-05f
C835 BLB_4 BLB_7_1 2.7043e-05f
C836 BLB_4 BL_0 1.13283e-05f
C837 BLB_4 BL_3 5.04465e-05f
C838 BLB_4 BL_4 0.000496275f
C839 BLB_4 BL_5 0.00523077f
C840 BLB_4 BL_6 7.8747e-05f
C841 BLB_4 BL_7 3.28001e-05f
C842 BLB_4 P_0_4_4 0.00155695f
C843 BLB_4 P_0_4_5 0.00305786f
C844 BLB_4 P_0_5 1.53664e-05f
C845 BLB_4 P_0_5_1 3.29173e-05f
C846 BLB_4 P_0_5_2 5.98839e-05f
C847 BLB_4 P_0_5_4 1.33929e-05f
C848 BLB_4 P_0_5_5 2.63037e-05f
C849 BLB_4 P_0_6_2 1.5732e-05f
C850 BLB_4 P_1_4_3 0.00306277f
C851 BLB_4 P_1_5 1.62139e-05f
C852 BLB_4 P_1_5_1 3.47328e-05f
C853 BLB_4 P_1_5_2 6.31866e-05f
C854 BLB_4 P_1_5_3 2.77544e-05f
C855 BLB_4 P_1_5_5 1.41316e-05f
C856 BLB_4 P_1_6_2 1.61739e-05f
C857 BLB_4 VDD_1 0.000834944f
C858 BLB_4 VSS_0 0.0254535f
C859 BLB_4 VSS_2 0.00642573f
C860 BLB_4 WL_0_14 0.00132322f
C861 BLB_4 WL_0_15 0.00288702f
C862 BLB_4 WL_0_26 0.000608331f
C863 BLB_4 WL_0_27 0.000608331f
C864 BLB_4 WL_0_28 0.000608331f
C865 BLB_4 WL_0_29 0.000608331f
C866 BLB_4 WL_0_30 0.000608331f
C867 BLB_4 WL_0_31 0.000608331f
C868 BLB_4 WL_0_6 0.000798906f
C869 BLB_4 WL_0_7 0.000798906f
C870 BLB_4 WL_0_8 0.000798906f
C871 BLB_4 WL_1_14 0.00131967f
C872 BLB_4 WL_1_15 0.00287928f
C873 BLB_4 WL_1_26 0.0006067f
C874 BLB_4 WL_1_27 0.0006067f
C875 BLB_4 WL_1_28 0.0006067f
C876 BLB_4 WL_1_29 0.0006067f
C877 BLB_4 WL_1_30 0.0006067f
C878 BLB_4 WL_1_31 0.0006067f
C879 BLB_4 WL_1_6 0.000796764f
C880 BLB_4 WL_1_7 0.000796764f
C881 BLB_4 WL_1_8 0.000796764f
C882 BLB_4 XB_0_4 0.00219904f
C883 BLB_4 XB_0_4_1 0.00919285f
C884 BLB_4 XB_0_4_2 0.0012993f
C885 BLB_4 XB_0_4_3 0.0025986f
C886 BLB_4 XB_1_4_3 0.00260514f
C887 BLB_4 net137_8 0.000601576f
C888 BLB_4 net139 0.00013892f
C889 BLB_4 net139_10 0.000126548f
C890 BLB_4 net139_2 0.000120522f
C891 BLB_4 net139_3 0.000130827f
C892 BLB_4 net139_4 0.000131788f
C893 BLB_4 net139_5 5.26336e-05f
C894 BLB_4 net139_6 5.26336e-05f
C895 BLB_4 net139_7 2.63168e-05f
C896 BLB_4 net139_8 5.26336e-05f
C897 BLB_4 net139_9 8.14394e-05f
C898 BLB_4 net17_2 0.00137804f
C899 BLB_4 net17_8 0.000601812f
C900 BLB_4 net19_4 1.6062e-05f
C901 BLB_4 net19_7 2.44217e-05f
C902 BLB_4 net20 0.000139514f
C903 BLB_4 net20_11 8.17876e-05f
C904 BLB_4 net20_2 0.000121037f
C905 BLB_4 net20_3 0.000131386f
C906 BLB_4 net20_4 0.000132351f
C907 BLB_4 net20_5 5.28586e-05f
C908 BLB_4 net20_6 5.28586e-05f
C909 BLB_4 net20_7 2.64293e-05f
C910 BLB_4 net20_8 5.28586e-05f
C911 BLB_4 net20_9 0.000127089f
C912 BLB_4 net71 7.004e-05f
C913 BLB_4 net87 7.28633e-05f
C914 BLB_4 net88_5 1.19512e-05f
C915 BLB_4 net88_7 1.81714e-05f
C916 BLB_4_1 BLB_5_1 0.000104744f
C917 BLB_4_1 BLB_6_1 2.35135e-05f
C918 BLB_4_1 BLB_7_1 1.6934e-05f
C919 BLB_4_1 BL_1 1.87663e-05f
C920 BLB_4_1 BL_2 2.78993e-05f
C921 BLB_4_1 BL_2_1 1.04106e-05f
C922 BLB_4_1 BL_3_1 3.1589e-05f
C923 BLB_4_1 BL_4_1 0.000310762f
C924 BLB_4_1 BL_5_1 0.00327545f
C925 BLB_4_1 BL_6 4.93105e-05f
C926 BLB_4_1 BL_7 2.0539e-05f
C927 BLB_4_1 P_0_2_2 1.24276e-05f
C928 BLB_4_1 P_0_3_2 1.21548e-05f
C929 BLB_4_1 P_0_4 0.00178638f
C930 BLB_4_1 P_0_4_1 0.0038267f
C931 BLB_4_1 P_0_4_2 0.00696162f
C932 BLB_4_1 P_0_4_3 0.000772346f
C933 BLB_4_1 VDD_1 0.000522833f
C934 BLB_4_1 VSS_0 0.0159387f
C935 BLB_4_1 VSS_2 0.00402372f
C936 BLB_4_1 WL_0 0.000305725f
C937 BLB_4_1 WL_0_1 0.000733766f
C938 BLB_4_1 WL_0_10 0.00132322f
C939 BLB_4_1 WL_0_11 0.00120293f
C940 BLB_4_1 WL_0_12 0.00132322f
C941 BLB_4_1 WL_0_13 0.00132322f
C942 BLB_4_1 WL_0_16 0.000608331f
C943 BLB_4_1 WL_0_17 0.000608331f
C944 BLB_4_1 WL_0_18 0.000608331f
C945 BLB_4_1 WL_0_19 0.000608331f
C946 BLB_4_1 WL_0_2 0.000798906f
C947 BLB_4_1 WL_0_20 0.000608331f
C948 BLB_4_1 WL_0_21 0.000608331f
C949 BLB_4_1 WL_0_22 0.000608331f
C950 BLB_4_1 WL_0_23 0.000608331f
C951 BLB_4_1 WL_0_24 0.000608331f
C952 BLB_4_1 WL_0_25 0.000608331f
C953 BLB_4_1 WL_0_3 0.000798906f
C954 BLB_4_1 WL_0_4 0.000798906f
C955 BLB_4_1 WL_0_5 0.000798906f
C956 BLB_4_1 WL_0_9 0.000842048f
C957 BLB_4_1 net14 1.5471e-05f
C958 BLB_4_1 net14_2 1.3422e-05f
C959 BLB_4_1 net14_3 1.45697e-05f
C960 BLB_4_1 net14_4 1.46767e-05f
C961 BLB_4_1 net14_9 1.40931e-05f
C962 BLB_4_1 net16 2.31919e-05f
C963 BLB_4_1 net16_2 3.02096e-05f
C964 BLB_4_1 net16_3 3.02096e-05f
C965 BLB_4_1 net16_4 5.14298e-05f
C966 BLB_4_1 net16_6 2.18802e-05f
C967 BLB_4_1 net16_7 7.81974e-05f
C968 BLB_4_1 net17 0.00158841f
C969 BLB_4_1 net17_11 0.000931177f
C970 BLB_4_1 net17_3 0.00149588f
C971 BLB_4_1 net17_4 0.00150686f
C972 BLB_4_1 net17_5 0.000601812f
C973 BLB_4_1 net17_6 0.000601812f
C974 BLB_4_1 net17_7 0.000300906f
C975 BLB_4_1 net17_9 0.00144694f
C976 BLB_4_1 net71 4.38583e-05f
C977 BLB_4_1 net87 4.56262e-05f
C978 BLB_4_2 BLB_5_2 0.000118608f
C979 BLB_4_2 BLB_6_2 2.66257e-05f
C980 BLB_4_2 BLB_7_2 1.91753e-05f
C981 BLB_4_2 BL_2_2 1.04106e-05f
C982 BLB_4_2 BL_3_2 3.577e-05f
C983 BLB_4_2 BL_4_2 0.000351893f
C984 BLB_4_2 BL_5_2 0.00370898f
C985 BLB_4_2 BL_6_2 5.58371e-05f
C986 BLB_4_2 BL_7_2 2.32575e-05f
C987 BLB_4_2 P_1_2_2 1.17218e-05f
C988 BLB_4_2 P_1_3_2 1.23248e-05f
C989 BLB_4_2 P_1_4 0.00178925f
C990 BLB_4_2 P_1_4_1 0.00383285f
C991 BLB_4_2 P_1_4_2 0.0069728f
C992 BLB_4_2 P_1_4_4 0.000773586f
C993 BLB_4_2 P_1_4_5 0.00155945f
C994 BLB_4_2 VDD_1 0.000592033f
C995 BLB_4_2 VSS_0 0.0180483f
C996 BLB_4_2 VSS_2 0.00455629f
C997 BLB_4_2 WL_1 0.000304905f
C998 BLB_4_2 WL_1_1 0.000731798f
C999 BLB_4_2 WL_1_10 0.00131967f
C1000 BLB_4_2 WL_1_11 0.0011997f
C1001 BLB_4_2 WL_1_12 0.00131967f
C1002 BLB_4_2 WL_1_13 0.00131967f
C1003 BLB_4_2 WL_1_16 0.0006067f
C1004 BLB_4_2 WL_1_17 0.0006067f
C1005 BLB_4_2 WL_1_18 0.0006067f
C1006 BLB_4_2 WL_1_19 0.0006067f
C1007 BLB_4_2 WL_1_2 0.000796764f
C1008 BLB_4_2 WL_1_20 0.0006067f
C1009 BLB_4_2 WL_1_21 0.0006067f
C1010 BLB_4_2 WL_1_22 0.0006067f
C1011 BLB_4_2 WL_1_23 0.0006067f
C1012 BLB_4_2 WL_1_24 0.0006067f
C1013 BLB_4_2 WL_1_25 0.0006067f
C1014 BLB_4_2 WL_1_3 0.000796764f
C1015 BLB_4_2 WL_1_4 0.000796764f
C1016 BLB_4_2 WL_1_5 0.000796764f
C1017 BLB_4_2 WL_1_9 0.00083979f
C1018 BLB_4_2 XB_1_3_1 1.62686e-05f
C1019 BLB_4_2 XB_1_4 0.00220457f
C1020 BLB_4_2 XB_1_4_1 0.00921597f
C1021 BLB_4_2 XB_1_4_2 0.00130257f
C1022 BLB_4_2 net135 1.20963e-05f
C1023 BLB_4_2 net135_10 1.1019e-05f
C1024 BLB_4_2 net135_2 1.04943e-05f
C1025 BLB_4_2 net135_3 1.13916e-05f
C1026 BLB_4_2 net135_4 1.14753e-05f
C1027 BLB_4_2 net137 0.00158779f
C1028 BLB_4_2 net137_10 0.00144638f
C1029 BLB_4_2 net137_2 0.0013775f
C1030 BLB_4_2 net137_3 0.00149529f
C1031 BLB_4_2 net137_4 0.00150627f
C1032 BLB_4_2 net137_5 0.000601576f
C1033 BLB_4_2 net137_6 0.000601576f
C1034 BLB_4_2 net137_7 0.000300788f
C1035 BLB_4_2 net137_9 0.000930812f
C1036 BLB_4_2 net71 4.96632e-05f
C1037 BLB_4_2 net86 1.74999e-05f
C1038 BLB_4_2 net86_2 2.27952e-05f
C1039 BLB_4_2 net86_3 2.27952e-05f
C1040 BLB_4_2 net86_4 1.65101e-05f
C1041 BLB_4_2 net86_5 3.88073e-05f
C1042 BLB_4_2 net86_7 5.90053e-05f
C1043 BLB_4_2 net87 5.16651e-05f
C1044 BLB_5 BLB_6_1 0.000168472f
C1045 BLB_5 BLB_7_1 3.72286e-05f
C1046 BLB_5 BL_3 1.68738e-05f
C1047 BLB_5 BL_4 6.4234e-05f
C1048 BLB_5 BL_5 0.000497551f
C1049 BLB_5 BL_6 0.00525661f
C1050 BLB_5 BL_7 7.48114e-05f
C1051 BLB_5 P_0_5_4 0.00155814f
C1052 BLB_5 P_0_5_5 0.0030602f
C1053 BLB_5 P_0_6 1.69844e-05f
C1054 BLB_5 P_0_6_1 3.63833e-05f
C1055 BLB_5 P_0_6_2 6.61892e-05f
C1056 BLB_5 P_0_6_4 1.48031e-05f
C1057 BLB_5 P_0_6_5 2.90733e-05f
C1058 BLB_5 P_0_7_2 1.04471e-05f
C1059 BLB_5 P_1_5_3 0.00305796f
C1060 BLB_5 P_1_6 1.55434e-05f
C1061 BLB_5 P_1_6_1 3.32963e-05f
C1062 BLB_5 P_1_6_2 6.05734e-05f
C1063 BLB_5 P_1_6_3 2.66066e-05f
C1064 BLB_5 P_1_6_5 1.35471e-05f
C1065 BLB_5 P_1_7_2 1.06331e-05f
C1066 BLB_5 VDD_1 0.000585471f
C1067 BLB_5 VSS_0 0.0253791f
C1068 BLB_5 VSS_2 0.00636189f
C1069 BLB_5 WL_0_15 0.00287714f
C1070 BLB_5 WL_0_28 0.000606249f
C1071 BLB_5 WL_0_29 0.000606249f
C1072 BLB_5 WL_0_30 0.000606249f
C1073 BLB_5 WL_0_31 0.000606249f
C1074 BLB_5 WL_0_7 0.000796172f
C1075 BLB_5 WL_0_8 0.000796172f
C1076 BLB_5 WL_1_15 0.00289885f
C1077 BLB_5 WL_1_28 0.000610823f
C1078 BLB_5 WL_1_29 0.000610823f
C1079 BLB_5 WL_1_30 0.000610823f
C1080 BLB_5 WL_1_31 0.000610823f
C1081 BLB_5 WL_1_7 0.000802178f
C1082 BLB_5 WL_1_8 0.000802178f
C1083 BLB_5 XB_0_5 0.00223442f
C1084 BLB_5 XB_0_5_1 0.00934076f
C1085 BLB_5 XB_0_5_2 0.00132021f
C1086 BLB_5 XB_0_5_3 0.00264041f
C1087 BLB_5 XB_0_6_1 3.56845e-05f
C1088 BLB_5 XB_0_6_3 1.00872e-05f
C1089 BLB_5 XB_1_5_3 0.00263803f
C1090 BLB_5 XB_1_6_1 2.92652e-05f
C1091 BLB_5 net139_8 0.000609808f
C1092 BLB_5 net141 0.000158218f
C1093 BLB_5 net141_10 0.000144127f
C1094 BLB_5 net141_2 0.000137264f
C1095 BLB_5 net141_3 0.000149001f
C1096 BLB_5 net141_4 0.000150095f
C1097 BLB_5 net141_5 5.99451e-05f
C1098 BLB_5 net141_6 5.99451e-05f
C1099 BLB_5 net141_7 2.99725e-05f
C1100 BLB_5 net141_8 5.99451e-05f
C1101 BLB_5 net141_9 9.27524e-05f
C1102 BLB_5 net20_2 0.00140845f
C1103 BLB_5 net20_8 0.000615093f
C1104 BLB_5 net23 1.30349e-05f
C1105 BLB_5 net23_2 1.69792e-05f
C1106 BLB_5 net23_3 1.69792e-05f
C1107 BLB_5 net23_4 2.89059e-05f
C1108 BLB_5 net23_6 1.22977e-05f
C1109 BLB_5 net23_7 4.39505e-05f
C1110 BLB_5 net24 0.000155973f
C1111 BLB_5 net24_11 9.14364e-05f
C1112 BLB_5 net24_2 0.000135316f
C1113 BLB_5 net24_3 0.000146887f
C1114 BLB_5 net24_4 0.000147965f
C1115 BLB_5 net24_5 5.90946e-05f
C1116 BLB_5 net24_6 5.90946e-05f
C1117 BLB_5 net24_7 2.95473e-05f
C1118 BLB_5 net24_8 5.90946e-05f
C1119 BLB_5 net24_9 0.000142082f
C1120 BLB_5 net72 9.16787e-05f
C1121 BLB_5 net90 9.98511e-05f
C1122 BLB_5 net91 1.43453e-05f
C1123 BLB_5 net91_2 1.86861e-05f
C1124 BLB_5 net91_3 1.86861e-05f
C1125 BLB_5 net91_4 1.3534e-05f
C1126 BLB_5 net91_5 3.18119e-05f
C1127 BLB_5 net91_7 4.8369e-05f
C1128 BLB_5_1 BLB_6_1 0.000105495f
C1129 BLB_5_1 BLB_7_1 2.33121e-05f
C1130 BLB_5_1 BL_2 1.73875e-05f
C1131 BLB_5_1 BL_3_1 1.05662e-05f
C1132 BLB_5_1 BL_4_1 4.02226e-05f
C1133 BLB_5_1 BL_5_1 0.000311561f
C1134 BLB_5_1 BL_6_1 0.00329163f
C1135 BLB_5_1 BL_7 4.68461e-05f
C1136 BLB_5_1 P_0_5 0.00178774f
C1137 BLB_5_1 P_0_5_1 0.00382963f
C1138 BLB_5_1 P_0_5_2 0.00696695f
C1139 BLB_5_1 P_0_5_3 0.000772937f
C1140 BLB_5_1 VDD_1 0.000366615f
C1141 BLB_5_1 VSS_0 0.0158921f
C1142 BLB_5_1 VSS_2 0.00398374f
C1143 BLB_5_1 WL_0 0.000304679f
C1144 BLB_5_1 WL_0_1 0.000731255f
C1145 BLB_5_1 WL_0_10 0.00131869f
C1146 BLB_5_1 WL_0_11 0.00119881f
C1147 BLB_5_1 WL_0_12 0.00131869f
C1148 BLB_5_1 WL_0_13 0.00131869f
C1149 BLB_5_1 WL_0_14 0.00131869f
C1150 BLB_5_1 WL_0_16 0.000606249f
C1151 BLB_5_1 WL_0_17 0.000606249f
C1152 BLB_5_1 WL_0_18 0.000606249f
C1153 BLB_5_1 WL_0_19 0.000606249f
C1154 BLB_5_1 WL_0_2 0.000796172f
C1155 BLB_5_1 WL_0_20 0.000606249f
C1156 BLB_5_1 WL_0_21 0.000606249f
C1157 BLB_5_1 WL_0_22 0.000606249f
C1158 BLB_5_1 WL_0_23 0.000606249f
C1159 BLB_5_1 WL_0_24 0.000606249f
C1160 BLB_5_1 WL_0_25 0.000606249f
C1161 BLB_5_1 WL_0_26 0.000606249f
C1162 BLB_5_1 WL_0_27 0.000606249f
C1163 BLB_5_1 WL_0_3 0.000796172f
C1164 BLB_5_1 WL_0_4 0.000796172f
C1165 BLB_5_1 WL_0_5 0.000796172f
C1166 BLB_5_1 WL_0_6 0.000796172f
C1167 BLB_5_1 WL_0_9 0.000839166f
C1168 BLB_5_1 net17 1.2438e-05f
C1169 BLB_5_1 net17_2 1.07907e-05f
C1170 BLB_5_1 net17_3 1.17134e-05f
C1171 BLB_5_1 net17_4 1.17994e-05f
C1172 BLB_5_1 net17_9 1.13303e-05f
C1173 BLB_5_1 net19 3.26449e-05f
C1174 BLB_5_1 net19_2 4.2523e-05f
C1175 BLB_5_1 net19_3 4.2523e-05f
C1176 BLB_5_1 net19_4 7.23926e-05f
C1177 BLB_5_1 net19_6 3.07986e-05f
C1178 BLB_5_1 net19_7 0.000110071f
C1179 BLB_5_1 net20 0.00162346f
C1180 BLB_5_1 net20_11 0.000951727f
C1181 BLB_5_1 net20_3 0.00152889f
C1182 BLB_5_1 net20_4 0.00154011f
C1183 BLB_5_1 net20_5 0.000615093f
C1184 BLB_5_1 net20_6 0.000615093f
C1185 BLB_5_1 net20_7 0.000307547f
C1186 BLB_5_1 net20_9 0.00147888f
C1187 BLB_5_1 net72 5.74082e-05f
C1188 BLB_5_1 net90 6.25256e-05f
C1189 BLB_5_2 BLB_6_2 0.000119458f
C1190 BLB_5_2 BLB_7_2 2.63976e-05f
C1191 BLB_5_2 BL_3_2 1.19647e-05f
C1192 BLB_5_2 BL_4_2 4.55464e-05f
C1193 BLB_5_2 BL_5_2 0.000352798f
C1194 BLB_5_2 BL_6_2 0.0037273f
C1195 BLB_5_2 BL_7_2 5.30465e-05f
C1196 BLB_5_2 P_1_5 0.00178644f
C1197 BLB_5_2 P_1_5_1 0.00382683f
C1198 BLB_5_2 P_1_5_2 0.00696185f
C1199 BLB_5_2 P_1_5_4 0.000772371f
C1200 BLB_5_2 P_1_5_5 0.001557f
C1201 BLB_5_2 VDD_1 0.000415139f
C1202 BLB_5_2 VSS_0 0.0179956f
C1203 BLB_5_2 VSS_2 0.00451102f
C1204 BLB_5_2 WL_1 0.000306977f
C1205 BLB_5_2 WL_1_1 0.000736771f
C1206 BLB_5_2 WL_1_10 0.00132864f
C1207 BLB_5_2 WL_1_11 0.00120785f
C1208 BLB_5_2 WL_1_12 0.00132864f
C1209 BLB_5_2 WL_1_13 0.00132864f
C1210 BLB_5_2 WL_1_14 0.00132864f
C1211 BLB_5_2 WL_1_16 0.000610823f
C1212 BLB_5_2 WL_1_17 0.000610823f
C1213 BLB_5_2 WL_1_18 0.000610823f
C1214 BLB_5_2 WL_1_19 0.000610823f
C1215 BLB_5_2 WL_1_2 0.000802178f
C1216 BLB_5_2 WL_1_20 0.000610823f
C1217 BLB_5_2 WL_1_21 0.000610823f
C1218 BLB_5_2 WL_1_22 0.000610823f
C1219 BLB_5_2 WL_1_23 0.000610823f
C1220 BLB_5_2 WL_1_24 0.000610823f
C1221 BLB_5_2 WL_1_25 0.000610823f
C1222 BLB_5_2 WL_1_26 0.000610823f
C1223 BLB_5_2 WL_1_27 0.000610823f
C1224 BLB_5_2 WL_1_3 0.000802178f
C1225 BLB_5_2 WL_1_4 0.000802178f
C1226 BLB_5_2 WL_1_5 0.000802178f
C1227 BLB_5_2 WL_1_6 0.000802178f
C1228 BLB_5_2 WL_1_9 0.000845496f
C1229 BLB_5_2 XB_1_5 0.0022324f
C1230 BLB_5_2 XB_1_5_1 0.00933231f
C1231 BLB_5_2 XB_1_5_2 0.00131901f
C1232 BLB_5_2 net139 0.00160952f
C1233 BLB_5_2 net139_10 0.00146617f
C1234 BLB_5_2 net139_2 0.00139635f
C1235 BLB_5_2 net139_3 0.00151575f
C1236 BLB_5_2 net139_4 0.00152688f
C1237 BLB_5_2 net139_5 0.000609808f
C1238 BLB_5_2 net139_6 0.000609808f
C1239 BLB_5_2 net139_7 0.000304904f
C1240 BLB_5_2 net139_9 0.00094355f
C1241 BLB_5_2 net72 6.50066e-05f
C1242 BLB_5_2 net88 3.13709e-05f
C1243 BLB_5_2 net88_2 4.08636e-05f
C1244 BLB_5_2 net88_3 4.08636e-05f
C1245 BLB_5_2 net88_4 2.95967e-05f
C1246 BLB_5_2 net88_5 6.95675e-05f
C1247 BLB_5_2 net88_7 0.000105775f
C1248 BLB_5_2 net90 7.08013e-05f
C1249 BLB_6 BLB_7_1 0.000214312f
C1250 BLB_6 BL_3 1.53972e-05f
C1251 BLB_6 BL_4 1.99268e-05f
C1252 BLB_6 BL_5 4.85509e-05f
C1253 BLB_6 BL_7 0.00523687f
C1254 BLB_6 P_0_6_4 0.00155314f
C1255 BLB_6 P_0_6_5 0.00305037f
C1256 BLB_6 P_0_7 1.68709e-05f
C1257 BLB_6 P_0_7_1 3.61401e-05f
C1258 BLB_6 P_0_7_2 6.57468e-05f
C1259 BLB_6 P_0_7_4 1.47041e-05f
C1260 BLB_6 P_0_7_5 2.8879e-05f
C1261 BLB_6 P_1_6_3 0.00306671f
C1262 BLB_6 P_1_7 1.85568e-05f
C1263 BLB_6 P_1_7_1 3.97515e-05f
C1264 BLB_6 P_1_7_2 7.23168e-05f
C1265 BLB_6 P_1_7_3 3.17648e-05f
C1266 BLB_6 P_1_7_5 1.61735e-05f
C1267 BLB_6 VDD_1 0.000718638f
C1268 BLB_6 VSS_0 0.0257077f
C1269 BLB_6 VSS_2 0.00635786f
C1270 BLB_6 WL_0_30 0.000605804f
C1271 BLB_6 WL_0_31 0.000605804f
C1272 BLB_6 WL_0_8 0.000795587f
C1273 BLB_6 WL_1_30 0.000612251f
C1274 BLB_6 WL_1_31 0.000612251f
C1275 BLB_6 WL_1_8 0.000804054f
C1276 BLB_6 XB_0_6 0.00219818f
C1277 BLB_6 XB_0_6_1 0.00918927f
C1278 BLB_6 XB_0_6_2 0.0012988f
C1279 BLB_6 XB_0_6_3 0.00259759f
C1280 BLB_6 XB_0_7_1 3.62319e-05f
C1281 BLB_6 XB_0_7_3 1.02419e-05f
C1282 BLB_6 XB_1_6_3 0.00260463f
C1283 BLB_6 XB_1_7 1.0819e-05f
C1284 BLB_6 XB_1_7_1 4.52278e-05f
C1285 BLB_6 XB_1_7_3 1.27848e-05f
C1286 BLB_6 net141_8 0.000595206f
C1287 BLB_6 net142 0.000138335f
C1288 BLB_6 net142_10 0.000126015f
C1289 BLB_6 net142_2 0.000120014f
C1290 BLB_6 net142_3 0.000130276f
C1291 BLB_6 net142_4 0.000131233f
C1292 BLB_6 net142_5 5.24119e-05f
C1293 BLB_6 net142_6 5.24119e-05f
C1294 BLB_6 net142_7 2.6206e-05f
C1295 BLB_6 net142_8 5.24119e-05f
C1296 BLB_6 net142_9 8.10964e-05f
C1297 BLB_6 net24_2 0.0013738f
C1298 BLB_6 net24_8 0.000599958f
C1299 BLB_6 net27_7 1.33667e-05f
C1300 BLB_6 net28 0.000131343f
C1301 BLB_6 net28_11 7.69976e-05f
C1302 BLB_6 net28_2 0.000113948f
C1303 BLB_6 net28_3 0.000123692f
C1304 BLB_6 net28_4 0.0001246f
C1305 BLB_6 net28_5 4.97629e-05f
C1306 BLB_6 net28_6 4.97629e-05f
C1307 BLB_6 net28_7 2.48814e-05f
C1308 BLB_6 net28_8 4.97629e-05f
C1309 BLB_6 net28_9 0.000119646f
C1310 BLB_6 net73 5.82276e-05f
C1311 BLB_6 net93 6.73054e-05f
C1312 BLB_6_1 BLB_7_1 0.0001342f
C1313 BLB_6_1 BL_2 1.1849e-05f
C1314 BLB_6_1 BL_4_1 1.24779e-05f
C1315 BLB_6_1 BL_5_1 3.04021e-05f
C1316 BLB_6_1 BL_6 0.000686404f
C1317 BLB_6_1 BL_6_1 0.00025613f
C1318 BLB_6_1 BL_7_1 0.00327927f
C1319 BLB_6_1 P_0_4_2 1.00087e-05f
C1320 BLB_6_1 P_0_5_2 1.57431e-05f
C1321 BLB_6_1 P_0_6 0.001782f
C1322 BLB_6_1 P_0_6_1 0.00381733f
C1323 BLB_6_1 P_0_6_2 0.00694456f
C1324 BLB_6_1 P_0_6_3 0.000770454f
C1325 BLB_6_1 VDD_1 0.000450003f
C1326 BLB_6_1 VSS_0 0.0160979f
C1327 BLB_6_1 VSS_2 0.00398122f
C1328 BLB_6_1 WL_0 0.000304455f
C1329 BLB_6_1 WL_0_1 0.000730718f
C1330 BLB_6_1 WL_0_10 0.00131772f
C1331 BLB_6_1 WL_0_11 0.00119793f
C1332 BLB_6_1 WL_0_12 0.00131772f
C1333 BLB_6_1 WL_0_13 0.00131772f
C1334 BLB_6_1 WL_0_14 0.00131772f
C1335 BLB_6_1 WL_0_15 0.00287503f
C1336 BLB_6_1 WL_0_16 0.000605804f
C1337 BLB_6_1 WL_0_17 0.000605804f
C1338 BLB_6_1 WL_0_18 0.000605804f
C1339 BLB_6_1 WL_0_19 0.000605804f
C1340 BLB_6_1 WL_0_2 0.000795587f
C1341 BLB_6_1 WL_0_20 0.000605804f
C1342 BLB_6_1 WL_0_21 0.000605804f
C1343 BLB_6_1 WL_0_22 0.000605804f
C1344 BLB_6_1 WL_0_23 0.000605804f
C1345 BLB_6_1 WL_0_24 0.000605804f
C1346 BLB_6_1 WL_0_25 0.000605804f
C1347 BLB_6_1 WL_0_26 0.000605804f
C1348 BLB_6_1 WL_0_27 0.000605804f
C1349 BLB_6_1 WL_0_28 0.000605804f
C1350 BLB_6_1 WL_0_29 0.000605804f
C1351 BLB_6_1 WL_0_3 0.000795587f
C1352 BLB_6_1 WL_0_4 0.000795587f
C1353 BLB_6_1 WL_0_5 0.000795587f
C1354 BLB_6_1 WL_0_6 0.000795587f
C1355 BLB_6_1 WL_0_7 0.000795587f
C1356 BLB_6_1 WL_0_9 0.00083855f
C1357 BLB_6_1 XB_0_5_1 1.48573e-05f
C1358 BLB_6_1 net20 1.50913e-05f
C1359 BLB_6_1 net20_2 1.30926e-05f
C1360 BLB_6_1 net20_3 1.42121e-05f
C1361 BLB_6_1 net20_4 1.43165e-05f
C1362 BLB_6_1 net20_9 1.37472e-05f
C1363 BLB_6_1 net23 3.70908e-05f
C1364 BLB_6_1 net23_2 4.83143e-05f
C1365 BLB_6_1 net23_3 4.83143e-05f
C1366 BLB_6_1 net23_4 8.22518e-05f
C1367 BLB_6_1 net23_6 3.49931e-05f
C1368 BLB_6_1 net23_7 0.000125061f
C1369 BLB_6_1 net24 0.00158352f
C1370 BLB_6_1 net24_11 0.000928309f
C1371 BLB_6_1 net24_3 0.00149127f
C1372 BLB_6_1 net24_4 0.00150222f
C1373 BLB_6_1 net24_5 0.000599958f
C1374 BLB_6_1 net24_6 0.000599958f
C1375 BLB_6_1 net24_7 0.000299979f
C1376 BLB_6_1 net24_9 0.00144249f
C1377 BLB_6_1 net73 3.64615e-05f
C1378 BLB_6_1 net93 4.21459e-05f
C1379 BLB_6_2 BLB_7_2 0.000151962f
C1380 BLB_6_2 BL_3_2 1.09177e-05f
C1381 BLB_6_2 BL_4_2 1.41295e-05f
C1382 BLB_6_2 BL_5_2 3.4426e-05f
C1383 BLB_6_2 BL_6_2 0.00025613f
C1384 BLB_6_2 BL_7_2 0.00371331f
C1385 BLB_6_2 P_1_5_2 1.67869e-05f
C1386 BLB_6_2 P_1_6 0.00179155f
C1387 BLB_6_2 P_1_6_1 0.00383778f
C1388 BLB_6_2 P_1_6_2 0.00698177f
C1389 BLB_6_2 P_1_6_4 0.000774581f
C1390 BLB_6_2 P_1_6_5 0.00156146f
C1391 BLB_6_2 VDD_1 0.000509564f
C1392 BLB_6_2 VSS_0 0.0182285f
C1393 BLB_6_2 VSS_2 0.00450817f
C1394 BLB_6_2 WL_1 0.000307695f
C1395 BLB_6_2 WL_1_1 0.000738494f
C1396 BLB_6_2 WL_1_10 0.00133175f
C1397 BLB_6_2 WL_1_11 0.00121068f
C1398 BLB_6_2 WL_1_12 0.00133175f
C1399 BLB_6_2 WL_1_13 0.00133175f
C1400 BLB_6_2 WL_1_14 0.00133175f
C1401 BLB_6_2 WL_1_15 0.00290563f
C1402 BLB_6_2 WL_1_16 0.000612251f
C1403 BLB_6_2 WL_1_17 0.000612251f
C1404 BLB_6_2 WL_1_18 0.000612251f
C1405 BLB_6_2 WL_1_19 0.000612251f
C1406 BLB_6_2 WL_1_2 0.000804054f
C1407 BLB_6_2 WL_1_20 0.000612251f
C1408 BLB_6_2 WL_1_21 0.000612251f
C1409 BLB_6_2 WL_1_22 0.000612251f
C1410 BLB_6_2 WL_1_23 0.000612251f
C1411 BLB_6_2 WL_1_24 0.000612251f
C1412 BLB_6_2 WL_1_25 0.000612251f
C1413 BLB_6_2 WL_1_26 0.000612251f
C1414 BLB_6_2 WL_1_27 0.000612251f
C1415 BLB_6_2 WL_1_28 0.000612251f
C1416 BLB_6_2 WL_1_29 0.000612251f
C1417 BLB_6_2 WL_1_3 0.000804054f
C1418 BLB_6_2 WL_1_4 0.000804054f
C1419 BLB_6_2 WL_1_5 0.000804054f
C1420 BLB_6_2 WL_1_6 0.000804054f
C1421 BLB_6_2 WL_1_7 0.000804054f
C1422 BLB_6_2 WL_1_9 0.000847474f
C1423 BLB_6_2 XB_1_5_1 2.91847e-05f
C1424 BLB_6_2 XB_1_6 0.00220414f
C1425 BLB_6_2 XB_1_6_1 0.00921417f
C1426 BLB_6_2 XB_1_6_2 0.00130231f
C1427 BLB_6_2 net141 0.00157097f
C1428 BLB_6_2 net141_10 0.00143106f
C1429 BLB_6_2 net141_2 0.00136292f
C1430 BLB_6_2 net141_3 0.00147945f
C1431 BLB_6_2 net141_4 0.00149032f
C1432 BLB_6_2 net141_5 0.000595206f
C1433 BLB_6_2 net141_6 0.000595206f
C1434 BLB_6_2 net141_7 0.000297603f
C1435 BLB_6_2 net141_9 0.000920956f
C1436 BLB_6_2 net73 4.12874e-05f
C1437 BLB_6_2 net91 2.40558e-05f
C1438 BLB_6_2 net91_2 3.13349e-05f
C1439 BLB_6_2 net91_3 3.13349e-05f
C1440 BLB_6_2 net91_4 2.26953e-05f
C1441 BLB_6_2 net91_5 5.33457e-05f
C1442 BLB_6_2 net91_7 8.11104e-05f
C1443 BLB_6_2 net93 4.77242e-05f
C1444 BLB_7 BL_3 1.01984e-05f
C1445 BLB_7 BL_4 1.52448e-05f
C1446 BLB_7 BL_5 2.44012e-05f
C1447 BLB_7 P_0_7_4 0.00158021f
C1448 BLB_7 P_0_7_5 0.00310354f
C1449 BLB_7 P_1_7_3 0.00310731f
C1450 BLB_7 VDD_1 0.000823108f
C1451 BLB_7 VSS_0 0.0291999f
C1452 BLB_7 VSS_2 0.00628866f
C1453 BLB_7 XB_0_7 0.00232234f
C1454 BLB_7 XB_0_7_1 0.0097083f
C1455 BLB_7 XB_0_7_2 0.00137215f
C1456 BLB_7 XB_0_7_3 0.00274431f
C1457 BLB_7 XB_1_7_3 0.0027616f
C1458 BLB_7 net142_8 0.000624955f
C1459 BLB_7 net28_2 0.00140105f
C1460 BLB_7 net28_8 0.000611861f
C1461 BLB_7 net74 0.000114255f
C1462 BLB_7 net96 0.00012147f
C1463 BLB_7_1 BL_5_1 1.52798e-05f
C1464 BLB_7_1 BL_6 0.000136571f
C1465 BLB_7_1 BL_6_1 5.09612e-05f
C1466 BLB_7_1 BL_7 0.000768721f
C1467 BLB_7_1 BL_7_1 0.000286847f
C1468 BLB_7_1 P_0_7 0.00181307f
C1469 BLB_7_1 P_0_7_1 0.00388387f
C1470 BLB_7_1 P_0_7_2 0.00706562f
C1471 BLB_7_1 P_0_7_3 0.000783884f
C1472 BLB_7_1 VDD_1 0.000515421f
C1473 BLB_7_1 VSS_0 0.0182846f
C1474 BLB_7_1 VSS_2 0.00393789f
C1475 BLB_7_1 WL_0 0.000303341f
C1476 BLB_7_1 WL_0_1 0.000728044f
C1477 BLB_7_1 WL_0_10 0.0013129f
C1478 BLB_7_1 WL_0_11 0.00119355f
C1479 BLB_7_1 WL_0_12 0.0013129f
C1480 BLB_7_1 WL_0_13 0.0013129f
C1481 BLB_7_1 WL_0_14 0.0013129f
C1482 BLB_7_1 WL_0_15 0.00286451f
C1483 BLB_7_1 WL_0_16 0.000603588f
C1484 BLB_7_1 WL_0_17 0.000603588f
C1485 BLB_7_1 WL_0_18 0.000603588f
C1486 BLB_7_1 WL_0_19 0.000603588f
C1487 BLB_7_1 WL_0_2 0.000792676f
C1488 BLB_7_1 WL_0_20 0.000603588f
C1489 BLB_7_1 WL_0_21 0.000603588f
C1490 BLB_7_1 WL_0_22 0.000603588f
C1491 BLB_7_1 WL_0_23 0.000603588f
C1492 BLB_7_1 WL_0_24 0.000603588f
C1493 BLB_7_1 WL_0_25 0.000603588f
C1494 BLB_7_1 WL_0_26 0.000603588f
C1495 BLB_7_1 WL_0_27 0.000603588f
C1496 BLB_7_1 WL_0_28 0.000603588f
C1497 BLB_7_1 WL_0_29 0.000603588f
C1498 BLB_7_1 WL_0_3 0.000792676f
C1499 BLB_7_1 WL_0_30 0.000603588f
C1500 BLB_7_1 WL_0_31 0.000603588f
C1501 BLB_7_1 WL_0_4 0.000792676f
C1502 BLB_7_1 WL_0_5 0.000792676f
C1503 BLB_7_1 WL_0_6 0.000792676f
C1504 BLB_7_1 WL_0_7 0.000792676f
C1505 BLB_7_1 WL_0_8 0.000792676f
C1506 BLB_7_1 WL_0_9 0.000835482f
C1507 BLB_7_1 net23_7 1.25911e-05f
C1508 BLB_7_1 net27 3.64692e-05f
C1509 BLB_7_1 net27_2 4.75046e-05f
C1510 BLB_7_1 net27_3 4.75046e-05f
C1511 BLB_7_1 net27_4 8.08734e-05f
C1512 BLB_7_1 net27_6 3.44067e-05f
C1513 BLB_7_1 net27_7 0.000122965f
C1514 BLB_7_1 net28 0.00161493f
C1515 BLB_7_1 net28_11 0.000946726f
C1516 BLB_7_1 net28_3 0.00152085f
C1517 BLB_7_1 net28_4 0.00153202f
C1518 BLB_7_1 net28_5 0.000611861f
C1519 BLB_7_1 net28_6 0.000611861f
C1520 BLB_7_1 net28_7 0.00030593f
C1521 BLB_7_1 net28_9 0.0014711f
C1522 BLB_7_1 net74 7.15455e-05f
C1523 BLB_7_1 net96 7.60631e-05f
C1524 BLB_7_2 BL_4_2 1.08096e-05f
C1525 BLB_7_2 BL_5_2 1.73022e-05f
C1526 BLB_7_2 BL_6_2 5.09612e-05f
C1527 BLB_7_2 BL_7_2 0.000286847f
C1528 BLB_7_2 P_1_6_1 1.16273e-05f
C1529 BLB_7_2 P_1_6_2 2.11527e-05f
C1530 BLB_7_2 P_1_7 0.00181527f
C1531 BLB_7_2 P_1_7_1 0.00388859f
C1532 BLB_7_2 P_1_7_2 0.00707421f
C1533 BLB_7_2 P_1_7_4 0.000784837f
C1534 BLB_7_2 P_1_7_5 0.00158213f
C1535 BLB_7_2 VDD_1 0.000583641f
C1536 BLB_7_2 VSS_0 0.0207047f
C1537 BLB_7_2 VSS_2 0.0044591f
C1538 BLB_7_2 WL_1 0.000302954f
C1539 BLB_7_2 WL_1_1 0.000727115f
C1540 BLB_7_2 WL_1_10 0.00131122f
C1541 BLB_7_2 WL_1_11 0.00119202f
C1542 BLB_7_2 WL_1_12 0.00131122f
C1543 BLB_7_2 WL_1_13 0.00131122f
C1544 BLB_7_2 WL_1_14 0.00131122f
C1545 BLB_7_2 WL_1_15 0.00286085f
C1546 BLB_7_2 WL_1_16 0.000602818f
C1547 BLB_7_2 WL_1_17 0.000602818f
C1548 BLB_7_2 WL_1_18 0.000602818f
C1549 BLB_7_2 WL_1_19 0.000602818f
C1550 BLB_7_2 WL_1_2 0.000791665f
C1551 BLB_7_2 WL_1_20 0.000602818f
C1552 BLB_7_2 WL_1_21 0.000602818f
C1553 BLB_7_2 WL_1_22 0.000602818f
C1554 BLB_7_2 WL_1_23 0.000602818f
C1555 BLB_7_2 WL_1_24 0.000602818f
C1556 BLB_7_2 WL_1_25 0.000602818f
C1557 BLB_7_2 WL_1_26 0.000602818f
C1558 BLB_7_2 WL_1_27 0.000602818f
C1559 BLB_7_2 WL_1_28 0.000602818f
C1560 BLB_7_2 WL_1_29 0.000602818f
C1561 BLB_7_2 WL_1_3 0.000791665f
C1562 BLB_7_2 WL_1_30 0.000602818f
C1563 BLB_7_2 WL_1_31 0.000602818f
C1564 BLB_7_2 WL_1_4 0.000791665f
C1565 BLB_7_2 WL_1_5 0.000791665f
C1566 BLB_7_2 WL_1_6 0.000791665f
C1567 BLB_7_2 WL_1_7 0.000791665f
C1568 BLB_7_2 WL_1_8 0.000791665f
C1569 BLB_7_2 WL_1_9 0.000834416f
C1570 BLB_7_2 XB_1_4_1 1.02936e-05f
C1571 BLB_7_2 XB_1_7 0.00233698f
C1572 BLB_7_2 XB_1_7_1 0.00976947f
C1573 BLB_7_2 XB_1_7_2 0.0013808f
C1574 BLB_7_2 net141 1.4291e-05f
C1575 BLB_7_2 net141_10 1.30183e-05f
C1576 BLB_7_2 net141_2 1.23983e-05f
C1577 BLB_7_2 net141_3 1.34585e-05f
C1578 BLB_7_2 net141_4 1.35573e-05f
C1579 BLB_7_2 net142 0.00164949f
C1580 BLB_7_2 net142_10 0.00150259f
C1581 BLB_7_2 net142_2 0.00143104f
C1582 BLB_7_2 net142_3 0.0015534f
C1583 BLB_7_2 net142_4 0.00156481f
C1584 BLB_7_2 net142_5 0.000624955f
C1585 BLB_7_2 net142_6 0.000624955f
C1586 BLB_7_2 net142_7 0.000312477f
C1587 BLB_7_2 net142_9 0.000966986f
C1588 BLB_7_2 net74 8.1015e-05f
C1589 BLB_7_2 net91_5 1.46612e-05f
C1590 BLB_7_2 net91_7 2.22919e-05f
C1591 BLB_7_2 net94 3.5387e-05f
C1592 BLB_7_2 net94_2 4.60949e-05f
C1593 BLB_7_2 net94_3 4.60949e-05f
C1594 BLB_7_2 net94_4 3.33857e-05f
C1595 BLB_7_2 net94_5 7.84735e-05f
C1596 BLB_7_2 net94_7 0.000119316f
C1597 BLB_7_2 net96 8.61306e-05f
C1598 BL_0 BL_3 3.04301e-05f
C1599 BL_0 BL_4 1.65099e-05f
C1600 BL_0 BL_5 1.11891e-05f
C1601 BL_0 P_0_0 3.8999e-05f
C1602 BL_0 P_0_0_2 0.000151981f
C1603 BL_0 P_0_0_5 6.67571e-05f
C1604 BL_0 VDD_1 0.00108756f
C1605 BL_0 VSS_0 0.0367405f
C1606 BL_0 VSS_2 0.00686948f
C1607 BL_0 WL_0 0.000299702f
C1608 BL_0 WL_0_1 0.000719311f
C1609 BL_0 WL_0_10 0.00129715f
C1610 BL_0 WL_0_11 0.00117923f
C1611 BL_0 WL_0_12 0.00129715f
C1612 BL_0 WL_0_2 0.000783168f
C1613 BL_0 WL_0_3 0.000783168f
C1614 BL_0 WL_0_4 0.000783168f
C1615 BL_0 WL_0_9 0.00082546f
C1616 BL_0 XB_0_0_1 5.52403e-05f
C1617 BL_0 XB_0_0_3 1.56151e-05f
C1618 BL_0 net2 0.000591715f
C1619 BL_0 net2_3 0.000770764f
C1620 BL_0 net2_6 0.00055825f
C1621 BL_0 net2_7 0.00199512f
C1622 BL_0 net3 0.00163587f
C1623 BL_0 net3_11 0.000959f
C1624 BL_0 net3_2 0.00141922f
C1625 BL_0 net3_3 0.00154057f
C1626 BL_0 net3_4 0.00155188f
C1627 BL_0 net3_6 0.000619794f
C1628 BL_0 net3_8 0.000619794f
C1629 BL_0 net68 1.63901e-05f
C1630 BL_0 net6_7 1.56274e-05f
C1631 BL_0 net7 1.38661e-05f
C1632 BL_0 net7_2 1.20297e-05f
C1633 BL_0 net7_3 1.30583e-05f
C1634 BL_0 net7_4 1.31542e-05f
C1635 BL_0 net80 1.31504e-05f
C1636 BL_0_1 BL_1 0.000201218f
C1637 BL_0_1 BL_1_1 7.50843e-05f
C1638 BL_0_1 BL_2 5.48068e-05f
C1639 BL_0_1 BL_2_1 2.04511e-05f
C1640 BL_0_1 BL_3 1.13549e-05f
C1641 BL_0_1 BL_6 1.13561e-05f
C1642 BL_0_1 BL_7 1.00632e-05f
C1643 BL_0_1 P_0_0_1 8.35419e-05f
C1644 BL_0_1 P_0_0_3 1.68613e-05f
C1645 BL_0_1 P_0_0_4 3.39903e-05f
C1646 BL_0_1 P_0_1_1 1.22665e-05f
C1647 BL_0_1 P_0_1_2 2.23154e-05f
C1648 BL_0_1 VDD_1 0.000405823f
C1649 BL_0_1 VSS_0 0.0137097f
C1650 BL_0_1 VSS_2 0.00256333f
C1651 BL_0_1 WL_0_13 0.00129715f
C1652 BL_0_1 WL_0_14 0.00129715f
C1653 BL_0_1 WL_0_15 0.00283015f
C1654 BL_0_1 WL_0_16 0.000596348f
C1655 BL_0_1 WL_0_17 0.000596348f
C1656 BL_0_1 WL_0_18 0.000596348f
C1657 BL_0_1 WL_0_19 0.000596348f
C1658 BL_0_1 WL_0_20 0.000596348f
C1659 BL_0_1 WL_0_21 0.000596348f
C1660 BL_0_1 WL_0_22 0.000596348f
C1661 BL_0_1 WL_0_23 0.000596348f
C1662 BL_0_1 WL_0_24 0.000596348f
C1663 BL_0_1 WL_0_25 0.000596348f
C1664 BL_0_1 WL_0_26 0.000596348f
C1665 BL_0_1 WL_0_27 0.000596348f
C1666 BL_0_1 WL_0_28 0.000596348f
C1667 BL_0_1 WL_0_29 0.000596348f
C1668 BL_0_1 WL_0_30 0.000596348f
C1669 BL_0_1 WL_0_31 0.000596348f
C1670 BL_0_1 WL_0_5 0.000783168f
C1671 BL_0_1 WL_0_6 0.000783168f
C1672 BL_0_1 WL_0_7 0.000783168f
C1673 BL_0_1 WL_0_8 0.000783168f
C1674 BL_0_1 XB_0_0 1.32141e-05f
C1675 BL_0_1 XB_0_1_1 1.31564e-05f
C1676 BL_0_1 net2_2 0.000770764f
C1677 BL_0_1 net2_4 0.00131218f
C1678 BL_0_1 net3_5 0.000619794f
C1679 BL_0_1 net3_7 0.000309897f
C1680 BL_0_1 net3_9 0.00149018f
C1681 BL_0_1 net6_4 1.0278e-05f
C1682 BL_0_1 net7_9 1.26312e-05f
C1683 BL_0_2 BL_1_2 7.50843e-05f
C1684 BL_0_2 BL_2_2 2.04511e-05f
C1685 BL_0_2 BL_3_2 1.13549e-05f
C1686 BL_0_2 P_1_0 3.93747e-05f
C1687 BL_0_2 P_1_0_1 8.43468e-05f
C1688 BL_0_2 P_1_0_2 0.000153446f
C1689 BL_0_2 P_1_0_3 6.74003e-05f
C1690 BL_0_2 P_1_0_4 1.70238e-05f
C1691 BL_0_2 P_1_0_5 3.43178e-05f
C1692 BL_0_2 P_1_1_1 1.39459e-05f
C1693 BL_0_2 P_1_1_2 2.53706e-05f
C1694 BL_0_2 P_1_1_3 1.11439e-05f
C1695 BL_0_2 VDD_1 0.000405823f
C1696 BL_0_2 VSS_0 0.0137097f
C1697 BL_0_2 VSS_2 0.00256333f
C1698 BL_0_2 WL_1 0.000298234f
C1699 BL_0_2 WL_1_1 0.000715787f
C1700 BL_0_2 WL_1_10 0.0012908f
C1701 BL_0_2 WL_1_11 0.00117345f
C1702 BL_0_2 WL_1_12 0.0012908f
C1703 BL_0_2 WL_1_13 0.0012908f
C1704 BL_0_2 WL_1_14 0.0012908f
C1705 BL_0_2 WL_1_15 0.00281628f
C1706 BL_0_2 WL_1_16 0.000593426f
C1707 BL_0_2 WL_1_17 0.000593426f
C1708 BL_0_2 WL_1_18 0.000593426f
C1709 BL_0_2 WL_1_19 0.000593426f
C1710 BL_0_2 WL_1_2 0.000779331f
C1711 BL_0_2 WL_1_20 0.000593426f
C1712 BL_0_2 WL_1_21 0.000593426f
C1713 BL_0_2 WL_1_22 0.000593426f
C1714 BL_0_2 WL_1_23 0.000593426f
C1715 BL_0_2 WL_1_24 0.000593426f
C1716 BL_0_2 WL_1_25 0.000593426f
C1717 BL_0_2 WL_1_26 0.000593426f
C1718 BL_0_2 WL_1_27 0.000593426f
C1719 BL_0_2 WL_1_28 0.000593426f
C1720 BL_0_2 WL_1_29 0.000593426f
C1721 BL_0_2 WL_1_3 0.000779331f
C1722 BL_0_2 WL_1_30 0.000593426f
C1723 BL_0_2 WL_1_31 0.000593426f
C1724 BL_0_2 WL_1_4 0.000779331f
C1725 BL_0_2 WL_1_5 0.000779331f
C1726 BL_0_2 WL_1_6 0.000779331f
C1727 BL_0_2 WL_1_7 0.000779331f
C1728 BL_0_2 WL_1_8 0.000779331f
C1729 BL_0_2 WL_1_9 0.000821416f
C1730 BL_0_2 XB_1_0_1 3.80787e-05f
C1731 BL_0_2 XB_1_0_3 1.0764e-05f
C1732 BL_0_2 XB_1_1_1 1.82523e-05f
C1733 BL_0_2 net130 0.00169467f
C1734 BL_0_2 net130_10 0.00154374f
C1735 BL_0_2 net130_2 0.00147023f
C1736 BL_0_2 net130_3 0.00159594f
C1737 BL_0_2 net130_4 0.00160766f
C1738 BL_0_2 net130_5 0.00064207f
C1739 BL_0_2 net130_6 0.00064207f
C1740 BL_0_2 net130_7 0.000321035f
C1741 BL_0_2 net130_8 0.00064207f
C1742 BL_0_2 net130_9 0.000993469f
C1743 BL_0_2 net132 1.93591e-05f
C1744 BL_0_2 net132_10 1.7635e-05f
C1745 BL_0_2 net132_2 1.67952e-05f
C1746 BL_0_2 net132_3 1.82313e-05f
C1747 BL_0_2 net132_4 1.83652e-05f
C1748 BL_0_2 net132_9 1.1349e-05f
C1749 BL_0_2 net76 0.000563404f
C1750 BL_0_2 net76_2 0.000733887f
C1751 BL_0_2 net76_3 0.000733887f
C1752 BL_0_2 net76_4 0.00053154f
C1753 BL_0_2 net76_5 0.00124939f
C1754 BL_0_2 net76_7 0.00189966f
C1755 BL_1 BL_2 0.000161948f
C1756 BL_1 BL_3 3.75176e-05f
C1757 BL_1 BL_4 1.77189e-05f
C1758 BL_1 BL_5 1.29016e-05f
C1759 BL_1 P_0_0 6.66154e-05f
C1760 BL_1 P_0_0_2 0.000259604f
C1761 BL_1 P_0_0_5 0.00011403f
C1762 BL_1 P_0_1 3.07469e-05f
C1763 BL_1 P_0_1_2 0.000119822f
C1764 BL_1 P_0_1_5 5.26314e-05f
C1765 BL_1 VDD_1 0.00091518f
C1766 BL_1 VSS_0 0.0313122f
C1767 BL_1 VSS_2 0.00686444f
C1768 BL_1 WL_0 0.000298383f
C1769 BL_1 WL_0_1 0.000716143f
C1770 BL_1 WL_0_10 0.00129144f
C1771 BL_1 WL_0_11 0.00117404f
C1772 BL_1 WL_0_12 0.00129144f
C1773 BL_1 WL_0_13 0.00129144f
C1774 BL_1 WL_0_16 0.000593721f
C1775 BL_1 WL_0_2 0.000779719f
C1776 BL_1 WL_0_3 0.000779719f
C1777 BL_1 WL_0_4 0.000779719f
C1778 BL_1 WL_0_5 0.000779719f
C1779 BL_1 WL_0_9 0.000821825f
C1780 BL_1 XB_0_0 0.000325726f
C1781 BL_1 XB_0_0_1 0.00136166f
C1782 BL_1 XB_0_0_3 0.00038491f
C1783 BL_1 XB_0_1_1 4.82619e-05f
C1784 BL_1 XB_0_1_3 1.36425e-05f
C1785 BL_1 net11 1.47141e-05f
C1786 BL_1 net11_2 1.27653e-05f
C1787 BL_1 net11_3 1.38569e-05f
C1788 BL_1 net11_4 1.39586e-05f
C1789 BL_1 net3 4.98227e-05f
C1790 BL_1 net3_11 2.92077e-05f
C1791 BL_1 net3_2 4.32242e-05f
C1792 BL_1 net3_3 4.69202e-05f
C1793 BL_1 net3_4 4.72648e-05f
C1794 BL_1 net3_5 1.88767e-05f
C1795 BL_1 net3_6 1.88767e-05f
C1796 BL_1 net3_8 1.88767e-05f
C1797 BL_1 net6 0.000577604f
C1798 BL_1 net67 2.40441e-05f
C1799 BL_1 net6_3 0.000752384f
C1800 BL_1 net6_6 0.000544937f
C1801 BL_1 net6_7 0.00194754f
C1802 BL_1 net7 0.00148881f
C1803 BL_1 net78 2.6709e-05f
C1804 BL_1 net7_11 0.000872788f
C1805 BL_1 net7_2 0.00129163f
C1806 BL_1 net7_3 0.00140208f
C1807 BL_1 net7_4 0.00141237f
C1808 BL_1 net7_6 0.000564076f
C1809 BL_1 net7_8 0.000564076f
C1810 BL_1_1 BL_2 6.04304e-05f
C1811 BL_1_1 BL_3 1.39996e-05f
C1812 BL_1_1 P_0_0_1 0.000142701f
C1813 BL_1_1 P_0_0_3 2.88014e-05f
C1814 BL_1_1 P_0_0_4 5.80599e-05f
C1815 BL_1_1 P_0_1_1 6.58647e-05f
C1816 BL_1_1 P_0_1_3 1.32935e-05f
C1817 BL_1_1 P_0_1_4 2.6798e-05f
C1818 BL_1_1 P_0_2_2 1.51863e-05f
C1819 BL_1_1 VDD_1 0.000341498f
C1820 BL_1_1 VSS_0 0.0116841f
C1821 BL_1_1 VSS_2 0.00256145f
C1822 BL_1_1 WL_0_14 0.00129144f
C1823 BL_1_1 WL_0_15 0.00281768f
C1824 BL_1_1 WL_0_17 0.000593721f
C1825 BL_1_1 WL_0_18 0.000593721f
C1826 BL_1_1 WL_0_19 0.000593721f
C1827 BL_1_1 WL_0_20 0.000593721f
C1828 BL_1_1 WL_0_21 0.000593721f
C1829 BL_1_1 WL_0_22 0.000593721f
C1830 BL_1_1 WL_0_23 0.000593721f
C1831 BL_1_1 WL_0_24 0.000593721f
C1832 BL_1_1 WL_0_25 0.000593721f
C1833 BL_1_1 WL_0_26 0.000593721f
C1834 BL_1_1 WL_0_27 0.000593721f
C1835 BL_1_1 WL_0_28 0.000593721f
C1836 BL_1_1 WL_0_29 0.000593721f
C1837 BL_1_1 WL_0_30 0.000593721f
C1838 BL_1_1 WL_0_31 0.000593721f
C1839 BL_1_1 WL_0_6 0.000779719f
C1840 BL_1_1 WL_0_7 0.000779719f
C1841 BL_1_1 WL_0_8 0.000779719f
C1842 BL_1_1 XB_0_0_2 0.000192455f
C1843 BL_1_1 XB_0_1 1.15448e-05f
C1844 BL_1_1 net11_9 1.34036e-05f
C1845 BL_1_1 net3_9 4.53855e-05f
C1846 BL_1_1 net6_2 0.000752384f
C1847 BL_1_1 net6_4 0.00128088f
C1848 BL_1_1 net7_5 0.000564076f
C1849 BL_1_1 net7_7 0.000282038f
C1850 BL_1_1 net7_9 0.00135621f
C1851 BL_1_2 BL_2_2 6.04304e-05f
C1852 BL_1_2 BL_3_2 1.39996e-05f
C1853 BL_1_2 P_1_0 6.41496e-05f
C1854 BL_1_2 P_1_0_1 0.000137419f
C1855 BL_1_2 P_1_0_2 0.000249995f
C1856 BL_1_2 P_1_0_3 0.000109809f
C1857 BL_1_2 P_1_0_4 2.77353e-05f
C1858 BL_1_2 P_1_0_5 5.59108e-05f
C1859 BL_1_2 P_1_1 3.3148e-05f
C1860 BL_1_2 P_1_1_1 7.10081e-05f
C1861 BL_1_2 P_1_1_2 0.00012918f
C1862 BL_1_2 P_1_1_3 5.67415e-05f
C1863 BL_1_2 P_1_1_4 1.43316e-05f
C1864 BL_1_2 P_1_1_5 2.88907e-05f
C1865 BL_1_2 P_1_2_2 1.77462e-05f
C1866 BL_1_2 VDD_1 0.000341498f
C1867 BL_1_2 VSS_0 0.0116841f
C1868 BL_1_2 VSS_2 0.00256145f
C1869 BL_1_2 WL_1 0.000301086f
C1870 BL_1_2 WL_1_1 0.000722631f
C1871 BL_1_2 WL_1_10 0.00130314f
C1872 BL_1_2 WL_1_11 0.00118467f
C1873 BL_1_2 WL_1_12 0.00130314f
C1874 BL_1_2 WL_1_13 0.00130314f
C1875 BL_1_2 WL_1_14 0.00130314f
C1876 BL_1_2 WL_1_15 0.00284321f
C1877 BL_1_2 WL_1_16 0.0005991f
C1878 BL_1_2 WL_1_17 0.0005991f
C1879 BL_1_2 WL_1_18 0.0005991f
C1880 BL_1_2 WL_1_19 0.0005991f
C1881 BL_1_2 WL_1_2 0.000786783f
C1882 BL_1_2 WL_1_20 0.0005991f
C1883 BL_1_2 WL_1_21 0.0005991f
C1884 BL_1_2 WL_1_22 0.0005991f
C1885 BL_1_2 WL_1_23 0.0005991f
C1886 BL_1_2 WL_1_24 0.0005991f
C1887 BL_1_2 WL_1_25 0.0005991f
C1888 BL_1_2 WL_1_26 0.0005991f
C1889 BL_1_2 WL_1_27 0.0005991f
C1890 BL_1_2 WL_1_28 0.0005991f
C1891 BL_1_2 WL_1_29 0.0005991f
C1892 BL_1_2 WL_1_3 0.000786783f
C1893 BL_1_2 WL_1_30 0.0005991f
C1894 BL_1_2 WL_1_31 0.0005991f
C1895 BL_1_2 WL_1_4 0.000786783f
C1896 BL_1_2 WL_1_5 0.000786783f
C1897 BL_1_2 WL_1_6 0.000786783f
C1898 BL_1_2 WL_1_7 0.000786783f
C1899 BL_1_2 WL_1_8 0.000786783f
C1900 BL_1_2 WL_1_9 0.00082927f
C1901 BL_1_2 XB_1_0 0.000330748f
C1902 BL_1_2 XB_1_0_1 0.00138266f
C1903 BL_1_2 XB_1_0_2 0.000195422f
C1904 BL_1_2 XB_1_0_3 0.000390844f
C1905 BL_1_2 XB_1_1 1.42466e-05f
C1906 BL_1_2 XB_1_1_1 5.95564e-05f
C1907 BL_1_2 XB_1_1_3 1.68352e-05f
C1908 BL_1_2 net130 5.79569e-05f
C1909 BL_1_2 net130_10 5.27952e-05f
C1910 BL_1_2 net130_2 5.02811e-05f
C1911 BL_1_2 net130_3 5.45805e-05f
C1912 BL_1_2 net130_4 5.49813e-05f
C1913 BL_1_2 net130_5 2.19585e-05f
C1914 BL_1_2 net130_6 2.19585e-05f
C1915 BL_1_2 net130_7 1.09793e-05f
C1916 BL_1_2 net130_8 2.19585e-05f
C1917 BL_1_2 net130_9 3.39762e-05f
C1918 BL_1_2 net132 0.00156155f
C1919 BL_1_2 net132_10 0.00142247f
C1920 BL_1_2 net132_2 0.00135474f
C1921 BL_1_2 net132_3 0.00147058f
C1922 BL_1_2 net132_4 0.00148137f
C1923 BL_1_2 net132_5 0.000591633f
C1924 BL_1_2 net132_6 0.000591633f
C1925 BL_1_2 net132_7 0.000295817f
C1926 BL_1_2 net132_8 0.000591633f
C1927 BL_1_2 net132_9 0.000915428f
C1928 BL_1_2 net134 1.39395e-05f
C1929 BL_1_2 net134_10 1.2698e-05f
C1930 BL_1_2 net134_2 1.20933e-05f
C1931 BL_1_2 net134_3 1.31274e-05f
C1932 BL_1_2 net134_4 1.32238e-05f
C1933 BL_1_2 net79 0.000556232f
C1934 BL_1_2 net79_2 0.000724544f
C1935 BL_1_2 net79_3 0.000724544f
C1936 BL_1_2 net79_4 0.000524773f
C1937 BL_1_2 net79_5 0.00123349f
C1938 BL_1_2 net79_7 0.00187548f
C1939 BL_2 BL_3 0.000152441f
C1940 BL_2 BL_4 3.74597e-05f
C1941 BL_2 BL_5 1.86619e-05f
C1942 BL_2 BL_6 1.4759e-05f
C1943 BL_2 P_0_1 6.73499e-05f
C1944 BL_2 P_0_1_2 0.000262466f
C1945 BL_2 P_0_1_5 0.000115287f
C1946 BL_2 P_0_2 2.90394e-05f
C1947 BL_2 P_0_2_2 0.000113168f
C1948 BL_2 P_0_2_5 4.97087e-05f
C1949 BL_2 VDD_1 0.000812832f
C1950 BL_2 VSS_0 0.0312749f
C1951 BL_2 VSS_2 0.00675521f
C1952 BL_2 WL_0 0.000298118f
C1953 BL_2 WL_0_1 0.000715507f
C1954 BL_2 WL_0_10 0.00129029f
C1955 BL_2 WL_0_11 0.00117299f
C1956 BL_2 WL_0_12 0.00129029f
C1957 BL_2 WL_0_13 0.00129029f
C1958 BL_2 WL_0_14 0.00129029f
C1959 BL_2 WL_0_16 0.000593194f
C1960 BL_2 WL_0_17 0.000593194f
C1961 BL_2 WL_0_18 0.000593194f
C1962 BL_2 WL_0_2 0.000779026f
C1963 BL_2 WL_0_3 0.000779026f
C1964 BL_2 WL_0_4 0.000779026f
C1965 BL_2 WL_0_5 0.000779026f
C1966 BL_2 WL_0_6 0.000779026f
C1967 BL_2 WL_0_9 0.000821095f
C1968 BL_2 XB_0_1 0.000337122f
C1969 BL_2 XB_0_1_1 0.0014093f
C1970 BL_2 XB_0_1_3 0.000398377f
C1971 BL_2 XB_0_2_1 3.44513e-05f
C1972 BL_2 net10 0.000583019f
C1973 BL_2 net10_3 0.000759437f
C1974 BL_2 net10_6 0.000550046f
C1975 BL_2 net10_7 0.0019658f
C1976 BL_2 net11 0.00148469f
C1977 BL_2 net11_11 0.000870373f
C1978 BL_2 net11_2 0.00128806f
C1979 BL_2 net11_3 0.0013982f
C1980 BL_2 net11_4 0.00140846f
C1981 BL_2 net11_6 0.000562514f
C1982 BL_2 net11_8 0.000562514f
C1983 BL_2 net14 1.49324e-05f
C1984 BL_2 net14_2 1.29548e-05f
C1985 BL_2 net14_3 1.40625e-05f
C1986 BL_2 net14_4 1.41658e-05f
C1987 BL_2 net2_4 1.13445e-05f
C1988 BL_2 net2_7 1.72489e-05f
C1989 BL_2 net68 3.09823e-05f
C1990 BL_2 net7 5.27908e-05f
C1991 BL_2 net70 1.53236e-05f
C1992 BL_2 net7_11 3.09477e-05f
C1993 BL_2 net7_2 4.57992e-05f
C1994 BL_2 net7_3 4.97154e-05f
C1995 BL_2 net7_4 5.00805e-05f
C1996 BL_2 net7_5 2.00012e-05f
C1997 BL_2 net7_6 2.00012e-05f
C1998 BL_2 net7_8 2.00012e-05f
C1999 BL_2 net80 2.36692e-05f
C2000 BL_2 net85 1.35616e-05f
C2001 BL_2_1 BL_3 5.68832e-05f
C2002 BL_2_1 BL_4 1.3978e-05f
C2003 BL_2_1 P_0_1_1 0.000144274f
C2004 BL_2_1 P_0_1_3 2.91189e-05f
C2005 BL_2_1 P_0_1_4 5.87e-05f
C2006 BL_2_1 P_0_2_1 6.2207e-05f
C2007 BL_2_1 P_0_2_3 1.25553e-05f
C2008 BL_2_1 P_0_2_4 2.53098e-05f
C2009 BL_2_1 P_0_3_2 1.80514e-05f
C2010 BL_2_1 VDD_1 0.000303307f
C2011 BL_2_1 VSS_0 0.0116702f
C2012 BL_2_1 VSS_2 0.00252069f
C2013 BL_2_1 WL_0_15 0.00281518f
C2014 BL_2_1 WL_0_19 0.000593194f
C2015 BL_2_1 WL_0_20 0.000593194f
C2016 BL_2_1 WL_0_21 0.000593194f
C2017 BL_2_1 WL_0_22 0.000593194f
C2018 BL_2_1 WL_0_23 0.000593194f
C2019 BL_2_1 WL_0_24 0.000593194f
C2020 BL_2_1 WL_0_25 0.000593194f
C2021 BL_2_1 WL_0_26 0.000593194f
C2022 BL_2_1 WL_0_27 0.000593194f
C2023 BL_2_1 WL_0_28 0.000593194f
C2024 BL_2_1 WL_0_29 0.000593194f
C2025 BL_2_1 WL_0_30 0.000593194f
C2026 BL_2_1 WL_0_31 0.000593194f
C2027 BL_2_1 WL_0_7 0.000779026f
C2028 BL_2_1 WL_0_8 0.000779026f
C2029 BL_2_1 XB_0_1_2 0.000199188f
C2030 BL_2_1 net10_2 0.000759437f
C2031 BL_2_1 net10_4 0.00129289f
C2032 BL_2_1 net11_5 0.000562514f
C2033 BL_2_1 net11_7 0.000281257f
C2034 BL_2_1 net11_9 0.00135246f
C2035 BL_2_1 net14_9 1.36025e-05f
C2036 BL_2_1 net68 1.1561e-05f
C2037 BL_2_1 net7_7 1.00006e-05f
C2038 BL_2_1 net7_9 4.80892e-05f
C2039 BL_2_2 BL_3_2 5.68832e-05f
C2040 BL_2_2 BL_4_2 1.3978e-05f
C2041 BL_2_2 P_1_0_2 1.12145e-05f
C2042 BL_2_2 P_1_1 6.59927e-05f
C2043 BL_2_2 P_1_1_1 0.000141367f
C2044 BL_2_2 P_1_1_2 0.000257177f
C2045 BL_2_2 P_1_1_3 0.000112964f
C2046 BL_2_2 P_1_1_4 2.85321e-05f
C2047 BL_2_2 P_1_1_5 5.75172e-05f
C2048 BL_2_2 P_1_2 3.13013e-05f
C2049 BL_2_2 P_1_2_1 6.70522e-05f
C2050 BL_2_2 P_1_2_2 0.000121983f
C2051 BL_2_2 P_1_2_3 5.35804e-05f
C2052 BL_2_2 P_1_2_4 1.35332e-05f
C2053 BL_2_2 P_1_2_5 2.72812e-05f
C2054 BL_2_2 P_1_3_1 1.63257e-05f
C2055 BL_2_2 P_1_3_2 2.97001e-05f
C2056 BL_2_2 P_1_3_3 1.30456e-05f
C2057 BL_2_2 VDD_1 0.000303307f
C2058 BL_2_2 VSS_0 0.0116702f
C2059 BL_2_2 VSS_2 0.00252069f
C2060 BL_2_2 WL_1 0.00029518f
C2061 BL_2_2 WL_1_1 0.000708458f
C2062 BL_2_2 WL_1_10 0.00127758f
C2063 BL_2_2 WL_1_11 0.00116144f
C2064 BL_2_2 WL_1_12 0.00127758f
C2065 BL_2_2 WL_1_13 0.00127758f
C2066 BL_2_2 WL_1_14 0.00127758f
C2067 BL_2_2 WL_1_15 0.00278745f
C2068 BL_2_2 WL_1_16 0.00058735f
C2069 BL_2_2 WL_1_17 0.00058735f
C2070 BL_2_2 WL_1_18 0.00058735f
C2071 BL_2_2 WL_1_19 0.00058735f
C2072 BL_2_2 WL_1_2 0.000771351f
C2073 BL_2_2 WL_1_20 0.00058735f
C2074 BL_2_2 WL_1_21 0.00058735f
C2075 BL_2_2 WL_1_22 0.00058735f
C2076 BL_2_2 WL_1_23 0.00058735f
C2077 BL_2_2 WL_1_24 0.00058735f
C2078 BL_2_2 WL_1_25 0.00058735f
C2079 BL_2_2 WL_1_26 0.00058735f
C2080 BL_2_2 WL_1_27 0.00058735f
C2081 BL_2_2 WL_1_28 0.00058735f
C2082 BL_2_2 WL_1_29 0.00058735f
C2083 BL_2_2 WL_1_3 0.000771351f
C2084 BL_2_2 WL_1_30 0.00058735f
C2085 BL_2_2 WL_1_31 0.00058735f
C2086 BL_2_2 WL_1_4 0.000771351f
C2087 BL_2_2 WL_1_5 0.000771351f
C2088 BL_2_2 WL_1_6 0.000771351f
C2089 BL_2_2 WL_1_7 0.000771351f
C2090 BL_2_2 WL_1_8 0.000771351f
C2091 BL_2_2 WL_1_9 0.000813005f
C2092 BL_2_2 XB_1_1 0.000340867f
C2093 BL_2_2 XB_1_1_1 0.00142496f
C2094 BL_2_2 XB_1_1_2 0.000201401f
C2095 BL_2_2 XB_1_1_3 0.000402802f
C2096 BL_2_2 XB_1_2_1 2.58084e-05f
C2097 BL_2_2 XB_1_3_1 2.11174e-05f
C2098 BL_2_2 net132 6.14847e-05f
C2099 BL_2_2 net132_10 5.60088e-05f
C2100 BL_2_2 net132_2 5.33417e-05f
C2101 BL_2_2 net132_3 5.79028e-05f
C2102 BL_2_2 net132_4 5.8328e-05f
C2103 BL_2_2 net132_5 2.32951e-05f
C2104 BL_2_2 net132_6 2.32951e-05f
C2105 BL_2_2 net132_7 1.16476e-05f
C2106 BL_2_2 net132_8 2.32951e-05f
C2107 BL_2_2 net132_9 3.60443e-05f
C2108 BL_2_2 net134 0.00154871f
C2109 BL_2_2 net134_10 0.00141078f
C2110 BL_2_2 net134_2 0.0013436f
C2111 BL_2_2 net134_3 0.00145848f
C2112 BL_2_2 net134_4 0.00146919f
C2113 BL_2_2 net134_5 0.000586769f
C2114 BL_2_2 net134_6 0.000586769f
C2115 BL_2_2 net134_7 0.000293384f
C2116 BL_2_2 net134_8 0.000586769f
C2117 BL_2_2 net134_9 0.000907901f
C2118 BL_2_2 net135 1.03042e-05f
C2119 BL_2_2 net68 1.1561e-05f
C2120 BL_2_2 net76_7 1.32103e-05f
C2121 BL_2_2 net81 0.000562885f
C2122 BL_2_2 net81_2 0.00073321f
C2123 BL_2_2 net81_3 0.00073321f
C2124 BL_2_2 net81_4 0.00053105f
C2125 BL_2_2 net81_5 0.00124824f
C2126 BL_2_2 net81_7 0.00189791f
C2127 BL_3 BL_4 0.000166348f
C2128 BL_3 BL_5 3.55021e-05f
C2129 BL_3 P_0_1_2 1.35205e-05f
C2130 BL_3 P_0_2 6.292e-05f
C2131 BL_3 P_0_2_2 0.000245203f
C2132 BL_3 P_0_2_5 0.000107704f
C2133 BL_3 P_0_3 3.41025e-05f
C2134 BL_3 P_0_3_2 0.0001329f
C2135 BL_3 P_0_3_5 5.83755e-05f
C2136 BL_3 VDD_1 0.000867301f
C2137 BL_3 VSS_0 0.0311746f
C2138 BL_3 VSS_2 0.00688938f
C2139 BL_3 WL_0 0.000296874f
C2140 BL_3 WL_0_1 0.000712523f
C2141 BL_3 WL_0_10 0.00128491f
C2142 BL_3 WL_0_11 0.0011681f
C2143 BL_3 WL_0_12 0.00128491f
C2144 BL_3 WL_0_13 0.00128491f
C2145 BL_3 WL_0_14 0.00128491f
C2146 BL_3 WL_0_15 0.00280344f
C2147 BL_3 WL_0_16 0.00059072f
C2148 BL_3 WL_0_17 0.00059072f
C2149 BL_3 WL_0_18 0.00059072f
C2150 BL_3 WL_0_19 0.00059072f
C2151 BL_3 WL_0_2 0.000775777f
C2152 BL_3 WL_0_20 0.00059072f
C2153 BL_3 WL_0_3 0.000775777f
C2154 BL_3 WL_0_4 0.000775777f
C2155 BL_3 WL_0_5 0.000775777f
C2156 BL_3 WL_0_6 0.000775777f
C2157 BL_3 WL_0_7 0.000775777f
C2158 BL_3 WL_0_9 0.00081767f
C2159 BL_3 XB_0_2 0.000324054f
C2160 BL_3 XB_0_2_1 0.00135467f
C2161 BL_3 XB_0_2_3 0.000382934f
C2162 BL_3 XB_0_3_1 4.54354e-05f
C2163 BL_3 XB_0_3_3 1.28435e-05f
C2164 BL_3 net11 6.3757e-05f
C2165 BL_3 net11_11 3.73764e-05f
C2166 BL_3 net11_2 5.5313e-05f
C2167 BL_3 net11_3 6.00427e-05f
C2168 BL_3 net11_4 6.04836e-05f
C2169 BL_3 net11_5 2.4156e-05f
C2170 BL_3 net11_6 2.4156e-05f
C2171 BL_3 net11_8 2.4156e-05f
C2172 BL_3 net13 0.000586907f
C2173 BL_3 net13_3 0.000764501f
C2174 BL_3 net13_6 0.000553713f
C2175 BL_3 net13_7 0.00197891f
C2176 BL_3 net14 0.00148187f
C2177 BL_3 net14_11 0.000868719f
C2178 BL_3 net14_2 0.00128561f
C2179 BL_3 net14_3 0.00139554f
C2180 BL_3 net14_4 0.00140579f
C2181 BL_3 net14_6 0.000561446f
C2182 BL_3 net14_8 0.000561446f
C2183 BL_3 net17 1.10289e-05f
C2184 BL_3 net17_3 1.03864e-05f
C2185 BL_3 net17_4 1.04627e-05f
C2186 BL_3 net69 2.80368e-05f
C2187 BL_3 net6_4 1.31066e-05f
C2188 BL_3 net6_7 1.99282e-05f
C2189 BL_3 net83 1.81241e-05f
C2190 BL_3_1 BL_4 6.20726e-05f
C2191 BL_3_1 BL_5 1.32475e-05f
C2192 BL_3_1 BL_6 1.9604e-05f
C2193 BL_3_1 BL_7 1.36087e-05f
C2194 BL_3_1 P_0_2_1 0.000134784f
C2195 BL_3_1 P_0_2_3 2.72036e-05f
C2196 BL_3_1 P_0_2_4 5.48391e-05f
C2197 BL_3_1 P_0_3_1 7.30529e-05f
C2198 BL_3_1 P_0_3_3 1.47443e-05f
C2199 BL_3_1 P_0_3_4 2.97227e-05f
C2200 BL_3_1 P_0_4_2 1.71976e-05f
C2201 BL_3_1 VDD_1 0.000323632f
C2202 BL_3_1 VSS_0 0.0116328f
C2203 BL_3_1 VSS_2 0.00257076f
C2204 BL_3_1 WL_0_21 0.00059072f
C2205 BL_3_1 WL_0_22 0.00059072f
C2206 BL_3_1 WL_0_23 0.00059072f
C2207 BL_3_1 WL_0_24 0.00059072f
C2208 BL_3_1 WL_0_25 0.00059072f
C2209 BL_3_1 WL_0_26 0.00059072f
C2210 BL_3_1 WL_0_27 0.00059072f
C2211 BL_3_1 WL_0_28 0.00059072f
C2212 BL_3_1 WL_0_29 0.00059072f
C2213 BL_3_1 WL_0_30 0.00059072f
C2214 BL_3_1 WL_0_31 0.00059072f
C2215 BL_3_1 WL_0_8 0.000775777f
C2216 BL_3_1 XB_0_2_2 0.000191467f
C2217 BL_3_1 XB_0_3 1.08687e-05f
C2218 BL_3_1 net11_7 1.2078e-05f
C2219 BL_3_1 net11_9 5.80787e-05f
C2220 BL_3_1 net13_2 0.000764501f
C2221 BL_3_1 net13_4 0.00130151f
C2222 BL_3_1 net14_5 0.000561446f
C2223 BL_3_1 net14_7 0.000280723f
C2224 BL_3_1 net14_9 0.00134989f
C2225 BL_3_1 net17_9 1.00466e-05f
C2226 BL_3_1 net69 1.04619e-05f
C2227 BL_3_2 BL_4_2 6.20726e-05f
C2228 BL_3_2 BL_5_2 1.32475e-05f
C2229 BL_3_2 P_1_1_2 1.80198e-05f
C2230 BL_3_2 P_1_2 6.64668e-05f
C2231 BL_3_2 P_1_2_1 0.000142382f
C2232 BL_3_2 P_1_2_2 0.000259025f
C2233 BL_3_2 P_1_2_3 0.000113776f
C2234 BL_3_2 P_1_2_4 2.87371e-05f
C2235 BL_3_2 P_1_2_5 5.79304e-05f
C2236 BL_3_2 P_1_3 3.51458e-05f
C2237 BL_3_2 P_1_3_1 7.52878e-05f
C2238 BL_3_2 P_1_3_2 0.000136965f
C2239 BL_3_2 P_1_3_3 6.01613e-05f
C2240 BL_3_2 P_1_3_4 1.51954e-05f
C2241 BL_3_2 P_1_3_5 3.0632e-05f
C2242 BL_3_2 P_1_4_2 1.81888e-05f
C2243 BL_3_2 VDD_1 0.000323632f
C2244 BL_3_2 VSS_0 0.0116328f
C2245 BL_3_2 VSS_2 0.00257076f
C2246 BL_3_2 WL_1 0.00029962f
C2247 BL_3_2 WL_1_1 0.000719114f
C2248 BL_3_2 WL_1_10 0.0012968f
C2249 BL_3_2 WL_1_11 0.00117891f
C2250 BL_3_2 WL_1_12 0.0012968f
C2251 BL_3_2 WL_1_13 0.0012968f
C2252 BL_3_2 WL_1_14 0.0012968f
C2253 BL_3_2 WL_1_15 0.00282937f
C2254 BL_3_2 WL_1_16 0.000596184f
C2255 BL_3_2 WL_1_17 0.000596184f
C2256 BL_3_2 WL_1_18 0.000596184f
C2257 BL_3_2 WL_1_19 0.000596184f
C2258 BL_3_2 WL_1_2 0.000782953f
C2259 BL_3_2 WL_1_20 0.000596184f
C2260 BL_3_2 WL_1_21 0.000596184f
C2261 BL_3_2 WL_1_22 0.000596184f
C2262 BL_3_2 WL_1_23 0.000596184f
C2263 BL_3_2 WL_1_24 0.000596184f
C2264 BL_3_2 WL_1_25 0.000596184f
C2265 BL_3_2 WL_1_26 0.000596184f
C2266 BL_3_2 WL_1_27 0.000596184f
C2267 BL_3_2 WL_1_28 0.000596184f
C2268 BL_3_2 WL_1_29 0.000596184f
C2269 BL_3_2 WL_1_3 0.000782953f
C2270 BL_3_2 WL_1_30 0.000596184f
C2271 BL_3_2 WL_1_31 0.000596184f
C2272 BL_3_2 WL_1_4 0.000782953f
C2273 BL_3_2 WL_1_5 0.000782953f
C2274 BL_3_2 WL_1_6 0.000782953f
C2275 BL_3_2 WL_1_7 0.000782953f
C2276 BL_3_2 WL_1_8 0.000782953f
C2277 BL_3_2 WL_1_9 0.000825234f
C2278 BL_3_2 XB_1_2 0.0003271f
C2279 BL_3_2 XB_1_2_1 0.00136741f
C2280 BL_3_2 XB_1_2_2 0.000193267f
C2281 BL_3_2 XB_1_2_3 0.000386534f
C2282 BL_3_2 XB_1_3 1.40925e-05f
C2283 BL_3_2 XB_1_3_1 5.89122e-05f
C2284 BL_3_2 XB_1_3_3 1.66531e-05f
C2285 BL_3_2 net134 5.43702e-05f
C2286 BL_3_2 net134_10 4.9528e-05f
C2287 BL_3_2 net134_2 4.71695e-05f
C2288 BL_3_2 net134_3 5.12028e-05f
C2289 BL_3_2 net134_4 5.15788e-05f
C2290 BL_3_2 net134_5 2.05996e-05f
C2291 BL_3_2 net134_6 2.05996e-05f
C2292 BL_3_2 net134_7 1.02998e-05f
C2293 BL_3_2 net134_8 2.05996e-05f
C2294 BL_3_2 net134_9 3.18736e-05f
C2295 BL_3_2 net135 0.00154146f
C2296 BL_3_2 net135_10 0.00140417f
C2297 BL_3_2 net135_2 0.00133731f
C2298 BL_3_2 net135_3 0.00145166f
C2299 BL_3_2 net135_4 0.00146232f
C2300 BL_3_2 net135_5 0.000584023f
C2301 BL_3_2 net135_6 0.000584023f
C2302 BL_3_2 net135_7 0.000292011f
C2303 BL_3_2 net135_8 0.000584023f
C2304 BL_3_2 net135_9 0.000903652f
C2305 BL_3_2 net137 1.35116e-05f
C2306 BL_3_2 net137_10 1.23082e-05f
C2307 BL_3_2 net137_2 1.17221e-05f
C2308 BL_3_2 net137_3 1.27245e-05f
C2309 BL_3_2 net137_4 1.28179e-05f
C2310 BL_3_2 net69 1.04619e-05f
C2311 BL_3_2 net79_5 1.24177e-05f
C2312 BL_3_2 net79_7 1.88808e-05f
C2313 BL_3_2 net84 0.000559695f
C2314 BL_3_2 net84_2 0.000729056f
C2315 BL_3_2 net84_3 0.000729056f
C2316 BL_3_2 net84_4 0.000528041f
C2317 BL_3_2 net84_5 0.00124117f
C2318 BL_3_2 net84_7 0.00188716f
C2319 BL_4 BL_5 0.000151889f
C2320 BL_4 P_0_2_2 1.07898e-05f
C2321 BL_4 P_0_3 6.69501e-05f
C2322 BL_4 P_0_3_2 0.000260908f
C2323 BL_4 P_0_3_5 0.000114603f
C2324 BL_4 P_0_4 3.03887e-05f
C2325 BL_4 P_0_4_2 0.000118427f
C2326 BL_4 P_0_4_5 5.20183e-05f
C2327 BL_4 VDD_1 0.000979834f
C2328 BL_4 VSS_0 0.031156f
C2329 BL_4 VSS_2 0.00681219f
C2330 BL_4 WL_0 0.000297336f
C2331 BL_4 WL_0_1 0.000713631f
C2332 BL_4 WL_0_10 0.00128691f
C2333 BL_4 WL_0_11 0.00116992f
C2334 BL_4 WL_0_12 0.00128691f
C2335 BL_4 WL_0_13 0.00128691f
C2336 BL_4 WL_0_14 0.00128691f
C2337 BL_4 WL_0_15 0.0028078f
C2338 BL_4 WL_0_16 0.000591638f
C2339 BL_4 WL_0_17 0.000591638f
C2340 BL_4 WL_0_18 0.000591638f
C2341 BL_4 WL_0_19 0.000591638f
C2342 BL_4 WL_0_2 0.000776983f
C2343 BL_4 WL_0_20 0.000591638f
C2344 BL_4 WL_0_21 0.000591638f
C2345 BL_4 WL_0_22 0.000591638f
C2346 BL_4 WL_0_3 0.000776983f
C2347 BL_4 WL_0_4 0.000776983f
C2348 BL_4 WL_0_5 0.000776983f
C2349 BL_4 WL_0_6 0.000776983f
C2350 BL_4 WL_0_7 0.000776983f
C2351 BL_4 WL_0_8 0.000776983f
C2352 BL_4 WL_0_9 0.000818941f
C2353 BL_4 XB_0_3 0.000329902f
C2354 BL_4 XB_0_3_1 0.00137912f
C2355 BL_4 XB_0_3_3 0.000389845f
C2356 BL_4 XB_0_4_1 5.32024e-05f
C2357 BL_4 XB_0_4_3 1.50391e-05f
C2358 BL_4 net10_4 1.52143e-05f
C2359 BL_4 net10_7 2.31328e-05f
C2360 BL_4 net13_7 1.09784e-05f
C2361 BL_4 net14 6.12072e-05f
C2362 BL_4 net14_11 3.58816e-05f
C2363 BL_4 net14_2 5.3101e-05f
C2364 BL_4 net14_3 5.76415e-05f
C2365 BL_4 net14_4 5.80648e-05f
C2366 BL_4 net14_5 2.319e-05f
C2367 BL_4 net14_6 2.319e-05f
C2368 BL_4 net14_8 2.319e-05f
C2369 BL_4 net16 0.000587869f
C2370 BL_4 net16_3 0.000765754f
C2371 BL_4 net16_6 0.000554621f
C2372 BL_4 net16_7 0.00198215f
C2373 BL_4 net17 0.00148953f
C2374 BL_4 net17_11 0.000873212f
C2375 BL_4 net17_2 0.00129226f
C2376 BL_4 net17_3 0.00140276f
C2377 BL_4 net17_4 0.00141306f
C2378 BL_4 net17_6 0.000564349f
C2379 BL_4 net17_8 0.000564349f
C2380 BL_4 net70 2.58918e-05f
C2381 BL_4 net72 1.49737e-05f
C2382 BL_4 net85 2.38323e-05f
C2383 BL_4 net90 1.4414e-05f
C2384 BL_4_1 BL_5 5.66769e-05f
C2385 BL_4_1 BL_6 3.60437e-05f
C2386 BL_4_1 BL_6_1 1.34496e-05f
C2387 BL_4_1 BL_7 1.87464e-05f
C2388 BL_4_1 P_0_3_1 0.000143418f
C2389 BL_4_1 P_0_3_3 2.89461e-05f
C2390 BL_4_1 P_0_3_4 5.83516e-05f
C2391 BL_4_1 P_0_4_1 6.50974e-05f
C2392 BL_4_1 P_0_4_3 1.31386e-05f
C2393 BL_4_1 P_0_4_4 2.64858e-05f
C2394 BL_4_1 P_0_5_1 1.11968e-05f
C2395 BL_4_1 P_0_5_2 2.03695e-05f
C2396 BL_4_1 VDD_1 0.000365623f
C2397 BL_4_1 VSS_0 0.0116258f
C2398 BL_4_1 VSS_2 0.00254196f
C2399 BL_4_1 WL_0_23 0.000591638f
C2400 BL_4_1 WL_0_24 0.000591638f
C2401 BL_4_1 WL_0_25 0.000591638f
C2402 BL_4_1 WL_0_26 0.000591638f
C2403 BL_4_1 WL_0_27 0.000591638f
C2404 BL_4_1 WL_0_28 0.000591638f
C2405 BL_4_1 WL_0_29 0.000591638f
C2406 BL_4_1 WL_0_30 0.000591638f
C2407 BL_4_1 WL_0_31 0.000591638f
C2408 BL_4_1 XB_0_3_2 0.000194923f
C2409 BL_4_1 XB_0_4 1.27267e-05f
C2410 BL_4_1 net14_7 1.1595e-05f
C2411 BL_4_1 net14_9 5.5756e-05f
C2412 BL_4_1 net16_2 0.000765754f
C2413 BL_4_1 net16_4 0.00130365f
C2414 BL_4_1 net17_5 0.000564349f
C2415 BL_4_1 net17_7 0.000282175f
C2416 BL_4_1 net17_9 0.00135687f
C2417 BL_4_2 BL_5_2 5.66769e-05f
C2418 BL_4_2 BL_6_2 1.34496e-05f
C2419 BL_4_2 P_1_2_2 1.71974e-05f
C2420 BL_4_2 P_1_3 6.86735e-05f
C2421 BL_4_2 P_1_3_1 0.000147109f
C2422 BL_4_2 P_1_3_2 0.000267625f
C2423 BL_4_2 P_1_3_3 0.000117553f
C2424 BL_4_2 P_1_3_4 2.96912e-05f
C2425 BL_4_2 P_1_3_5 5.98536e-05f
C2426 BL_4_2 P_1_4 3.02212e-05f
C2427 BL_4_2 P_1_4_1 6.47386e-05f
C2428 BL_4_2 P_1_4_2 0.000117774f
C2429 BL_4_2 P_1_4_3 5.17316e-05f
C2430 BL_4_2 P_1_4_4 1.30662e-05f
C2431 BL_4_2 P_1_4_5 2.63399e-05f
C2432 BL_4_2 P_1_5_1 1.33004e-05f
C2433 BL_4_2 P_1_5_2 2.41965e-05f
C2434 BL_4_2 P_1_5_3 1.06282e-05f
C2435 BL_4_2 VDD_1 0.000365623f
C2436 BL_4_2 VSS_0 0.0116258f
C2437 BL_4_2 VSS_2 0.00254196f
C2438 BL_4_2 WL_1 0.00029694f
C2439 BL_4_2 WL_1_1 0.00071268f
C2440 BL_4_2 WL_1_10 0.00128519f
C2441 BL_4_2 WL_1_11 0.00116836f
C2442 BL_4_2 WL_1_12 0.00128519f
C2443 BL_4_2 WL_1_13 0.00128519f
C2444 BL_4_2 WL_1_14 0.00128519f
C2445 BL_4_2 WL_1_15 0.00280406f
C2446 BL_4_2 WL_1_16 0.00059085f
C2447 BL_4_2 WL_1_17 0.00059085f
C2448 BL_4_2 WL_1_18 0.00059085f
C2449 BL_4_2 WL_1_19 0.00059085f
C2450 BL_4_2 WL_1_2 0.000775948f
C2451 BL_4_2 WL_1_20 0.00059085f
C2452 BL_4_2 WL_1_21 0.00059085f
C2453 BL_4_2 WL_1_22 0.00059085f
C2454 BL_4_2 WL_1_23 0.00059085f
C2455 BL_4_2 WL_1_24 0.00059085f
C2456 BL_4_2 WL_1_25 0.00059085f
C2457 BL_4_2 WL_1_26 0.00059085f
C2458 BL_4_2 WL_1_27 0.00059085f
C2459 BL_4_2 WL_1_28 0.00059085f
C2460 BL_4_2 WL_1_29 0.00059085f
C2461 BL_4_2 WL_1_3 0.000775948f
C2462 BL_4_2 WL_1_30 0.00059085f
C2463 BL_4_2 WL_1_31 0.00059085f
C2464 BL_4_2 WL_1_4 0.000775948f
C2465 BL_4_2 WL_1_5 0.000775948f
C2466 BL_4_2 WL_1_6 0.000775948f
C2467 BL_4_2 WL_1_7 0.000775948f
C2468 BL_4_2 WL_1_8 0.000775948f
C2469 BL_4_2 WL_1_9 0.00081785f
C2470 BL_4_2 XB_1_3 0.000337577f
C2471 BL_4_2 XB_1_3_1 0.00141121f
C2472 BL_4_2 XB_1_3_2 0.000199457f
C2473 BL_4_2 XB_1_3_3 0.000398915f
C2474 BL_4_2 XB_1_4 1.1424e-05f
C2475 BL_4_2 XB_1_4_1 4.77567e-05f
C2476 BL_4_2 XB_1_4_3 1.34997e-05f
C2477 BL_4_2 XB_1_5_1 1.73051e-05f
C2478 BL_4_2 net135 5.95881e-05f
C2479 BL_4_2 net135_10 5.42811e-05f
C2480 BL_4_2 net135_2 5.16963e-05f
C2481 BL_4_2 net135_3 5.61167e-05f
C2482 BL_4_2 net135_4 5.65288e-05f
C2483 BL_4_2 net135_5 2.25766e-05f
C2484 BL_4_2 net135_6 2.25766e-05f
C2485 BL_4_2 net135_7 1.12883e-05f
C2486 BL_4_2 net135_8 2.25766e-05f
C2487 BL_4_2 net135_9 3.49325e-05f
C2488 BL_4_2 net137 0.00153592f
C2489 BL_4_2 net137_10 0.00139913f
C2490 BL_4_2 net137_2 0.0013325f
C2491 BL_4_2 net137_3 0.00144644f
C2492 BL_4_2 net137_4 0.00145706f
C2493 BL_4_2 net137_5 0.000581924f
C2494 BL_4_2 net137_6 0.000581924f
C2495 BL_4_2 net137_7 0.000290962f
C2496 BL_4_2 net137_8 0.000581924f
C2497 BL_4_2 net137_9 0.000900406f
C2498 BL_4_2 net139 1.17842e-05f
C2499 BL_4_2 net139_10 1.07347e-05f
C2500 BL_4_2 net139_2 1.02235e-05f
C2501 BL_4_2 net139_3 1.10977e-05f
C2502 BL_4_2 net139_4 1.11792e-05f
C2503 BL_4_2 net81_5 1.44195e-05f
C2504 BL_4_2 net81_7 2.19243e-05f
C2505 BL_4_2 net86 0.000567518f
C2506 BL_4_2 net86_2 0.000739245f
C2507 BL_4_2 net86_3 0.000739245f
C2508 BL_4_2 net86_4 0.000535421f
C2509 BL_4_2 net86_5 0.00125852f
C2510 BL_4_2 net86_7 0.00191353f
C2511 BL_5 P_0_4 6.34438e-05f
C2512 BL_5 P_0_4_2 0.000247244f
C2513 BL_5 P_0_4_5 0.000108601f
C2514 BL_5 P_0_5 3.17396e-05f
C2515 BL_5 P_0_5_2 0.000123691f
C2516 BL_5 P_0_5_5 5.43307e-05f
C2517 BL_5 VDD_1 0.000939752f
C2518 BL_5 VSS_0 0.0311431f
C2519 BL_5 VSS_2 0.00690038f
C2520 BL_5 WL_0 0.000298227f
C2521 BL_5 WL_0_1 0.000715771f
C2522 BL_5 WL_0_10 0.00129077f
C2523 BL_5 WL_0_11 0.00117342f
C2524 BL_5 WL_0_12 0.00129077f
C2525 BL_5 WL_0_13 0.00129077f
C2526 BL_5 WL_0_14 0.00129077f
C2527 BL_5 WL_0_15 0.00281622f
C2528 BL_5 WL_0_16 0.000593412f
C2529 BL_5 WL_0_17 0.000593412f
C2530 BL_5 WL_0_18 0.000593412f
C2531 BL_5 WL_0_19 0.000593412f
C2532 BL_5 WL_0_2 0.000779313f
C2533 BL_5 WL_0_20 0.000593412f
C2534 BL_5 WL_0_21 0.000593412f
C2535 BL_5 WL_0_22 0.000593412f
C2536 BL_5 WL_0_23 0.000593412f
C2537 BL_5 WL_0_24 0.000593412f
C2538 BL_5 WL_0_3 0.000779313f
C2539 BL_5 WL_0_4 0.000779313f
C2540 BL_5 WL_0_5 0.000779313f
C2541 BL_5 WL_0_6 0.000779313f
C2542 BL_5 WL_0_7 0.000779313f
C2543 BL_5 WL_0_8 0.000779313f
C2544 BL_5 WL_0_9 0.000821397f
C2545 BL_5 XB_0_4 0.000323128f
C2546 BL_5 XB_0_4_1 0.0013508f
C2547 BL_5 XB_0_4_3 0.00038184f
C2548 BL_5 XB_0_5_1 5.6193e-05f
C2549 BL_5 XB_0_5_3 1.58844e-05f
C2550 BL_5 net13_4 1.32988e-05f
C2551 BL_5 net13_7 2.02205e-05f
C2552 BL_5 net17 6.39326e-05f
C2553 BL_5 net17_11 3.74794e-05f
C2554 BL_5 net17_2 5.54654e-05f
C2555 BL_5 net17_3 6.02081e-05f
C2556 BL_5 net17_4 6.06502e-05f
C2557 BL_5 net17_5 2.42226e-05f
C2558 BL_5 net17_6 2.42226e-05f
C2559 BL_5 net17_8 2.42226e-05f
C2560 BL_5 net19 0.000585411f
C2561 BL_5 net19_3 0.000762552f
C2562 BL_5 net19_6 0.000552302f
C2563 BL_5 net19_7 0.00197386f
C2564 BL_5 net20 0.00148379f
C2565 BL_5 net20_11 0.000869845f
C2566 BL_5 net20_2 0.00128728f
C2567 BL_5 net20_3 0.00139735f
C2568 BL_5 net20_4 0.00140761f
C2569 BL_5 net20_6 0.000562173f
C2570 BL_5 net20_8 0.000562173f
C2571 BL_5 net71 1.93874e-05f
C2572 BL_5 net87 1.60645e-05f
C2573 BL_5_1 BL_6 0.000153962f
C2574 BL_5_1 BL_6_1 5.74508e-05f
C2575 BL_5_1 BL_7 3.61257e-05f
C2576 BL_5_1 BL_7_1 1.34802e-05f
C2577 BL_5_1 P_0_4_1 0.000135907f
C2578 BL_5_1 P_0_4_3 2.74301e-05f
C2579 BL_5_1 P_0_4_4 5.52956e-05f
C2580 BL_5_1 P_0_5_1 6.79912e-05f
C2581 BL_5_1 P_0_5_3 1.37227e-05f
C2582 BL_5_1 P_0_5_4 2.76632e-05f
C2583 BL_5_1 P_0_6_1 1.04288e-05f
C2584 BL_5_1 P_0_6_2 1.89723e-05f
C2585 BL_5_1 VDD_1 0.000350667f
C2586 BL_5_1 VSS_0 0.011621f
C2587 BL_5_1 VSS_2 0.00257486f
C2588 BL_5_1 WL_0_25 0.000593412f
C2589 BL_5_1 WL_0_26 0.000593412f
C2590 BL_5_1 WL_0_27 0.000593412f
C2591 BL_5_1 WL_0_28 0.000593412f
C2592 BL_5_1 WL_0_29 0.000593412f
C2593 BL_5_1 WL_0_30 0.000593412f
C2594 BL_5_1 WL_0_31 0.000593412f
C2595 BL_5_1 XB_0_4_2 0.00019092f
C2596 BL_5_1 XB_0_5 1.3442e-05f
C2597 BL_5_1 XB_0_6_1 1.30814e-05f
C2598 BL_5_1 net17_7 1.21113e-05f
C2599 BL_5_1 net17_9 5.82387e-05f
C2600 BL_5_1 net19_2 0.000762552f
C2601 BL_5_1 net19_4 0.00129819f
C2602 BL_5_1 net20_5 0.000562173f
C2603 BL_5_1 net20_7 0.000281087f
C2604 BL_5_1 net20_9 0.00135164f
C2605 BL_5_2 BL_6_2 5.74508e-05f
C2606 BL_5_2 BL_7_2 1.34802e-05f
C2607 BL_5_2 P_1_2_2 1.02447e-05f
C2608 BL_5_2 P_1_3_2 1.43422e-05f
C2609 BL_5_2 P_1_4 6.46869e-05f
C2610 BL_5_2 P_1_4_1 0.000138569f
C2611 BL_5_2 P_1_4_2 0.000252088f
C2612 BL_5_2 P_1_4_3 0.000110729f
C2613 BL_5_2 P_1_4_4 2.79676e-05f
C2614 BL_5_2 P_1_4_5 5.6379e-05f
C2615 BL_5_2 P_1_5 3.53533e-05f
C2616 BL_5_2 P_1_5_1 7.57322e-05f
C2617 BL_5_2 P_1_5_2 0.000137774f
C2618 BL_5_2 P_1_5_3 6.05165e-05f
C2619 BL_5_2 P_1_5_4 1.52851e-05f
C2620 BL_5_2 P_1_5_5 3.08128e-05f
C2621 BL_5_2 P_1_6_2 1.65017e-05f
C2622 BL_5_2 VDD_1 0.000350667f
C2623 BL_5_2 VSS_0 0.011621f
C2624 BL_5_2 VSS_2 0.00257486f
C2625 BL_5_2 WL_1 0.000299251f
C2626 BL_5_2 WL_1_1 0.000718227f
C2627 BL_5_2 WL_1_10 0.0012952f
C2628 BL_5_2 WL_1_11 0.00117745f
C2629 BL_5_2 WL_1_12 0.0012952f
C2630 BL_5_2 WL_1_13 0.0012952f
C2631 BL_5_2 WL_1_14 0.0012952f
C2632 BL_5_2 WL_1_15 0.00282588f
C2633 BL_5_2 WL_1_16 0.000595449f
C2634 BL_5_2 WL_1_17 0.000595449f
C2635 BL_5_2 WL_1_18 0.000595449f
C2636 BL_5_2 WL_1_19 0.000595449f
C2637 BL_5_2 WL_1_2 0.000781987f
C2638 BL_5_2 WL_1_20 0.000595449f
C2639 BL_5_2 WL_1_21 0.000595449f
C2640 BL_5_2 WL_1_22 0.000595449f
C2641 BL_5_2 WL_1_23 0.000595449f
C2642 BL_5_2 WL_1_24 0.000595449f
C2643 BL_5_2 WL_1_25 0.000595449f
C2644 BL_5_2 WL_1_26 0.000595449f
C2645 BL_5_2 WL_1_27 0.000595449f
C2646 BL_5_2 WL_1_28 0.000595449f
C2647 BL_5_2 WL_1_29 0.000595449f
C2648 BL_5_2 WL_1_3 0.000781987f
C2649 BL_5_2 WL_1_30 0.000595449f
C2650 BL_5_2 WL_1_31 0.000595449f
C2651 BL_5_2 WL_1_4 0.000781987f
C2652 BL_5_2 WL_1_5 0.000781987f
C2653 BL_5_2 WL_1_6 0.000781987f
C2654 BL_5_2 WL_1_7 0.000781987f
C2655 BL_5_2 WL_1_8 0.000781987f
C2656 BL_5_2 WL_1_9 0.000824216f
C2657 BL_5_2 XB_1_4 0.000332241f
C2658 BL_5_2 XB_1_4_1 0.0013889f
C2659 BL_5_2 XB_1_4_2 0.000196304f
C2660 BL_5_2 XB_1_4_3 0.000392609f
C2661 BL_5_2 XB_1_5 1.74808e-05f
C2662 BL_5_2 XB_1_5_1 7.30766e-05f
C2663 BL_5_2 XB_1_5_2 1.03285e-05f
C2664 BL_5_2 XB_1_5_3 2.06571e-05f
C2665 BL_5_2 net137 5.61164e-05f
C2666 BL_5_2 net137_10 5.11186e-05f
C2667 BL_5_2 net137_2 4.86844e-05f
C2668 BL_5_2 net137_3 5.28473e-05f
C2669 BL_5_2 net137_4 5.32353e-05f
C2670 BL_5_2 net137_5 2.12612e-05f
C2671 BL_5_2 net137_6 2.12612e-05f
C2672 BL_5_2 net137_7 1.06306e-05f
C2673 BL_5_2 net137_8 2.12612e-05f
C2674 BL_5_2 net137_9 3.28972e-05f
C2675 BL_5_2 net139 0.00154323f
C2676 BL_5_2 net139_10 0.00140579f
C2677 BL_5_2 net139_2 0.00133884f
C2678 BL_5_2 net139_3 0.00145333f
C2679 BL_5_2 net139_4 0.001464f
C2680 BL_5_2 net139_5 0.000584693f
C2681 BL_5_2 net139_6 0.000584693f
C2682 BL_5_2 net139_7 0.000292347f
C2683 BL_5_2 net139_8 0.000584693f
C2684 BL_5_2 net139_9 0.00090469f
C2685 BL_5_2 net141 1.05797e-05f
C2686 BL_5_2 net141_4 1.00365e-05f
C2687 BL_5_2 net84_5 1.23939e-05f
C2688 BL_5_2 net84_7 1.88446e-05f
C2689 BL_5_2 net88 0.000568224f
C2690 BL_5_2 net88_2 0.000740165f
C2691 BL_5_2 net88_3 0.000740165f
C2692 BL_5_2 net88_4 0.000536088f
C2693 BL_5_2 net88_5 0.00126008f
C2694 BL_5_2 net88_7 0.00191591f
C2695 BL_6 BL_7 0.000164764f
C2696 BL_6 P_0_4_2 1.38329e-05f
C2697 BL_6 P_0_5 6.25636e-05f
C2698 BL_6 P_0_5_2 0.000243814f
C2699 BL_6 P_0_5_5 0.000107094f
C2700 BL_6 P_0_6 2.76063e-05f
C2701 BL_6 P_0_6_2 0.000107584f
C2702 BL_6 P_0_6_5 4.72556e-05f
C2703 BL_6 P_0_7_5 1.57043e-05f
C2704 BL_6 VDD_1 0.000857094f
C2705 BL_6 VSS_0 0.031451f
C2706 BL_6 VSS_2 0.00680366f
C2707 BL_6 WL_0 0.000298479f
C2708 BL_6 WL_0_1 0.000716374f
C2709 BL_6 WL_0_10 0.00129185f
C2710 BL_6 WL_0_11 0.00117441f
C2711 BL_6 WL_0_12 0.00129185f
C2712 BL_6 WL_0_13 0.00129185f
C2713 BL_6 WL_0_14 0.00129185f
C2714 BL_6 WL_0_15 0.00281859f
C2715 BL_6 WL_0_16 0.000593912f
C2716 BL_6 WL_0_17 0.000593912f
C2717 BL_6 WL_0_18 0.000593912f
C2718 BL_6 WL_0_19 0.000593912f
C2719 BL_6 WL_0_2 0.00077997f
C2720 BL_6 WL_0_20 0.000593912f
C2721 BL_6 WL_0_21 0.000593912f
C2722 BL_6 WL_0_22 0.000593912f
C2723 BL_6 WL_0_23 0.000593912f
C2724 BL_6 WL_0_24 0.000593912f
C2725 BL_6 WL_0_25 0.000593912f
C2726 BL_6 WL_0_26 0.000593912f
C2727 BL_6 WL_0_3 0.00077997f
C2728 BL_6 WL_0_4 0.00077997f
C2729 BL_6 WL_0_5 0.00077997f
C2730 BL_6 WL_0_6 0.00077997f
C2731 BL_6 WL_0_7 0.00077997f
C2732 BL_6 WL_0_8 0.00077997f
C2733 BL_6 WL_0_9 0.000822089f
C2734 BL_6 XB_0_5 0.000336858f
C2735 BL_6 XB_0_5_1 0.0014082f
C2736 BL_6 XB_0_5_3 0.000398065f
C2737 BL_6 XB_0_6_1 2.21215e-05f
C2738 BL_6 XB_0_7_3 1.19898e-05f
C2739 BL_6 net16_4 1.26579e-05f
C2740 BL_6 net16_7 1.9246e-05f
C2741 BL_6 net20 4.77356e-05f
C2742 BL_6 net20_11 2.79841e-05f
C2743 BL_6 net20_2 4.14135e-05f
C2744 BL_6 net20_3 4.49547e-05f
C2745 BL_6 net20_4 4.52848e-05f
C2746 BL_6 net20_5 1.80859e-05f
C2747 BL_6 net20_6 1.80859e-05f
C2748 BL_6 net20_8 1.80859e-05f
C2749 BL_6 net23 0.000586498f
C2750 BL_6 net23_3 0.000763968f
C2751 BL_6 net23_6 0.000553328f
C2752 BL_6 net23_7 0.00197753f
C2753 BL_6 net24 0.00149367f
C2754 BL_6 net24_11 0.000875637f
C2755 BL_6 net24_2 0.00129585f
C2756 BL_6 net24_3 0.00140665f
C2757 BL_6 net24_4 0.00141698f
C2758 BL_6 net24_6 0.000565917f
C2759 BL_6 net24_8 0.000565917f
C2760 BL_6 net28 1.35654e-05f
C2761 BL_6 net28_2 1.17688e-05f
C2762 BL_6 net28_3 1.27751e-05f
C2763 BL_6 net28_4 1.28689e-05f
C2764 BL_6 net72 3.33609e-05f
C2765 BL_6 net74 2.31589e-05f
C2766 BL_6 net90 3.02677e-05f
C2767 BL_6 net96 2.59487e-05f
C2768 BL_6_1 BL_7 6.14814e-05f
C2769 BL_6_1 P_0_5_1 0.000134021f
C2770 BL_6_1 P_0_5_3 2.70496e-05f
C2771 BL_6_1 P_0_5_4 5.45285e-05f
C2772 BL_6_1 P_0_6_1 5.91371e-05f
C2773 BL_6_1 P_0_6_3 1.19357e-05f
C2774 BL_6_1 P_0_6_4 2.40608e-05f
C2775 BL_6_1 P_0_7_1 1.96528e-05f
C2776 BL_6_1 P_0_7_2 3.57529e-05f
C2777 BL_6_1 VDD_1 0.000319823f
C2778 BL_6_1 VSS_0 0.0117359f
C2779 BL_6_1 VSS_2 0.00253877f
C2780 BL_6_1 WL_0_27 0.000593912f
C2781 BL_6_1 WL_0_28 0.000593912f
C2782 BL_6_1 WL_0_29 0.000593912f
C2783 BL_6_1 WL_0_30 0.000593912f
C2784 BL_6_1 WL_0_31 0.000593912f
C2785 BL_6_1 XB_0_5_2 0.000199033f
C2786 BL_6_1 XB_0_7 1.01462e-05f
C2787 BL_6_1 XB_0_7_1 4.24152e-05f
C2788 BL_6_1 net20_9 4.34842e-05f
C2789 BL_6_1 net23_2 0.000763968f
C2790 BL_6_1 net23_4 0.00130061f
C2791 BL_6_1 net24_5 0.000565917f
C2792 BL_6_1 net24_7 0.000282958f
C2793 BL_6_1 net24_9 0.00136064f
C2794 BL_6_1 net28_9 1.23572e-05f
C2795 BL_6_1 net72 1.24486e-05f
C2796 BL_6_1 net90 1.12943e-05f
C2797 BL_6_2 BL_7_2 6.14814e-05f
C2798 BL_6_2 P_1_4_1 1.00914e-05f
C2799 BL_6_2 P_1_4_2 1.83586e-05f
C2800 BL_6_2 P_1_5 6.15727e-05f
C2801 BL_6_2 P_1_5_1 0.000131898f
C2802 BL_6_2 P_1_5_2 0.000239952f
C2803 BL_6_2 P_1_5_3 0.000105398f
C2804 BL_6_2 P_1_5_4 2.66211e-05f
C2805 BL_6_2 P_1_5_5 5.36648e-05f
C2806 BL_6_2 P_1_6 3.40369e-05f
C2807 BL_6_2 P_1_6_1 7.29123e-05f
C2808 BL_6_2 P_1_6_2 0.000132644f
C2809 BL_6_2 P_1_6_3 5.82631e-05f
C2810 BL_6_2 P_1_6_4 1.47159e-05f
C2811 BL_6_2 P_1_6_5 2.96655e-05f
C2812 BL_6_2 P_1_7_1 2.11844e-05f
C2813 BL_6_2 P_1_7_2 3.85392e-05f
C2814 BL_6_2 P_1_7_3 1.69282e-05f
C2815 BL_6_2 VDD_1 0.000319823f
C2816 BL_6_2 VSS_0 0.0117359f
C2817 BL_6_2 VSS_2 0.00253877f
C2818 BL_6_2 WL_1 0.000297178f
C2819 BL_6_2 WL_1_1 0.000713253f
C2820 BL_6_2 WL_1_10 0.00128623f
C2821 BL_6_2 WL_1_11 0.0011693f
C2822 BL_6_2 WL_1_12 0.00128623f
C2823 BL_6_2 WL_1_13 0.00128623f
C2824 BL_6_2 WL_1_14 0.00128623f
C2825 BL_6_2 WL_1_15 0.00280631f
C2826 BL_6_2 WL_1_16 0.000591325f
C2827 BL_6_2 WL_1_17 0.000591325f
C2828 BL_6_2 WL_1_18 0.000591325f
C2829 BL_6_2 WL_1_19 0.000591325f
C2830 BL_6_2 WL_1_2 0.000776572f
C2831 BL_6_2 WL_1_20 0.000591325f
C2832 BL_6_2 WL_1_21 0.000591325f
C2833 BL_6_2 WL_1_22 0.000591325f
C2834 BL_6_2 WL_1_23 0.000591325f
C2835 BL_6_2 WL_1_24 0.000591325f
C2836 BL_6_2 WL_1_25 0.000591325f
C2837 BL_6_2 WL_1_26 0.000591325f
C2838 BL_6_2 WL_1_27 0.000591325f
C2839 BL_6_2 WL_1_28 0.000591325f
C2840 BL_6_2 WL_1_29 0.000591325f
C2841 BL_6_2 WL_1_3 0.000776572f
C2842 BL_6_2 WL_1_30 0.000591325f
C2843 BL_6_2 WL_1_31 0.000591325f
C2844 BL_6_2 WL_1_4 0.000776572f
C2845 BL_6_2 WL_1_5 0.000776572f
C2846 BL_6_2 WL_1_6 0.000776572f
C2847 BL_6_2 WL_1_7 0.000776572f
C2848 BL_6_2 WL_1_8 0.000776572f
C2849 BL_6_2 WL_1_9 0.000818508f
C2850 BL_6_2 XB_1_5 0.000340995f
C2851 BL_6_2 XB_1_5_1 0.00142549f
C2852 BL_6_2 XB_1_5_2 0.000201477f
C2853 BL_6_2 XB_1_5_3 0.000402953f
C2854 BL_6_2 XB_1_6_1 3.69511e-05f
C2855 BL_6_2 XB_1_6_3 1.04452e-05f
C2856 BL_6_2 XB_1_7 1.64715e-05f
C2857 BL_6_2 XB_1_7_1 6.88573e-05f
C2858 BL_6_2 XB_1_7_3 1.94644e-05f
C2859 BL_6_2 net139 5.93199e-05f
C2860 BL_6_2 net139_10 5.40368e-05f
C2861 BL_6_2 net139_2 5.14636e-05f
C2862 BL_6_2 net139_3 5.58641e-05f
C2863 BL_6_2 net139_4 5.62743e-05f
C2864 BL_6_2 net139_5 2.24749e-05f
C2865 BL_6_2 net139_6 2.24749e-05f
C2866 BL_6_2 net139_7 1.12375e-05f
C2867 BL_6_2 net139_8 2.24749e-05f
C2868 BL_6_2 net139_9 3.47752e-05f
C2869 BL_6_2 net141 0.00153165f
C2870 BL_6_2 net141_10 0.00139524f
C2871 BL_6_2 net141_2 0.0013288f
C2872 BL_6_2 net141_3 0.00144242f
C2873 BL_6_2 net141_4 0.00145301f
C2874 BL_6_2 net141_5 0.000580307f
C2875 BL_6_2 net141_6 0.000580307f
C2876 BL_6_2 net141_7 0.000290153f
C2877 BL_6_2 net141_8 0.000580307f
C2878 BL_6_2 net141_9 0.000897903f
C2879 BL_6_2 net142 2.64579e-05f
C2880 BL_6_2 net142_10 2.41016e-05f
C2881 BL_6_2 net142_2 2.29539e-05f
C2882 BL_6_2 net142_3 2.49166e-05f
C2883 BL_6_2 net142_4 2.50995e-05f
C2884 BL_6_2 net142_5 1.00243e-05f
C2885 BL_6_2 net142_6 1.00243e-05f
C2886 BL_6_2 net142_8 1.00243e-05f
C2887 BL_6_2 net142_9 1.55105e-05f
C2888 BL_6_2 net72 1.24486e-05f
C2889 BL_6_2 net86_5 1.19937e-05f
C2890 BL_6_2 net86_7 1.82361e-05f
C2891 BL_6_2 net90 1.12943e-05f
C2892 BL_6_2 net91 0.000568789f
C2893 BL_6_2 net91_2 0.000740901f
C2894 BL_6_2 net91_3 0.000740901f
C2895 BL_6_2 net91_4 0.00053662f
C2896 BL_6_2 net91_5 0.00126133f
C2897 BL_6_2 net91_7 0.00191782f
C2898 BL_7 P_0_5_1 1.00743e-05f
C2899 BL_7 P_0_5_2 1.83274e-05f
C2900 BL_7 P_0_6 6.52906e-05f
C2901 BL_7 P_0_6_2 0.000254441f
C2902 BL_7 P_0_6_5 0.000111762f
C2903 BL_7 P_0_7 3.47346e-05f
C2904 BL_7 P_0_7_2 0.000135363f
C2905 BL_7 P_0_7_5 5.94575e-05f
C2906 BL_7 VDD_1 0.000912717f
C2907 BL_7 VSS_0 0.0314319f
C2908 BL_7 VSS_2 0.00678734f
C2909 BL_7 WL_0 0.000301152f
C2910 BL_7 WL_0_1 0.000722791f
C2911 BL_7 WL_0_10 0.00130343f
C2912 BL_7 WL_0_11 0.00118493f
C2913 BL_7 WL_0_12 0.00130343f
C2914 BL_7 WL_0_13 0.00130343f
C2915 BL_7 WL_0_14 0.00130343f
C2916 BL_7 WL_0_15 0.00284384f
C2917 BL_7 WL_0_16 0.000599233f
C2918 BL_7 WL_0_17 0.000599233f
C2919 BL_7 WL_0_18 0.000599233f
C2920 BL_7 WL_0_19 0.000599233f
C2921 BL_7 WL_0_2 0.000786957f
C2922 BL_7 WL_0_20 0.000599233f
C2923 BL_7 WL_0_21 0.000599233f
C2924 BL_7 WL_0_22 0.000599233f
C2925 BL_7 WL_0_23 0.000599233f
C2926 BL_7 WL_0_24 0.000599233f
C2927 BL_7 WL_0_25 0.000599233f
C2928 BL_7 WL_0_26 0.000599233f
C2929 BL_7 WL_0_27 0.000599233f
C2930 BL_7 WL_0_28 0.000599233f
C2931 BL_7 WL_0_3 0.000786957f
C2932 BL_7 WL_0_4 0.000786957f
C2933 BL_7 WL_0_5 0.000786957f
C2934 BL_7 WL_0_6 0.000786957f
C2935 BL_7 WL_0_7 0.000786957f
C2936 BL_7 WL_0_8 0.000786957f
C2937 BL_7 WL_0_9 0.000829454f
C2938 BL_7 XB_0_6 0.000327498f
C2939 BL_7 XB_0_6_1 0.00136907f
C2940 BL_7 XB_0_6_3 0.000387004f
C2941 BL_7 XB_0_7_1 6.74054e-05f
C2942 BL_7 XB_0_7_3 1.90539e-05f
C2943 BL_7 net19_4 1.2225e-05f
C2944 BL_7 net19_7 1.85877e-05f
C2945 BL_7 net24 5.88807e-05f
C2946 BL_7 net24_11 3.45178e-05f
C2947 BL_7 net24_2 5.10826e-05f
C2948 BL_7 net24_3 5.54505e-05f
C2949 BL_7 net24_4 5.58577e-05f
C2950 BL_7 net24_5 2.23085e-05f
C2951 BL_7 net24_6 2.23085e-05f
C2952 BL_7 net24_8 2.23085e-05f
C2953 BL_7 net27 0.000588509f
C2954 BL_7 net27_3 0.000766588f
C2955 BL_7 net27_6 0.000555225f
C2956 BL_7 net27_7 0.00198431f
C2957 BL_7 net28 0.00149348f
C2958 BL_7 net28_11 0.000875526f
C2959 BL_7 net28_2 0.00129568f
C2960 BL_7 net28_3 0.00140647f
C2961 BL_7 net28_4 0.0014168f
C2962 BL_7 net28_6 0.000565845f
C2963 BL_7 net28_8 0.000565845f
C2964 BL_7 net73 1.71069e-05f
C2965 BL_7 net93 1.637e-05f
C2966 BL_7 net96 1.20446e-05f
C2967 BL_7_1 P_0_6_1 0.000139863f
C2968 BL_7_1 P_0_6_3 2.82286e-05f
C2969 BL_7_1 P_0_6_4 5.69052e-05f
C2970 BL_7_1 P_0_7_1 7.4407e-05f
C2971 BL_7_1 P_0_7_3 1.50176e-05f
C2972 BL_7_1 P_0_7_4 3.02736e-05f
C2973 BL_7_1 VDD_1 0.000340579f
C2974 BL_7_1 VSS_0 0.0117288f
C2975 BL_7_1 VSS_2 0.00253268f
C2976 BL_7_1 WL_0_29 0.000599233f
C2977 BL_7_1 WL_0_30 0.000599233f
C2978 BL_7_1 WL_0_31 0.000599233f
C2979 BL_7_1 XB_0_6_2 0.000193502f
C2980 BL_7_1 XB_0_7 1.61242e-05f
C2981 BL_7_1 net24_7 1.11543e-05f
C2982 BL_7_1 net24_9 5.36367e-05f
C2983 BL_7_1 net27_2 0.000766588f
C2984 BL_7_1 net27_4 0.00130507f
C2985 BL_7_1 net28_5 0.000565845f
C2986 BL_7_1 net28_7 0.000282922f
C2987 BL_7_1 net28_9 0.00136047f
C2988 BL_7_2 P_1_5_2 1.57284e-05f
C2989 BL_7_2 P_1_6 6.28034e-05f
C2990 BL_7_2 P_1_6_1 0.000134535f
C2991 BL_7_2 P_1_6_2 0.000244749f
C2992 BL_7_2 P_1_6_3 0.000107505f
C2993 BL_7_2 P_1_6_4 2.71533e-05f
C2994 BL_7_2 P_1_6_5 5.47375e-05f
C2995 BL_7_2 P_1_7 3.6217e-05f
C2996 BL_7_2 P_1_7_1 7.75824e-05f
C2997 BL_7_2 P_1_7_2 0.00014114f
C2998 BL_7_2 P_1_7_3 6.19949e-05f
C2999 BL_7_2 P_1_7_4 1.56585e-05f
C3000 BL_7_2 P_1_7_5 3.15656e-05f
C3001 BL_7_2 VDD_1 0.000340579f
C3002 BL_7_2 VSS_0 0.0117288f
C3003 BL_7_2 VSS_2 0.00253268f
C3004 BL_7_2 WL_1 0.000293403f
C3005 BL_7_2 WL_1_1 0.000704193f
C3006 BL_7_2 WL_1_10 0.00126989f
C3007 BL_7_2 WL_1_11 0.00115444f
C3008 BL_7_2 WL_1_12 0.00126989f
C3009 BL_7_2 WL_1_13 0.00126989f
C3010 BL_7_2 WL_1_14 0.00126989f
C3011 BL_7_2 WL_1_15 0.00277067f
C3012 BL_7_2 WL_1_16 0.000583814f
C3013 BL_7_2 WL_1_17 0.000583814f
C3014 BL_7_2 WL_1_18 0.000583814f
C3015 BL_7_2 WL_1_19 0.000583814f
C3016 BL_7_2 WL_1_2 0.000766708f
C3017 BL_7_2 WL_1_20 0.000583814f
C3018 BL_7_2 WL_1_21 0.000583814f
C3019 BL_7_2 WL_1_22 0.000583814f
C3020 BL_7_2 WL_1_23 0.000583814f
C3021 BL_7_2 WL_1_24 0.000583814f
C3022 BL_7_2 WL_1_25 0.000583814f
C3023 BL_7_2 WL_1_26 0.000583814f
C3024 BL_7_2 WL_1_27 0.000583814f
C3025 BL_7_2 WL_1_28 0.000583814f
C3026 BL_7_2 WL_1_29 0.000583814f
C3027 BL_7_2 WL_1_3 0.000766708f
C3028 BL_7_2 WL_1_30 0.000583814f
C3029 BL_7_2 WL_1_31 0.000583814f
C3030 BL_7_2 WL_1_4 0.000766708f
C3031 BL_7_2 WL_1_5 0.000766708f
C3032 BL_7_2 WL_1_6 0.000766708f
C3033 BL_7_2 WL_1_7 0.000766708f
C3034 BL_7_2 WL_1_8 0.000766708f
C3035 BL_7_2 WL_1_9 0.000808111f
C3036 BL_7_2 XB_1_6 0.00033527f
C3037 BL_7_2 XB_1_6_1 0.00140156f
C3038 BL_7_2 XB_1_6_2 0.000198094f
C3039 BL_7_2 XB_1_6_3 0.000396188f
C3040 BL_7_2 XB_1_7 1.46097e-05f
C3041 BL_7_2 XB_1_7_1 6.10742e-05f
C3042 BL_7_2 XB_1_7_3 1.72643e-05f
C3043 BL_7_2 net141 6.57677e-05f
C3044 BL_7_2 net141_10 5.99103e-05f
C3045 BL_7_2 net141_2 5.70575e-05f
C3046 BL_7_2 net141_3 6.19363e-05f
C3047 BL_7_2 net141_4 6.23911e-05f
C3048 BL_7_2 net141_5 2.49179e-05f
C3049 BL_7_2 net141_6 2.49179e-05f
C3050 BL_7_2 net141_7 1.24589e-05f
C3051 BL_7_2 net141_8 2.49179e-05f
C3052 BL_7_2 net141_9 3.85551e-05f
C3053 BL_7_2 net142 0.0015438f
C3054 BL_7_2 net142_10 0.00140631f
C3055 BL_7_2 net142_2 0.00133934f
C3056 BL_7_2 net142_3 0.00145386f
C3057 BL_7_2 net142_4 0.00146454f
C3058 BL_7_2 net142_5 0.000584909f
C3059 BL_7_2 net142_6 0.000584909f
C3060 BL_7_2 net142_7 0.000292455f
C3061 BL_7_2 net142_8 0.000584909f
C3062 BL_7_2 net142_9 0.000905024f
C3063 BL_7_2 net88_5 1.1019e-05f
C3064 BL_7_2 net88_7 1.6754e-05f
C3065 BL_7_2 net91_7 1.10716e-05f
C3066 BL_7_2 net94 0.000573879f
C3067 BL_7_2 net94_2 0.000747531f
C3068 BL_7_2 net94_3 0.000747531f
C3069 BL_7_2 net94_4 0.000541422f
C3070 BL_7_2 net94_5 0.00127262f
C3071 BL_7_2 net94_7 0.00193498f
C3072 P_0_0 VDD_1 0.00102299f
C3073 P_0_0 VSS_0 0.00768386f
C3074 P_0_0 VSS_2 2.26743e-05f
C3075 P_0_0 WL_0 6.94879e-05f
C3076 P_0_0 WL_0_1 0.000166777f
C3077 P_0_0 WL_0_9 0.000191388f
C3078 P_0_0 XB_0_0 0.0017738f
C3079 P_0_0 XB_1_0_3 2.44609e-05f
C3080 P_0_0 net3 0.00851939f
C3081 P_0_0 net3_11 0.00499434f
C3082 P_0_0 net3_3 0.00802308f
C3083 P_0_0 net3_4 0.008082f
C3084 P_0_0 net3_6 0.0032278f
C3085 P_0_0 net67 0.000299423f
C3086 P_0_0_1 VDD_1 0.0021914f
C3087 P_0_0_1 VSS_0 0.01646f
C3088 P_0_0_1 VSS_2 4.85719e-05f
C3089 P_0_0_1 XB_0_0 0.00379975f
C3090 P_0_0_1 XB_1_0_3 5.2399e-05f
C3091 P_0_0_1 net3_2 0.00739109f
C3092 P_0_0_1 net67 0.000641411f
C3093 P_0_0_1 net76_3 1.29814e-05f
C3094 P_0_0_1 net79_4 1.18696e-05f
C3095 P_0_0_2 VDD_1 0.00398665f
C3096 P_0_0_2 VSS_0 0.0299445f
C3097 P_0_0_2 VSS_2 8.83631e-05f
C3098 P_0_0_2 WL_0_16 0.000138267f
C3099 P_0_0_2 WL_0_17 0.000138267f
C3100 P_0_0_2 XB_0_0 0.00691259f
C3101 P_0_0_2 XB_1_0_3 9.53254e-05f
C3102 P_0_0_2 net3_5 0.0032278f
C3103 P_0_0_2 net3_9 0.00776065f
C3104 P_0_0_2 net67 0.00116687f
C3105 P_0_0_2 net76_3 2.36161e-05f
C3106 P_0_0_2 net79_4 2.15934e-05f
C3107 P_0_0_3 VDD_1 0.000442292f
C3108 P_0_0_3 VSS_0 0.00332214f
C3109 P_0_0_3 XB_0_0 0.000766906f
C3110 P_0_0_3 XB_1_0_3 1.05757e-05f
C3111 P_0_0_3 net3_7 0.0016139f
C3112 P_0_0_3 net67 0.000129456f
C3113 P_0_0_4 VDD_1 0.000891605f
C3114 P_0_0_4 VSS_0 0.00669701f
C3115 P_0_0_4 VSS_2 1.97622e-05f
C3116 P_0_0_4 WL_0_10 0.000300753f
C3117 P_0_0_4 WL_0_11 0.000273412f
C3118 P_0_0_4 WL_0_12 0.000300753f
C3119 P_0_0_4 WL_0_13 0.000300753f
C3120 P_0_0_4 WL_0_14 0.000300753f
C3121 P_0_0_4 WL_0_15 0.000656188f
C3122 P_0_0_4 WL_0_18 0.000138267f
C3123 P_0_0_4 WL_0_19 0.000138267f
C3124 P_0_0_4 WL_0_2 0.000181582f
C3125 P_0_0_4 WL_0_20 0.000138267f
C3126 P_0_0_4 WL_0_21 0.000138267f
C3127 P_0_0_4 WL_0_22 0.000138267f
C3128 P_0_0_4 WL_0_23 0.000138267f
C3129 P_0_0_4 WL_0_24 0.000138267f
C3130 P_0_0_4 WL_0_25 0.000138267f
C3131 P_0_0_4 WL_0_26 0.000138267f
C3132 P_0_0_4 WL_0_27 0.000138267f
C3133 P_0_0_4 WL_0_28 0.000138267f
C3134 P_0_0_4 WL_0_29 0.000138267f
C3135 P_0_0_4 WL_0_3 0.000181582f
C3136 P_0_0_4 WL_0_30 0.000138267f
C3137 P_0_0_4 WL_0_31 0.000138267f
C3138 P_0_0_4 WL_0_4 0.000181582f
C3139 P_0_0_4 WL_0_5 0.000181582f
C3140 P_0_0_4 WL_0_6 0.000181582f
C3141 P_0_0_4 WL_0_7 0.000181582f
C3142 P_0_0_4 WL_0_8 0.000181582f
C3143 P_0_0_4 WL_1_11 2.18674e-05f
C3144 P_0_0_4 WL_1_12 2.40541e-05f
C3145 P_0_0_4 WL_1_13 2.40541e-05f
C3146 P_0_0_4 WL_1_14 2.40541e-05f
C3147 P_0_0_4 WL_1_15 5.24817e-05f
C3148 P_0_0_4 WL_1_20 1.10586e-05f
C3149 P_0_0_4 WL_1_21 1.10586e-05f
C3150 P_0_0_4 WL_1_22 1.10586e-05f
C3151 P_0_0_4 WL_1_23 1.10586e-05f
C3152 P_0_0_4 WL_1_24 1.10586e-05f
C3153 P_0_0_4 WL_1_25 1.10586e-05f
C3154 P_0_0_4 WL_1_26 1.10586e-05f
C3155 P_0_0_4 WL_1_27 1.10586e-05f
C3156 P_0_0_4 WL_1_28 1.10586e-05f
C3157 P_0_0_4 WL_1_29 1.10586e-05f
C3158 P_0_0_4 WL_1_3 1.45229e-05f
C3159 P_0_0_4 WL_1_30 1.10586e-05f
C3160 P_0_0_4 WL_1_31 1.10586e-05f
C3161 P_0_0_4 WL_1_4 1.45229e-05f
C3162 P_0_0_4 WL_1_5 1.45229e-05f
C3163 P_0_0_4 WL_1_6 1.45229e-05f
C3164 P_0_0_4 WL_1_7 1.45229e-05f
C3165 P_0_0_4 WL_1_8 1.45229e-05f
C3166 P_0_0_4 XB_0_0_2 0.00154599f
C3167 P_0_0_4 XB_1_0_3 2.13193e-05f
C3168 P_0_0_4 net10_7 1.02663e-05f
C3169 P_0_0_4 net67 0.000260968f
C3170 P_0_0_4 net7 3.3918e-05f
C3171 P_0_0_4 net7_11 1.98838e-05f
C3172 P_0_0_4 net7_2 2.94259e-05f
C3173 P_0_0_4 net7_3 3.1942e-05f
C3174 P_0_0_4 net7_4 3.21766e-05f
C3175 P_0_0_4 net7_5 1.28507e-05f
C3176 P_0_0_4 net7_6 1.28507e-05f
C3177 P_0_0_4 net7_8 1.28507e-05f
C3178 P_0_0_4 net7_9 3.08972e-05f
C3179 P_0_0_5 VDD_1 0.00175112f
C3180 P_0_0_5 VSS_0 0.013153f
C3181 P_0_0_5 VSS_2 3.88131e-05f
C3182 P_0_0_5 WL_1_1 1.33388e-05f
C3183 P_0_0_5 WL_1_10 2.40541e-05f
C3184 P_0_0_5 WL_1_16 1.10586e-05f
C3185 P_0_0_5 WL_1_17 1.10586e-05f
C3186 P_0_0_5 WL_1_18 1.10586e-05f
C3187 P_0_0_5 WL_1_19 1.10586e-05f
C3188 P_0_0_5 WL_1_2 1.45229e-05f
C3189 P_0_0_5 WL_1_9 1.53072e-05f
C3190 P_0_0_5 XB_0_0_3 0.00303632f
C3191 P_0_0_5 XB_1_0_3 4.18712e-05f
C3192 P_0_0_5 net130 3.00406e-05f
C3193 P_0_0_5 net130_10 2.73652e-05f
C3194 P_0_0_5 net130_2 2.60621e-05f
C3195 P_0_0_5 net130_3 2.82906e-05f
C3196 P_0_0_5 net130_4 2.84983e-05f
C3197 P_0_0_5 net130_5 1.13817e-05f
C3198 P_0_0_5 net130_6 1.13817e-05f
C3199 P_0_0_5 net130_8 1.13817e-05f
C3200 P_0_0_5 net130_9 1.76108e-05f
C3201 P_0_0_5 net3_8 0.0032278f
C3202 P_0_0_5 net67 0.000512542f
C3203 P_0_0_5 net76_3 1.03732e-05f
C3204 P_0_1 VDD_1 0.000990875f
C3205 P_0_1 VSS_0 0.00766232f
C3206 P_0_1 WL_0 7.23308e-05f
C3207 P_0_1 WL_0_1 0.0001736f
C3208 P_0_1 WL_0_10 0.000313057f
C3209 P_0_1 WL_0_2 0.000189011f
C3210 P_0_1 WL_0_9 0.000199218f
C3211 P_0_1 XB_0_1 0.00178482f
C3212 P_0_1 XB_1_1_3 2.76704e-05f
C3213 P_0_1 net68 0.000304728f
C3214 P_0_1 net7 0.00851566f
C3215 P_0_1 net7_11 0.00499216f
C3216 P_0_1 net7_3 0.00801957f
C3217 P_0_1 net7_4 0.00807846f
C3218 P_0_1 net7_6 0.00322639f
C3219 P_0_1 net81_4 1.1109e-05f
C3220 P_0_1_1 VDD_1 0.00212261f
C3221 P_0_1_1 VSS_0 0.0164139f
C3222 P_0_1_1 XB_0_1 0.00382337f
C3223 P_0_1_1 XB_1_1_3 5.92744e-05f
C3224 P_0_1_1 net68 0.000652776f
C3225 P_0_1_1 net79_3 1.0319e-05f
C3226 P_0_1_1 net7_2 0.00738785f
C3227 P_0_1_1 net81_4 2.37971e-05f
C3228 P_0_1_2 VDD_1 0.0038615f
C3229 P_0_1_2 VSS_0 0.0298605f
C3230 P_0_1_2 VSS_2 1.59115e-05f
C3231 P_0_1_2 WL_0_16 0.000143924f
C3232 P_0_1_2 WL_0_17 0.000143924f
C3233 P_0_1_2 WL_0_18 0.000143924f
C3234 P_0_1_2 WL_0_19 0.000143924f
C3235 P_0_1_2 XB_0_0_1 1.4981e-05f
C3236 P_0_1_2 XB_0_1 0.00695555f
C3237 P_0_1_2 XB_0_6 1.00865e-05f
C3238 P_0_1_2 XB_1_1_3 0.000107833f
C3239 P_0_1_2 net68 0.00118754f
C3240 P_0_1_2 net79_3 1.87726e-05f
C3241 P_0_1_2 net7_5 0.00322639f
C3242 P_0_1_2 net7_9 0.00775725f
C3243 P_0_1_2 net81_4 4.32923e-05f
C3244 P_0_1_3 VDD_1 0.000428408f
C3245 P_0_1_3 VSS_0 0.00331283f
C3246 P_0_1_3 XB_0_1 0.000771673f
C3247 P_0_1_3 XB_1_1_3 1.19634e-05f
C3248 P_0_1_3 net68 0.00013175f
C3249 P_0_1_3 net7_7 0.00161319f
C3250 P_0_1_4 VDD_1 0.000863615f
C3251 P_0_1_4 VSS_0 0.00667824f
C3252 P_0_1_4 WL_0_11 0.000284597f
C3253 P_0_1_4 WL_0_12 0.000313057f
C3254 P_0_1_4 WL_0_13 0.000313057f
C3255 P_0_1_4 WL_0_14 0.000313057f
C3256 P_0_1_4 WL_0_15 0.000683033f
C3257 P_0_1_4 WL_0_20 0.000143924f
C3258 P_0_1_4 WL_0_21 0.000143924f
C3259 P_0_1_4 WL_0_22 0.000143924f
C3260 P_0_1_4 WL_0_23 0.000143924f
C3261 P_0_1_4 WL_0_24 0.000143924f
C3262 P_0_1_4 WL_0_25 0.000143924f
C3263 P_0_1_4 WL_0_26 0.000143924f
C3264 P_0_1_4 WL_0_27 0.000143924f
C3265 P_0_1_4 WL_0_28 0.000143924f
C3266 P_0_1_4 WL_0_29 0.000143924f
C3267 P_0_1_4 WL_0_3 0.000189011f
C3268 P_0_1_4 WL_0_30 0.000143924f
C3269 P_0_1_4 WL_0_31 0.000143924f
C3270 P_0_1_4 WL_0_4 0.000189011f
C3271 P_0_1_4 WL_0_5 0.000189011f
C3272 P_0_1_4 WL_0_6 0.000189011f
C3273 P_0_1_4 WL_0_7 0.000189011f
C3274 P_0_1_4 WL_0_8 0.000189011f
C3275 P_0_1_4 WL_1_12 1.03274e-05f
C3276 P_0_1_4 WL_1_13 1.03274e-05f
C3277 P_0_1_4 WL_1_14 1.03274e-05f
C3278 P_0_1_4 WL_1_15 2.25324e-05f
C3279 P_0_1_4 XB_0_1_2 0.00155559f
C3280 P_0_1_4 XB_1_1_3 2.41167e-05f
C3281 P_0_1_4 net10 1.32571e-05f
C3282 P_0_1_4 net10_2 1.72686e-05f
C3283 P_0_1_4 net10_3 1.72686e-05f
C3284 P_0_1_4 net10_4 2.93986e-05f
C3285 P_0_1_4 net10_6 1.25073e-05f
C3286 P_0_1_4 net10_7 4.46997e-05f
C3287 P_0_1_4 net11 3.55907e-05f
C3288 P_0_1_4 net11_11 2.08644e-05f
C3289 P_0_1_4 net11_2 3.08771e-05f
C3290 P_0_1_4 net11_3 3.35173e-05f
C3291 P_0_1_4 net11_4 3.37634e-05f
C3292 P_0_1_4 net11_5 1.34845e-05f
C3293 P_0_1_4 net11_6 1.34845e-05f
C3294 P_0_1_4 net11_8 1.34845e-05f
C3295 P_0_1_4 net11_9 3.24209e-05f
C3296 P_0_1_4 net68 0.000265592f
C3297 P_0_1_5 VDD_1 0.00169614f
C3298 P_0_1_5 VSS_0 0.0131161f
C3299 P_0_1_5 WL_1_10 1.03274e-05f
C3300 P_0_1_5 XB_0_1_3 0.00305519f
C3301 P_0_1_5 XB_1_1_3 4.73653e-05f
C3302 P_0_1_5 net132 4.36072e-05f
C3303 P_0_1_5 net132_10 3.97234e-05f
C3304 P_0_1_5 net132_2 3.78319e-05f
C3305 P_0_1_5 net132_3 4.10668e-05f
C3306 P_0_1_5 net132_4 4.13683e-05f
C3307 P_0_1_5 net132_5 1.65217e-05f
C3308 P_0_1_5 net132_6 1.65217e-05f
C3309 P_0_1_5 net132_8 1.65217e-05f
C3310 P_0_1_5 net132_9 2.55639e-05f
C3311 P_0_1_5 net68 0.000521623f
C3312 P_0_1_5 net7_8 0.00322639f
C3313 P_0_1_5 net81_4 1.90159e-05f
C3314 P_0_2 VDD_1 0.00101345f
C3315 P_0_2 VSS_0 0.00763617f
C3316 P_0_2 VSS_2 2.05148e-05f
C3317 P_0_2 WL_0 7.18797e-05f
C3318 P_0_2 WL_0_1 0.000172517f
C3319 P_0_2 WL_0_10 0.000311105f
C3320 P_0_2 WL_0_11 0.000282823f
C3321 P_0_2 WL_0_2 0.000187833f
C3322 P_0_2 WL_0_3 0.000187833f
C3323 P_0_2 WL_0_9 0.000197976f
C3324 P_0_2 WL_1_1 1.4002e-05f
C3325 P_0_2 WL_1_10 2.52502e-05f
C3326 P_0_2 WL_1_16 1.16084e-05f
C3327 P_0_2 WL_1_17 1.16084e-05f
C3328 P_0_2 WL_1_18 1.16084e-05f
C3329 P_0_2 WL_1_19 1.16084e-05f
C3330 P_0_2 WL_1_2 1.5245e-05f
C3331 P_0_2 WL_1_9 1.60683e-05f
C3332 P_0_2 XB_0_2 0.00177896f
C3333 P_0_2 XB_1_2_3 2.6432e-05f
C3334 P_0_2 net10_7 2.1761e-05f
C3335 P_0_2 net11 0.0085295f
C3336 P_0_2 net11_11 0.00500027f
C3337 P_0_2 net11_3 0.0080326f
C3338 P_0_2 net11_4 0.00809158f
C3339 P_0_2 net11_6 0.00323163f
C3340 P_0_2 net69 0.000301483f
C3341 P_0_2_1 VDD_1 0.00217097f
C3342 P_0_2_1 VSS_0 0.0163579f
C3343 P_0_2_1 VSS_2 4.39459e-05f
C3344 P_0_2_1 XB_0_2 0.00381081f
C3345 P_0_2_1 XB_1_2_3 5.66216e-05f
C3346 P_0_2_1 net11_2 0.00739986f
C3347 P_0_2_1 net69 0.000645823f
C3348 P_0_2_1 net84_4 1.55253e-05f
C3349 P_0_2_2 VDD_1 0.00394948f
C3350 P_0_2_2 VSS_0 0.0297586f
C3351 P_0_2_2 VSS_2 7.99474e-05f
C3352 P_0_2_2 WL_0_16 0.000143026f
C3353 P_0_2_2 WL_0_17 0.000143026f
C3354 P_0_2_2 WL_0_18 0.000143026f
C3355 P_0_2_2 WL_0_19 0.000143026f
C3356 P_0_2_2 WL_0_20 0.000143026f
C3357 P_0_2_2 WL_0_21 0.000143026f
C3358 P_0_2_2 XB_0_2 0.0069327f
C3359 P_0_2_2 XB_1_1_3 1.07634e-05f
C3360 P_0_2_2 XB_1_2_3 0.000103007f
C3361 P_0_2_2 net10_4 1.4312e-05f
C3362 P_0_2_2 net11_5 0.00323163f
C3363 P_0_2_2 net11_9 0.00776985f
C3364 P_0_2_2 net69 0.0011749f
C3365 P_0_2_2 net81_3 1.28716e-05f
C3366 P_0_2_2 net84_4 2.82439e-05f
C3367 P_0_2_3 VDD_1 0.000438169f
C3368 P_0_2_3 VSS_0 0.00330152f
C3369 P_0_2_3 XB_0_2 0.000769138f
C3370 P_0_2_3 XB_1_2_3 1.1428e-05f
C3371 P_0_2_3 net11_7 0.00161581f
C3372 P_0_2_3 net69 0.000130347f
C3373 P_0_2_4 VDD_1 0.000883292f
C3374 P_0_2_4 VSS_0 0.00665545f
C3375 P_0_2_4 VSS_2 1.78801e-05f
C3376 P_0_2_4 WL_0_12 0.000311105f
C3377 P_0_2_4 WL_0_13 0.000311105f
C3378 P_0_2_4 WL_0_14 0.000311105f
C3379 P_0_2_4 WL_0_15 0.000678774f
C3380 P_0_2_4 WL_0_22 0.000143026f
C3381 P_0_2_4 WL_0_23 0.000143026f
C3382 P_0_2_4 WL_0_24 0.000143026f
C3383 P_0_2_4 WL_0_25 0.000143026f
C3384 P_0_2_4 WL_0_26 0.000143026f
C3385 P_0_2_4 WL_0_27 0.000143026f
C3386 P_0_2_4 WL_0_28 0.000143026f
C3387 P_0_2_4 WL_0_29 0.000143026f
C3388 P_0_2_4 WL_0_30 0.000143026f
C3389 P_0_2_4 WL_0_31 0.000143026f
C3390 P_0_2_4 WL_0_4 0.000187833f
C3391 P_0_2_4 WL_0_5 0.000187833f
C3392 P_0_2_4 WL_0_6 0.000187833f
C3393 P_0_2_4 WL_0_7 0.000187833f
C3394 P_0_2_4 WL_0_8 0.000187833f
C3395 P_0_2_4 WL_1_13 2.52502e-05f
C3396 P_0_2_4 WL_1_14 2.52502e-05f
C3397 P_0_2_4 WL_1_15 5.50912e-05f
C3398 P_0_2_4 WL_1_24 1.16084e-05f
C3399 P_0_2_4 WL_1_25 1.16084e-05f
C3400 P_0_2_4 WL_1_26 1.16084e-05f
C3401 P_0_2_4 WL_1_27 1.16084e-05f
C3402 P_0_2_4 WL_1_28 1.16084e-05f
C3403 P_0_2_4 WL_1_29 1.16084e-05f
C3404 P_0_2_4 WL_1_30 1.16084e-05f
C3405 P_0_2_4 WL_1_31 1.16084e-05f
C3406 P_0_2_4 WL_1_5 1.5245e-05f
C3407 P_0_2_4 WL_1_6 1.5245e-05f
C3408 P_0_2_4 WL_1_7 1.5245e-05f
C3409 P_0_2_4 WL_1_8 1.5245e-05f
C3410 P_0_2_4 XB_0_2_2 0.00155048f
C3411 P_0_2_4 XB_1_2_3 2.30373e-05f
C3412 P_0_2_4 net13_2 1.15191e-05f
C3413 P_0_2_4 net13_3 1.15191e-05f
C3414 P_0_2_4 net13_4 1.96106e-05f
C3415 P_0_2_4 net13_7 2.98172e-05f
C3416 P_0_2_4 net14 2.90616e-05f
C3417 P_0_2_4 net14_11 1.70369e-05f
C3418 P_0_2_4 net14_2 2.52127e-05f
C3419 P_0_2_4 net14_3 2.73686e-05f
C3420 P_0_2_4 net14_4 2.75696e-05f
C3421 P_0_2_4 net14_5 1.10108e-05f
C3422 P_0_2_4 net14_6 1.10108e-05f
C3423 P_0_2_4 net14_8 1.10108e-05f
C3424 P_0_2_4 net14_9 2.64734e-05f
C3425 P_0_2_4 net69 0.000262763f
C3426 P_0_2_5 VDD_1 0.00173479f
C3427 P_0_2_5 VSS_0 0.0130713f
C3428 P_0_2_5 VSS_2 3.51165e-05f
C3429 P_0_2_5 WL_1_11 2.29547e-05f
C3430 P_0_2_5 WL_1_12 2.52502e-05f
C3431 P_0_2_5 WL_1_20 1.16084e-05f
C3432 P_0_2_5 WL_1_21 1.16084e-05f
C3433 P_0_2_5 WL_1_22 1.16084e-05f
C3434 P_0_2_5 WL_1_23 1.16084e-05f
C3435 P_0_2_5 WL_1_3 1.5245e-05f
C3436 P_0_2_5 WL_1_4 1.5245e-05f
C3437 P_0_2_5 XB_0_2_3 0.00304516f
C3438 P_0_2_5 XB_1_2_3 4.52454e-05f
C3439 P_0_2_5 net11_8 0.00323163f
C3440 P_0_2_5 net134 2.7754e-05f
C3441 P_0_2_5 net134_10 2.52822e-05f
C3442 P_0_2_5 net134_2 2.40783e-05f
C3443 P_0_2_5 net134_3 2.61372e-05f
C3444 P_0_2_5 net134_4 2.63291e-05f
C3445 P_0_2_5 net134_5 1.05154e-05f
C3446 P_0_2_5 net134_6 1.05154e-05f
C3447 P_0_2_5 net134_8 1.05154e-05f
C3448 P_0_2_5 net134_9 1.62703e-05f
C3449 P_0_2_5 net69 0.000516068f
C3450 P_0_2_5 net84_4 1.2406e-05f
C3451 P_0_3 VDD_1 0.000999079f
C3452 P_0_3 VSS_0 0.007647f
C3453 P_0_3 WL_0 7.20457e-05f
C3454 P_0_3 WL_0_1 0.000172916f
C3455 P_0_3 WL_0_10 0.000311823f
C3456 P_0_3 WL_0_11 0.000283476f
C3457 P_0_3 WL_0_12 0.000311823f
C3458 P_0_3 WL_0_2 0.000188266f
C3459 P_0_3 WL_0_3 0.000188266f
C3460 P_0_3 WL_0_4 0.000188266f
C3461 P_0_3 WL_0_9 0.000198433f
C3462 P_0_3 WL_1_10 1.65537e-05f
C3463 P_0_3 WL_1_11 1.50488e-05f
C3464 P_0_3 WL_1_9 1.05342e-05f
C3465 P_0_3 XB_0_3 0.00178221f
C3466 P_0_3 XB_1_3_3 2.8043e-05f
C3467 P_0_3 net11 1.27863e-05f
C3468 P_0_3 net11_2 1.10929e-05f
C3469 P_0_3 net11_3 1.20415e-05f
C3470 P_0_3 net11_4 1.21299e-05f
C3471 P_0_3 net13_7 1.80059e-05f
C3472 P_0_3 net14 0.00853142f
C3473 P_0_3 net14_11 0.00500139f
C3474 P_0_3 net14_3 0.00803441f
C3475 P_0_3 net14_4 0.00809341f
C3476 P_0_3 net14_6 0.00323236f
C3477 P_0_3 net70 0.000304731f
C3478 P_0_3_1 VDD_1 0.00214018f
C3479 P_0_3_1 VSS_0 0.0163811f
C3480 P_0_3_1 VSS_2 1.00593e-05f
C3481 P_0_3_1 XB_0_3 0.00381777f
C3482 P_0_3_1 XB_1_3_3 6.00725e-05f
C3483 P_0_3_1 net14_2 0.00740152f
C3484 P_0_3_1 net70 0.000652782f
C3485 P_0_3_1 net84_3 1.23098e-05f
C3486 P_0_3_1 net86_4 1.60432e-05f
C3487 P_0_3_2 VDD_1 0.00389347f
C3488 P_0_3_2 VSS_0 0.0298008f
C3489 P_0_3_2 VSS_2 1.83002e-05f
C3490 P_0_3_2 WL_0_16 0.000143357f
C3491 P_0_3_2 WL_0_17 0.000143357f
C3492 P_0_3_2 WL_0_18 0.000143357f
C3493 P_0_3_2 WL_0_19 0.000143357f
C3494 P_0_3_2 WL_0_20 0.000143357f
C3495 P_0_3_2 WL_0_21 0.000143357f
C3496 P_0_3_2 WL_0_22 0.000143357f
C3497 P_0_3_2 WL_0_23 0.000143357f
C3498 P_0_3_2 XB_0_2_1 1.4698e-05f
C3499 P_0_3_2 XB_0_3 0.00694538f
C3500 P_0_3_2 XB_1_3_3 0.000109285f
C3501 P_0_3_2 net11_9 1.16476e-05f
C3502 P_0_3_2 net13_4 1.18423e-05f
C3503 P_0_3_2 net14_5 0.00323236f
C3504 P_0_3_2 net14_9 0.0077716f
C3505 P_0_3_2 net70 0.00118755f
C3506 P_0_3_2 net84_3 2.23942e-05f
C3507 P_0_3_2 net86_4 2.91862e-05f
C3508 P_0_3_3 VDD_1 0.000431955f
C3509 P_0_3_3 VSS_0 0.0033062f
C3510 P_0_3_3 XB_0_3 0.000770544f
C3511 P_0_3_3 XB_1_3_3 1.21245e-05f
C3512 P_0_3_3 net14_7 0.00161618f
C3513 P_0_3_3 net70 0.000131751f
C3514 P_0_3_4 VDD_1 0.000870766f
C3515 P_0_3_4 VSS_0 0.00666488f
C3516 P_0_3_4 WL_0_13 0.000311823f
C3517 P_0_3_4 WL_0_14 0.000311823f
C3518 P_0_3_4 WL_0_15 0.000680342f
C3519 P_0_3_4 WL_0_24 0.000143357f
C3520 P_0_3_4 WL_0_25 0.000143357f
C3521 P_0_3_4 WL_0_26 0.000143357f
C3522 P_0_3_4 WL_0_27 0.000143357f
C3523 P_0_3_4 WL_0_28 0.000143357f
C3524 P_0_3_4 WL_0_29 0.000143357f
C3525 P_0_3_4 WL_0_30 0.000143357f
C3526 P_0_3_4 WL_0_31 0.000143357f
C3527 P_0_3_4 WL_0_5 0.000188266f
C3528 P_0_3_4 WL_0_6 0.000188266f
C3529 P_0_3_4 WL_0_7 0.000188266f
C3530 P_0_3_4 WL_0_8 0.000188266f
C3531 P_0_3_4 WL_1_14 1.65537e-05f
C3532 P_0_3_4 WL_1_15 3.61172e-05f
C3533 P_0_3_4 XB_0_3_2 0.00155332f
C3534 P_0_3_4 XB_1_3_3 2.44414e-05f
C3535 P_0_3_4 net16 1.3642e-05f
C3536 P_0_3_4 net16_2 1.777e-05f
C3537 P_0_3_4 net16_3 1.777e-05f
C3538 P_0_3_4 net16_4 3.02522e-05f
C3539 P_0_3_4 net16_6 1.28704e-05f
C3540 P_0_3_4 net16_7 4.59975e-05f
C3541 P_0_3_4 net17 3.30883e-05f
C3542 P_0_3_4 net17_11 1.93974e-05f
C3543 P_0_3_4 net17_2 2.87061e-05f
C3544 P_0_3_4 net17_3 3.11607e-05f
C3545 P_0_3_4 net17_4 3.13895e-05f
C3546 P_0_3_4 net17_5 1.25364e-05f
C3547 P_0_3_4 net17_6 1.25364e-05f
C3548 P_0_3_4 net17_8 1.25364e-05f
C3549 P_0_3_4 net17_9 3.01414e-05f
C3550 P_0_3_4 net70 0.000265594f
C3551 P_0_3_5 VDD_1 0.00171019f
C3552 P_0_3_5 VSS_0 0.0130899f
C3553 P_0_3_5 WL_1_12 1.65537e-05f
C3554 P_0_3_5 WL_1_13 1.65537e-05f
C3555 P_0_3_5 XB_0_3_3 0.00305072f
C3556 P_0_3_5 XB_1_3_3 4.8003e-05f
C3557 P_0_3_5 net135 4.35411e-05f
C3558 P_0_3_5 net135_10 3.96633e-05f
C3559 P_0_3_5 net135_2 3.77746e-05f
C3560 P_0_3_5 net135_3 4.10046e-05f
C3561 P_0_3_5 net135_4 4.13057e-05f
C3562 P_0_3_5 net135_5 1.64967e-05f
C3563 P_0_3_5 net135_6 1.64967e-05f
C3564 P_0_3_5 net135_8 1.64967e-05f
C3565 P_0_3_5 net135_9 2.55252e-05f
C3566 P_0_3_5 net14_8 0.00323236f
C3567 P_0_3_5 net70 0.000521628f
C3568 P_0_3_5 net86_4 1.28199e-05f
C3569 P_0_4 VDD_1 0.00102588f
C3570 P_0_4 VSS_0 0.00766038f
C3571 P_0_4 VSS_2 1.79475e-05f
C3572 P_0_4 WL_0 7.18023e-05f
C3573 P_0_4 WL_0_1 0.000172332f
C3574 P_0_4 WL_0_10 0.00031077f
C3575 P_0_4 WL_0_11 0.000282518f
C3576 P_0_4 WL_0_12 0.00031077f
C3577 P_0_4 WL_0_13 0.00031077f
C3578 P_0_4 WL_0_2 0.00018763f
C3579 P_0_4 WL_0_3 0.00018763f
C3580 P_0_4 WL_0_4 0.00018763f
C3581 P_0_4 WL_0_5 0.00018763f
C3582 P_0_4 WL_0_9 0.000197762f
C3583 P_0_4 WL_1_1 1.33327e-05f
C3584 P_0_4 WL_1_10 2.40432e-05f
C3585 P_0_4 WL_1_11 2.18575e-05f
C3586 P_0_4 WL_1_12 2.40432e-05f
C3587 P_0_4 WL_1_16 1.10535e-05f
C3588 P_0_4 WL_1_17 1.10535e-05f
C3589 P_0_4 WL_1_18 1.10535e-05f
C3590 P_0_4 WL_1_19 1.10535e-05f
C3591 P_0_4 WL_1_2 1.45163e-05f
C3592 P_0_4 WL_1_20 1.10535e-05f
C3593 P_0_4 WL_1_21 1.10535e-05f
C3594 P_0_4 WL_1_22 1.10535e-05f
C3595 P_0_4 WL_1_23 1.10535e-05f
C3596 P_0_4 WL_1_3 1.45163e-05f
C3597 P_0_4 WL_1_4 1.45163e-05f
C3598 P_0_4 WL_1_9 1.53002e-05f
C3599 P_0_4 XB_0_4 0.00177813f
C3600 P_0_4 XB_1_4_3 2.62495e-05f
C3601 P_0_4 net17 0.00852392f
C3602 P_0_4 net17_11 0.004997f
C3603 P_0_4 net17_3 0.00802735f
C3604 P_0_4 net17_4 0.00808629f
C3605 P_0_4 net17_6 0.00322952f
C3606 P_0_4 net71 0.000301785f
C3607 P_0_4_1 VDD_1 0.0021976f
C3608 P_0_4_1 VSS_0 0.0164097f
C3609 P_0_4_1 VSS_2 3.84463e-05f
C3610 P_0_4_1 XB_0_3_2 1.02705e-05f
C3611 P_0_4_1 XB_0_4 0.00380904f
C3612 P_0_4_1 XB_1_3_3 1.3703e-05f
C3613 P_0_4_1 XB_1_4_3 5.62305e-05f
C3614 P_0_4_1 net17_2 0.00739502f
C3615 P_0_4_1 net71 0.000646471f
C3616 P_0_4_1 net88_4 1.42885e-05f
C3617 P_0_4_2 VDD_1 0.00399793f
C3618 P_0_4_2 VSS_0 0.029853f
C3619 P_0_4_2 VSS_2 6.99423e-05f
C3620 P_0_4_2 WL_0_16 0.000142872f
C3621 P_0_4_2 WL_0_17 0.000142872f
C3622 P_0_4_2 WL_0_18 0.000142872f
C3623 P_0_4_2 WL_0_19 0.000142872f
C3624 P_0_4_2 WL_0_20 0.000142872f
C3625 P_0_4_2 WL_0_21 0.000142872f
C3626 P_0_4_2 WL_0_22 0.000142872f
C3627 P_0_4_2 WL_0_23 0.000142872f
C3628 P_0_4_2 WL_0_24 0.000142872f
C3629 P_0_4_2 WL_0_25 0.000142872f
C3630 P_0_4_2 XB_0_3_1 1.86843e-05f
C3631 P_0_4_2 XB_0_4 0.00692949f
C3632 P_0_4_2 XB_1_3_3 2.49289e-05f
C3633 P_0_4_2 XB_1_4_3 0.000102296f
C3634 P_0_4_2 net17_5 0.00322952f
C3635 P_0_4_2 net17_9 0.00776477f
C3636 P_0_4_2 net71 0.00117607f
C3637 P_0_4_2 net88_4 2.5994e-05f
C3638 P_0_4_3 VDD_1 0.000443543f
C3639 P_0_4_3 VSS_0 0.00331199f
C3640 P_0_4_3 XB_0_4 0.000768781f
C3641 P_0_4_3 XB_1_4_3 1.1349e-05f
C3642 P_0_4_3 net17_7 0.00161476f
C3643 P_0_4_3 net71 0.000130478f
C3644 P_0_4_4 VDD_1 0.000894127f
C3645 P_0_4_4 VSS_0 0.00667655f
C3646 P_0_4_4 VSS_2 1.56424e-05f
C3647 P_0_4_4 WL_0_14 0.00031077f
C3648 P_0_4_4 WL_0_15 0.000678043f
C3649 P_0_4_4 WL_0_26 0.000142872f
C3650 P_0_4_4 WL_0_27 0.000142872f
C3651 P_0_4_4 WL_0_28 0.000142872f
C3652 P_0_4_4 WL_0_29 0.000142872f
C3653 P_0_4_4 WL_0_30 0.000142872f
C3654 P_0_4_4 WL_0_31 0.000142872f
C3655 P_0_4_4 WL_0_6 0.00018763f
C3656 P_0_4_4 WL_0_7 0.00018763f
C3657 P_0_4_4 WL_0_8 0.00018763f
C3658 P_0_4_4 WL_1_15 5.24579e-05f
C3659 P_0_4_4 WL_1_28 1.10535e-05f
C3660 P_0_4_4 WL_1_29 1.10535e-05f
C3661 P_0_4_4 WL_1_30 1.10535e-05f
C3662 P_0_4_4 WL_1_31 1.10535e-05f
C3663 P_0_4_4 WL_1_7 1.45163e-05f
C3664 P_0_4_4 WL_1_8 1.45163e-05f
C3665 P_0_4_4 XB_0_4_2 0.00154976f
C3666 P_0_4_4 XB_1_4_3 2.28782e-05f
C3667 P_0_4_4 net19 1.20488e-05f
C3668 P_0_4_4 net19_2 1.56947e-05f
C3669 P_0_4_4 net19_3 1.56947e-05f
C3670 P_0_4_4 net19_4 2.67192e-05f
C3671 P_0_4_4 net19_6 1.13674e-05f
C3672 P_0_4_4 net19_7 4.06257e-05f
C3673 P_0_4_4 net20 4.19497e-05f
C3674 P_0_4_4 net20_11 2.45923e-05f
C3675 P_0_4_4 net20_2 3.63939e-05f
C3676 P_0_4_4 net20_3 3.95059e-05f
C3677 P_0_4_4 net20_4 3.9796e-05f
C3678 P_0_4_4 net20_5 1.58938e-05f
C3679 P_0_4_4 net20_6 1.58938e-05f
C3680 P_0_4_4 net20_8 1.58938e-05f
C3681 P_0_4_4 net20_9 3.82136e-05f
C3682 P_0_4_4 net71 0.000263026f
C3683 P_0_4_5 VDD_1 0.00175607f
C3684 P_0_4_5 VSS_0 0.0131128f
C3685 P_0_4_5 VSS_2 3.07218e-05f
C3686 P_0_4_5 WL_1_13 2.40432e-05f
C3687 P_0_4_5 WL_1_14 2.40432e-05f
C3688 P_0_4_5 WL_1_24 1.10535e-05f
C3689 P_0_4_5 WL_1_25 1.10535e-05f
C3690 P_0_4_5 WL_1_26 1.10535e-05f
C3691 P_0_4_5 WL_1_27 1.10535e-05f
C3692 P_0_4_5 WL_1_5 1.45163e-05f
C3693 P_0_4_5 WL_1_6 1.45163e-05f
C3694 P_0_4_5 XB_0_4_3 0.00304374f
C3695 P_0_4_5 XB_1_3_3 1.09499e-05f
C3696 P_0_4_5 XB_1_4_3 4.49329e-05f
C3697 P_0_4_5 net137 2.98411e-05f
C3698 P_0_4_5 net137_10 2.71834e-05f
C3699 P_0_4_5 net137_2 2.5889e-05f
C3700 P_0_4_5 net137_3 2.81027e-05f
C3701 P_0_4_5 net137_4 2.8309e-05f
C3702 P_0_4_5 net137_5 1.13061e-05f
C3703 P_0_4_5 net137_6 1.13061e-05f
C3704 P_0_4_5 net137_8 1.13061e-05f
C3705 P_0_4_5 net137_9 1.74938e-05f
C3706 P_0_4_5 net17_8 0.00322952f
C3707 P_0_4_5 net71 0.000516585f
C3708 P_0_4_5 net88_4 1.14177e-05f
C3709 P_0_5 VDD_1 0.000999394f
C3710 P_0_5 VSS_0 0.00765515f
C3711 P_0_5 WL_0 7.36143e-05f
C3712 P_0_5 WL_0_1 0.000176681f
C3713 P_0_5 WL_0_10 0.000318612f
C3714 P_0_5 WL_0_11 0.000289648f
C3715 P_0_5 WL_0_12 0.000318612f
C3716 P_0_5 WL_0_13 0.000318612f
C3717 P_0_5 WL_0_14 0.000318612f
C3718 P_0_5 WL_0_2 0.000192365f
C3719 P_0_5 WL_0_3 0.000192365f
C3720 P_0_5 WL_0_4 0.000192365f
C3721 P_0_5 WL_0_5 0.000192365f
C3722 P_0_5 WL_0_6 0.000192365f
C3723 P_0_5 WL_0_9 0.000202753f
C3724 P_0_5 WL_1_10 1.53922e-05f
C3725 P_0_5 WL_1_11 1.39929e-05f
C3726 P_0_5 WL_1_12 1.53922e-05f
C3727 P_0_5 WL_1_13 1.53922e-05f
C3728 P_0_5 XB_0_5 0.00178486f
C3729 P_0_5 XB_1_5_3 2.95015e-05f
C3730 P_0_5 net19_3 1.15954e-05f
C3731 P_0_5 net19_7 3.00148e-05f
C3732 P_0_5 net20 0.00853162f
C3733 P_0_5 net20_11 0.00500151f
C3734 P_0_5 net20_3 0.0080346f
C3735 P_0_5 net20_4 0.0080936f
C3736 P_0_5 net20_6 0.00323243f
C3737 P_0_5 net72 0.000305453f
C3738 P_0_5_1 VDD_1 0.00214086f
C3739 P_0_5_1 VSS_0 0.0163985f
C3740 P_0_5_1 VSS_2 1.33561e-05f
C3741 P_0_5_1 XB_0_4_2 1.24505e-05f
C3742 P_0_5_1 XB_0_5 0.00382344f
C3743 P_0_5_1 XB_1_5_3 6.31968e-05f
C3744 P_0_5_1 net20_2 0.0074017f
C3745 P_0_5_1 net72 0.000654327f
C3746 P_0_5_1 net88_3 1.32754e-05f
C3747 P_0_5_1 net91_4 1.95997e-05f
C3748 P_0_5_2 VDD_1 0.0038947f
C3749 P_0_5_2 VSS_0 0.0298326f
C3750 P_0_5_2 VSS_2 2.42977e-05f
C3751 P_0_5_2 WL_0_16 0.000146478f
C3752 P_0_5_2 WL_0_17 0.000146478f
C3753 P_0_5_2 WL_0_18 0.000146478f
C3754 P_0_5_2 WL_0_19 0.000146478f
C3755 P_0_5_2 WL_0_20 0.000146478f
C3756 P_0_5_2 WL_0_21 0.000146478f
C3757 P_0_5_2 WL_0_22 0.000146478f
C3758 P_0_5_2 WL_0_23 0.000146478f
C3759 P_0_5_2 WL_0_24 0.000146478f
C3760 P_0_5_2 WL_0_25 0.000146478f
C3761 P_0_5_2 WL_0_26 0.000146478f
C3762 P_0_5_2 WL_0_27 0.000146478f
C3763 P_0_5_2 XB_0_4_1 2.26503e-05f
C3764 P_0_5_2 XB_0_5 0.00695569f
C3765 P_0_5_2 XB_1_5_3 0.000114969f
C3766 P_0_5_2 net19_2 1.15954e-05f
C3767 P_0_5_2 net19_4 1.97405e-05f
C3768 P_0_5_2 net20_5 0.00323243f
C3769 P_0_5_2 net20_9 0.00777179f
C3770 P_0_5_2 net72 0.00119037f
C3771 P_0_5_2 net88_3 2.4151e-05f
C3772 P_0_5_2 net91_4 3.56561e-05f
C3773 P_0_5_3 VDD_1 0.000432091f
C3774 P_0_5_3 VSS_0 0.00330973f
C3775 P_0_5_3 XB_0_5 0.000771688f
C3776 P_0_5_3 XB_1_5_3 1.27551e-05f
C3777 P_0_5_3 net20_7 0.00161622f
C3778 P_0_5_3 net72 0.000132063f
C3779 P_0_5_4 VDD_1 0.000871041f
C3780 P_0_5_4 VSS_0 0.00667199f
C3781 P_0_5_4 WL_0_15 0.000695154f
C3782 P_0_5_4 WL_0_28 0.000146478f
C3783 P_0_5_4 WL_0_29 0.000146478f
C3784 P_0_5_4 WL_0_30 0.000146478f
C3785 P_0_5_4 WL_0_31 0.000146478f
C3786 P_0_5_4 WL_0_7 0.000192365f
C3787 P_0_5_4 WL_0_8 0.000192365f
C3788 P_0_5_4 XB_0_5_2 0.00155562f
C3789 P_0_5_4 XB_1_5_3 2.57126e-05f
C3790 P_0_5_4 net23 1.31426e-05f
C3791 P_0_5_4 net23_2 1.71194e-05f
C3792 P_0_5_4 net23_3 1.71194e-05f
C3793 P_0_5_4 net23_4 2.91447e-05f
C3794 P_0_5_4 net23_6 1.23993e-05f
C3795 P_0_5_4 net23_7 4.43136e-05f
C3796 P_0_5_4 net24 3.64468e-05f
C3797 P_0_5_4 net24_11 2.13663e-05f
C3798 P_0_5_4 net24_2 3.16198e-05f
C3799 P_0_5_4 net24_3 3.43236e-05f
C3800 P_0_5_4 net24_4 3.45756e-05f
C3801 P_0_5_4 net24_5 1.38089e-05f
C3802 P_0_5_4 net24_6 1.38089e-05f
C3803 P_0_5_4 net24_8 1.38089e-05f
C3804 P_0_5_4 net24_9 3.32008e-05f
C3805 P_0_5_4 net72 0.000266223f
C3806 P_0_5_5 VDD_1 0.00171073f
C3807 P_0_5_5 VSS_0 0.0131038f
C3808 P_0_5_5 VSS_2 1.06726e-05f
C3809 P_0_5_5 WL_1_14 1.53922e-05f
C3810 P_0_5_5 WL_1_15 3.35829e-05f
C3811 P_0_5_5 XB_0_5_3 0.00305525f
C3812 P_0_5_5 XB_1_5_3 5.04996e-05f
C3813 P_0_5_5 net139 4.35069e-05f
C3814 P_0_5_5 net139_10 3.96321e-05f
C3815 P_0_5_5 net139_2 3.77448e-05f
C3816 P_0_5_5 net139_3 4.09723e-05f
C3817 P_0_5_5 net139_4 4.12732e-05f
C3818 P_0_5_5 net139_5 1.64837e-05f
C3819 P_0_5_5 net139_6 1.64837e-05f
C3820 P_0_5_5 net139_8 1.64837e-05f
C3821 P_0_5_5 net139_9 2.55051e-05f
C3822 P_0_5_5 net20_8 0.00323243f
C3823 P_0_5_5 net72 0.000522863f
C3824 P_0_5_5 net88_3 1.06082e-05f
C3825 P_0_5_5 net91_4 1.56618e-05f
C3826 P_0_6 VDD_1 0.00103562f
C3827 P_0_6 VSS_0 0.00767849f
C3828 P_0_6 VSS_2 2.00595e-05f
C3829 P_0_6 WL_0 7.25331e-05f
C3830 P_0_6 WL_0_1 0.000174085f
C3831 P_0_6 WL_0_10 0.000313933f
C3832 P_0_6 WL_0_11 0.000285393f
C3833 P_0_6 WL_0_12 0.000313933f
C3834 P_0_6 WL_0_13 0.000313933f
C3835 P_0_6 WL_0_14 0.000313933f
C3836 P_0_6 WL_0_15 0.000684944f
C3837 P_0_6 WL_0_2 0.00018954f
C3838 P_0_6 WL_0_3 0.00018954f
C3839 P_0_6 WL_0_4 0.00018954f
C3840 P_0_6 WL_0_5 0.00018954f
C3841 P_0_6 WL_0_6 0.00018954f
C3842 P_0_6 WL_0_7 0.00018954f
C3843 P_0_6 WL_0_9 0.000199775f
C3844 P_0_6 WL_1_1 1.50178e-05f
C3845 P_0_6 WL_1_10 2.7082e-05f
C3846 P_0_6 WL_1_11 2.462e-05f
C3847 P_0_6 WL_1_12 2.7082e-05f
C3848 P_0_6 WL_1_13 2.7082e-05f
C3849 P_0_6 WL_1_14 2.7082e-05f
C3850 P_0_6 WL_1_16 1.24506e-05f
C3851 P_0_6 WL_1_17 1.24506e-05f
C3852 P_0_6 WL_1_18 1.24506e-05f
C3853 P_0_6 WL_1_19 1.24506e-05f
C3854 P_0_6 WL_1_2 1.6351e-05f
C3855 P_0_6 WL_1_20 1.24506e-05f
C3856 P_0_6 WL_1_21 1.24506e-05f
C3857 P_0_6 WL_1_22 1.24506e-05f
C3858 P_0_6 WL_1_23 1.24506e-05f
C3859 P_0_6 WL_1_24 1.24506e-05f
C3860 P_0_6 WL_1_25 1.24506e-05f
C3861 P_0_6 WL_1_26 1.24506e-05f
C3862 P_0_6 WL_1_27 1.24506e-05f
C3863 P_0_6 WL_1_3 1.6351e-05f
C3864 P_0_6 WL_1_4 1.6351e-05f
C3865 P_0_6 WL_1_5 1.6351e-05f
C3866 P_0_6 WL_1_6 1.6351e-05f
C3867 P_0_6 WL_1_9 1.7234e-05f
C3868 P_0_6 XB_0_6 0.0017963f
C3869 P_0_6 XB_1_6_3 2.59033e-05f
C3870 P_0_6 net24 0.00852496f
C3871 P_0_6 net24_11 0.00499761f
C3872 P_0_6 net24_3 0.00802833f
C3873 P_0_6 net24_4 0.00808728f
C3874 P_0_6 net24_6 0.00322991f
C3875 P_0_6 net73 0.000310585f
C3876 P_0_6_1 VDD_1 0.00221847f
C3877 P_0_6_1 VSS_0 0.0164485f
C3878 P_0_6_1 VSS_2 4.29706e-05f
C3879 P_0_6_1 XB_0_5_2 1.34249e-05f
C3880 P_0_6_1 XB_0_6 0.00384796f
C3881 P_0_6_1 XB_1_5_3 1.10946e-05f
C3882 P_0_6_1 XB_1_6_3 5.54889e-05f
C3883 P_0_6_1 net24_2 0.00739592f
C3884 P_0_6_1 net73 0.000665321f
C3885 P_0_6_2 VDD_1 0.00403589f
C3886 P_0_6_2 VSS_0 0.0299235f
C3887 P_0_6_2 VSS_2 7.8173e-05f
C3888 P_0_6_2 WL_0_16 0.000144326f
C3889 P_0_6_2 WL_0_17 0.000144326f
C3890 P_0_6_2 WL_0_18 0.000144326f
C3891 P_0_6_2 WL_0_19 0.000144326f
C3892 P_0_6_2 WL_0_20 0.000144326f
C3893 P_0_6_2 WL_0_21 0.000144326f
C3894 P_0_6_2 WL_0_22 0.000144326f
C3895 P_0_6_2 WL_0_23 0.000144326f
C3896 P_0_6_2 WL_0_24 0.000144326f
C3897 P_0_6_2 WL_0_25 0.000144326f
C3898 P_0_6_2 WL_0_26 0.000144326f
C3899 P_0_6_2 WL_0_27 0.000144326f
C3900 P_0_6_2 WL_0_28 0.000144326f
C3901 P_0_6_2 WL_0_29 0.000144326f
C3902 P_0_6_2 XB_0_5_1 2.44229e-05f
C3903 P_0_6_2 XB_0_6 0.0070003f
C3904 P_0_6_2 XB_1_5_3 2.01836e-05f
C3905 P_0_6_2 XB_1_6_3 0.000100947f
C3906 P_0_6_2 net24_5 0.00322991f
C3907 P_0_6_2 net24_9 0.00776572f
C3908 P_0_6_2 net73 0.00121037f
C3909 P_0_6_3 VDD_1 0.000447755f
C3910 P_0_6_3 VSS_0 0.00331982f
C3911 P_0_6_3 XB_0_6 0.000776637f
C3912 P_0_6_3 XB_1_6_3 1.11994e-05f
C3913 P_0_6_3 net24_7 0.00161495f
C3914 P_0_6_3 net73 0.000134282f
C3915 P_0_6_4 VDD_1 0.000902618f
C3916 P_0_6_4 VSS_0 0.00669233f
C3917 P_0_6_4 VSS_2 1.74832e-05f
C3918 P_0_6_4 WL_0_30 0.000144326f
C3919 P_0_6_4 WL_0_31 0.000144326f
C3920 P_0_6_4 WL_0_8 0.00018954f
C3921 P_0_6_4 XB_0_6_2 0.0015656f
C3922 P_0_6_4 XB_1_6_3 2.25765e-05f
C3923 P_0_6_4 net27_2 1.00724e-05f
C3924 P_0_6_4 net27_3 1.00724e-05f
C3925 P_0_6_4 net27_4 1.71476e-05f
C3926 P_0_6_4 net27_7 2.60723e-05f
C3927 P_0_6_4 net28 4.12722e-05f
C3928 P_0_6_4 net28_11 2.41951e-05f
C3929 P_0_6_4 net28_2 3.58061e-05f
C3930 P_0_6_4 net28_3 3.88678e-05f
C3931 P_0_6_4 net28_4 3.91532e-05f
C3932 P_0_6_4 net28_5 1.56371e-05f
C3933 P_0_6_4 net28_6 1.56371e-05f
C3934 P_0_6_4 net28_8 1.56371e-05f
C3935 P_0_6_4 net28_9 3.75964e-05f
C3936 P_0_6_4 net73 0.000270696f
C3937 P_0_6_5 VDD_1 0.00177274f
C3938 P_0_6_5 VSS_0 0.0131438f
C3939 P_0_6_5 VSS_2 3.43371e-05f
C3940 P_0_6_5 WL_1_15 5.9088e-05f
C3941 P_0_6_5 WL_1_28 1.24506e-05f
C3942 P_0_6_5 WL_1_29 1.24506e-05f
C3943 P_0_6_5 WL_1_30 1.24506e-05f
C3944 P_0_6_5 WL_1_31 1.24506e-05f
C3945 P_0_6_5 WL_1_7 1.6351e-05f
C3946 P_0_6_5 WL_1_8 1.6351e-05f
C3947 P_0_6_5 XB_0_5_3 1.07276e-05f
C3948 P_0_6_5 XB_0_6_3 0.00307485f
C3949 P_0_6_5 XB_1_6_3 4.43403e-05f
C3950 P_0_6_5 net141 2.06791e-05f
C3951 P_0_6_5 net141_10 1.88374e-05f
C3952 P_0_6_5 net141_2 1.79404e-05f
C3953 P_0_6_5 net141_3 1.94744e-05f
C3954 P_0_6_5 net141_4 1.96174e-05f
C3955 P_0_6_5 net141_9 1.21228e-05f
C3956 P_0_6_5 net24_8 0.00322991f
C3957 P_0_6_5 net73 0.000531648f
C3958 P_0_7 VDD_1 0.00101606f
C3959 P_0_7 VSS_0 0.00774973f
C3960 P_0_7 WL_0 7.03487e-05f
C3961 P_0_7 WL_0_1 0.000168843f
C3962 P_0_7 WL_0_10 0.000304478f
C3963 P_0_7 WL_0_11 0.000276798f
C3964 P_0_7 WL_0_12 0.000304478f
C3965 P_0_7 WL_0_13 0.000304478f
C3966 P_0_7 WL_0_14 0.000304478f
C3967 P_0_7 WL_0_15 0.000664316f
C3968 P_0_7 WL_0_2 0.000183832f
C3969 P_0_7 WL_0_3 0.000183832f
C3970 P_0_7 WL_0_4 0.000183832f
C3971 P_0_7 WL_0_5 0.000183832f
C3972 P_0_7 WL_0_6 0.000183832f
C3973 P_0_7 WL_0_7 0.000183832f
C3974 P_0_7 WL_0_8 0.000183832f
C3975 P_0_7 WL_0_9 0.000193759f
C3976 P_0_7 XB_0_7 0.00177392f
C3977 P_0_7 XB_1_7_3 2.57813e-05f
C3978 P_0_7 net27_7 1.769e-05f
C3979 P_0_7 net28 0.00847635f
C3980 P_0_7 net28_11 0.00496911f
C3981 P_0_7 net28_3 0.00798255f
C3982 P_0_7 net28_4 0.00804117f
C3983 P_0_7 net28_6 0.00321149f
C3984 P_0_7 net74 0.000308148f
C3985 P_0_7 net94_3 1.28704e-05f
C3986 P_0_7_1 VDD_1 0.00217655f
C3987 P_0_7_1 VSS_0 0.0166011f
C3988 P_0_7_1 XB_0_7 0.00380002f
C3989 P_0_7_1 XB_1_7_3 5.52276e-05f
C3990 P_0_7_1 net28_2 0.00735375f
C3991 P_0_7_1 net74 0.000660101f
C3992 P_0_7_1 net94_3 2.75704e-05f
C3993 P_0_7_2 VDD_1 0.00395963f
C3994 P_0_7_2 VSS_0 0.0302012f
C3995 P_0_7_2 WL_0_16 0.00013998f
C3996 P_0_7_2 WL_0_17 0.00013998f
C3997 P_0_7_2 WL_0_18 0.00013998f
C3998 P_0_7_2 WL_0_19 0.00013998f
C3999 P_0_7_2 WL_0_20 0.00013998f
C4000 P_0_7_2 WL_0_21 0.00013998f
C4001 P_0_7_2 WL_0_22 0.00013998f
C4002 P_0_7_2 WL_0_23 0.00013998f
C4003 P_0_7_2 WL_0_24 0.00013998f
C4004 P_0_7_2 WL_0_25 0.00013998f
C4005 P_0_7_2 WL_0_26 0.00013998f
C4006 P_0_7_2 WL_0_27 0.00013998f
C4007 P_0_7_2 WL_0_28 0.00013998f
C4008 P_0_7_2 WL_0_29 0.00013998f
C4009 P_0_7_2 WL_0_30 0.00013998f
C4010 P_0_7_2 WL_0_31 0.00013998f
C4011 P_0_7_2 XB_0_7 0.00691307f
C4012 P_0_7_2 XB_1_7_3 0.000100471f
C4013 P_0_7_2 net27_4 1.16346e-05f
C4014 P_0_7_2 net28_5 0.00321149f
C4015 P_0_7_2 net28_9 0.00772144f
C4016 P_0_7_2 net74 0.00120087f
C4017 P_0_7_2 net94_3 5.01567e-05f
C4018 P_0_7_3 VDD_1 0.000439295f
C4019 P_0_7_3 VSS_0 0.00335062f
C4020 P_0_7_3 XB_0_7 0.00076696f
C4021 P_0_7_3 XB_1_7_3 1.11466e-05f
C4022 P_0_7_3 net28_7 0.00160575f
C4023 P_0_7_3 net74 0.000133229f
C4024 P_0_7_4 VDD_1 0.000885563f
C4025 P_0_7_4 VSS_0 0.00675442f
C4026 P_0_7_4 XB_0_7_2 0.00154609f
C4027 P_0_7_4 XB_1_7_3 2.24702e-05f
C4028 P_0_7_4 net74 0.000268572f
C4029 P_0_7_4 net94_3 1.12174e-05f
C4030 P_0_7_5 VDD_1 0.00173925f
C4031 P_0_7_5 VSS_0 0.0132657f
C4032 P_0_7_5 XB_0_7_3 0.00303654f
C4033 P_0_7_5 XB_1_7_3 4.41315e-05f
C4034 P_0_7_5 net142 6.13949e-05f
C4035 P_0_7_5 net142_10 5.5927e-05f
C4036 P_0_7_5 net142_2 5.32638e-05f
C4037 P_0_7_5 net142_3 5.78182e-05f
C4038 P_0_7_5 net142_4 5.82428e-05f
C4039 P_0_7_5 net142_5 2.32611e-05f
C4040 P_0_7_5 net142_6 2.32611e-05f
C4041 P_0_7_5 net142_7 1.16305e-05f
C4042 P_0_7_5 net142_8 2.32611e-05f
C4043 P_0_7_5 net142_9 3.59916e-05f
C4044 P_0_7_5 net28_8 0.00321149f
C4045 P_0_7_5 net74 0.000527476f
C4046 P_0_7_5 net94_3 2.20311e-05f
C4047 P_1_0 VDD_1 0.00101591f
C4048 P_1_0 VSS_0 0.00478195f
C4049 P_1_0 VSS_2 0.0029719f
C4050 P_1_0 WL_1 7.45788e-05f
C4051 P_1_0 WL_1_1 0.000178995f
C4052 P_1_0 WL_1_9 0.00020541f
C4053 P_1_0 XB_0_0_3 1.42664e-05f
C4054 P_1_0 XB_1_0 0.00183542f
C4055 P_1_0 net130 0.00859122f
C4056 P_1_0 net130_3 0.00809072f
C4057 P_1_0 net130_4 0.00815014f
C4058 P_1_0 net130_6 0.00325501f
C4059 P_1_0 net130_9 0.00503645f
C4060 P_1_0 net76_7 1.45591e-05f
C4061 P_1_0 net78 0.000276409f
C4062 P_1_0_1 VDD_1 0.00217623f
C4063 P_1_0_1 VSS_0 0.0102437f
C4064 P_1_0_1 VSS_2 0.00636628f
C4065 P_1_0_1 XB_0_0_3 3.05609e-05f
C4066 P_1_0_1 XB_1_0 0.00393176f
C4067 P_1_0_1 net130_2 0.0074534f
C4068 P_1_0_1 net78 0.000592112f
C4069 P_1_0_2 VDD_1 0.00395905f
C4070 P_1_0_2 VSS_0 0.0186355f
C4071 P_1_0_2 VSS_2 0.0115817f
C4072 P_1_0_2 WL_1_16 0.000148397f
C4073 P_1_0_2 WL_1_17 0.000148397f
C4074 P_1_0_2 XB_0_0_3 5.55971e-05f
C4075 P_1_0_2 XB_1_0 0.00715275f
C4076 P_1_0_2 net130_10 0.00782607f
C4077 P_1_0_2 net130_5 0.00325501f
C4078 P_1_0_2 net78 0.00107718f
C4079 P_1_0_3 VDD_1 0.00173899f
C4080 P_1_0_3 VSS_0 0.00818557f
C4081 P_1_0_3 VSS_2 0.0050872f
C4082 P_1_0_3 WL_0_1 1.07035e-05f
C4083 P_1_0_3 WL_0_10 1.93019e-05f
C4084 P_1_0_3 WL_0_2 1.16537e-05f
C4085 P_1_0_3 WL_0_9 1.2283e-05f
C4086 P_1_0_3 XB_0_0_3 2.44208e-05f
C4087 P_1_0_3 XB_1_0_3 0.00314181f
C4088 P_1_0_3 net130_8 0.00325501f
C4089 P_1_0_3 net3 1.33274e-05f
C4090 P_1_0_3 net3_2 1.15624e-05f
C4091 P_1_0_3 net3_3 1.2551e-05f
C4092 P_1_0_3 net3_4 1.26432e-05f
C4093 P_1_0_3 net3_9 1.21405e-05f
C4094 P_1_0_3 net78 0.000473148f
C4095 P_1_0_4 VDD_1 0.000439231f
C4096 P_1_0_4 VSS_0 0.00206749f
C4097 P_1_0_4 VSS_2 0.00128491f
C4098 P_1_0_4 XB_1_0 0.000793551f
C4099 P_1_0_4 net130_7 0.00162751f
C4100 P_1_0_4 net78 0.000119506f
C4101 P_1_0_5 VDD_1 0.000885433f
C4102 P_1_0_5 VSS_0 0.00416779f
C4103 P_1_0_5 VSS_2 0.00259022f
C4104 P_1_0_5 WL_0_11 1.75472e-05f
C4105 P_1_0_5 WL_0_12 1.93019e-05f
C4106 P_1_0_5 WL_0_13 1.93019e-05f
C4107 P_1_0_5 WL_0_14 1.93019e-05f
C4108 P_1_0_5 WL_0_15 4.21132e-05f
C4109 P_1_0_5 WL_0_3 1.16537e-05f
C4110 P_1_0_5 WL_0_4 1.16537e-05f
C4111 P_1_0_5 WL_0_5 1.16537e-05f
C4112 P_1_0_5 WL_0_6 1.16537e-05f
C4113 P_1_0_5 WL_0_7 1.16537e-05f
C4114 P_1_0_5 WL_0_8 1.16537e-05f
C4115 P_1_0_5 WL_1_10 0.000322787f
C4116 P_1_0_5 WL_1_11 0.000293443f
C4117 P_1_0_5 WL_1_12 0.000322787f
C4118 P_1_0_5 WL_1_13 0.000322787f
C4119 P_1_0_5 WL_1_14 0.000322787f
C4120 P_1_0_5 WL_1_15 0.000704262f
C4121 P_1_0_5 WL_1_18 0.000148397f
C4122 P_1_0_5 WL_1_19 0.000148397f
C4123 P_1_0_5 WL_1_2 0.000194886f
C4124 P_1_0_5 WL_1_20 0.000148397f
C4125 P_1_0_5 WL_1_21 0.000148397f
C4126 P_1_0_5 WL_1_22 0.000148397f
C4127 P_1_0_5 WL_1_23 0.000148397f
C4128 P_1_0_5 WL_1_24 0.000148397f
C4129 P_1_0_5 WL_1_25 0.000148397f
C4130 P_1_0_5 WL_1_26 0.000148397f
C4131 P_1_0_5 WL_1_27 0.000148397f
C4132 P_1_0_5 WL_1_28 0.000148397f
C4133 P_1_0_5 WL_1_29 0.000148397f
C4134 P_1_0_5 WL_1_3 0.000194886f
C4135 P_1_0_5 WL_1_30 0.000148397f
C4136 P_1_0_5 WL_1_31 0.000148397f
C4137 P_1_0_5 WL_1_4 0.000194886f
C4138 P_1_0_5 WL_1_5 0.000194886f
C4139 P_1_0_5 WL_1_6 0.000194886f
C4140 P_1_0_5 WL_1_7 0.000194886f
C4141 P_1_0_5 WL_1_8 0.000194886f
C4142 P_1_0_5 XB_0_0_3 1.24342e-05f
C4143 P_1_0_5 XB_1_0_2 0.0015997f
C4144 P_1_0_5 net132 3.18492e-05f
C4145 P_1_0_5 net132_10 2.90126e-05f
C4146 P_1_0_5 net132_2 2.76311e-05f
C4147 P_1_0_5 net132_3 2.99937e-05f
C4148 P_1_0_5 net132_4 3.0214e-05f
C4149 P_1_0_5 net132_5 1.20669e-05f
C4150 P_1_0_5 net132_6 1.20669e-05f
C4151 P_1_0_5 net132_8 1.20669e-05f
C4152 P_1_0_5 net132_9 1.8671e-05f
C4153 P_1_0_5 net78 0.00024091f
C4154 P_1_1 VDD_1 0.00097705f
C4155 P_1_1 VSS_0 0.00479812f
C4156 P_1_1 VSS_2 0.00297275f
C4157 P_1_1 WL_1 7.29888e-05f
C4158 P_1_1 WL_1_1 0.000175179f
C4159 P_1_1 WL_1_10 0.000315905f
C4160 P_1_1 WL_1_2 0.000190731f
C4161 P_1_1 WL_1_9 0.000201031f
C4162 P_1_1 XB_0_1_3 1.86226e-05f
C4163 P_1_1 XB_1_1 0.00182255f
C4164 P_1_1 net130 1.47575e-05f
C4165 P_1_1 net130_2 1.2803e-05f
C4166 P_1_1 net130_3 1.38978e-05f
C4167 P_1_1 net130_4 1.39999e-05f
C4168 P_1_1 net132 0.00855143f
C4169 P_1_1 net132_3 0.00805325f
C4170 P_1_1 net132_4 0.00811239f
C4171 P_1_1 net132_6 0.00323994f
C4172 P_1_1 net132_9 0.00501312f
C4173 P_1_1 net79_7 1.47601e-05f
C4174 P_1_1 net80 0.000289839f
C4175 P_1_1_1 VDD_1 0.00209299f
C4176 P_1_1_1 VSS_0 0.0102783f
C4177 P_1_1_1 VSS_2 0.00636809f
C4178 P_1_1_1 XB_0_1_3 3.98924e-05f
C4179 P_1_1_1 XB_1_1 0.00390419f
C4180 P_1_1_1 net132_2 0.00741889f
C4181 P_1_1_1 net80 0.00062088f
C4182 P_1_1_2 VDD_1 0.00380762f
C4183 P_1_1_2 VSS_0 0.0186985f
C4184 P_1_1_2 VSS_2 0.011585f
C4185 P_1_1_2 WL_1_16 0.000145233f
C4186 P_1_1_2 WL_1_17 0.000145233f
C4187 P_1_1_2 WL_1_18 0.000145233f
C4188 P_1_1_2 WL_1_19 0.000145233f
C4189 P_1_1_2 XB_0_0_3 1.29716e-05f
C4190 P_1_1_2 XB_0_1_3 7.25732e-05f
C4191 P_1_1_2 XB_1_1 0.00710258f
C4192 P_1_1_2 XB_1_6 1.15017e-05f
C4193 P_1_1_2 net130_10 1.34432e-05f
C4194 P_1_1_2 net132_10 0.00778983f
C4195 P_1_1_2 net132_5 0.00323994f
C4196 P_1_1_2 net80 0.00112952f
C4197 P_1_1_3 VDD_1 0.00167248f
C4198 P_1_1_3 VSS_0 0.00821325f
C4199 P_1_1_3 VSS_2 0.00508865f
C4200 P_1_1_3 WL_0_10 1.0669e-05f
C4201 P_1_1_3 XB_0_1_3 3.18774e-05f
C4202 P_1_1_3 XB_1_1_3 0.00311977f
C4203 P_1_1_3 net10_2 1.15071e-05f
C4204 P_1_1_3 net10_3 1.15071e-05f
C4205 P_1_1_3 net10_4 1.95901e-05f
C4206 P_1_1_3 net10_7 2.97861e-05f
C4207 P_1_1_3 net132_8 0.00323994f
C4208 P_1_1_3 net6_4 1.62846e-05f
C4209 P_1_1_3 net6_7 2.47603e-05f
C4210 P_1_1_3 net7 3.13246e-05f
C4211 P_1_1_3 net7_11 1.83635e-05f
C4212 P_1_1_3 net7_2 2.7176e-05f
C4213 P_1_1_3 net7_3 2.94997e-05f
C4214 P_1_1_3 net7_4 2.97164e-05f
C4215 P_1_1_3 net7_5 1.18682e-05f
C4216 P_1_1_3 net7_6 1.18682e-05f
C4217 P_1_1_3 net7_8 1.18682e-05f
C4218 P_1_1_3 net7_9 2.85348e-05f
C4219 P_1_1_3 net80 0.000496136f
C4220 P_1_1_4 VDD_1 0.00042243f
C4221 P_1_1_4 VSS_0 0.00207448f
C4222 P_1_1_4 VSS_2 0.00128528f
C4223 P_1_1_4 XB_1_1 0.000787984f
C4224 P_1_1_4 net132_7 0.00161997f
C4225 P_1_1_4 net80 0.000125313f
C4226 P_1_1_5 VDD_1 0.000851566f
C4227 P_1_1_5 VSS_0 0.00418189f
C4228 P_1_1_5 VSS_2 0.00259095f
C4229 P_1_1_5 WL_0_12 1.0669e-05f
C4230 P_1_1_5 WL_0_13 1.0669e-05f
C4231 P_1_1_5 WL_0_14 1.0669e-05f
C4232 P_1_1_5 WL_0_15 2.32778e-05f
C4233 P_1_1_5 WL_1_11 0.000287187f
C4234 P_1_1_5 WL_1_12 0.000315905f
C4235 P_1_1_5 WL_1_13 0.000315905f
C4236 P_1_1_5 WL_1_14 0.000315905f
C4237 P_1_1_5 WL_1_15 0.000689248f
C4238 P_1_1_5 WL_1_20 0.000145233f
C4239 P_1_1_5 WL_1_21 0.000145233f
C4240 P_1_1_5 WL_1_22 0.000145233f
C4241 P_1_1_5 WL_1_23 0.000145233f
C4242 P_1_1_5 WL_1_24 0.000145233f
C4243 P_1_1_5 WL_1_25 0.000145233f
C4244 P_1_1_5 WL_1_26 0.000145233f
C4245 P_1_1_5 WL_1_27 0.000145233f
C4246 P_1_1_5 WL_1_28 0.000145233f
C4247 P_1_1_5 WL_1_29 0.000145233f
C4248 P_1_1_5 WL_1_3 0.000190731f
C4249 P_1_1_5 WL_1_30 0.000145233f
C4250 P_1_1_5 WL_1_31 0.000145233f
C4251 P_1_1_5 WL_1_4 0.000190731f
C4252 P_1_1_5 WL_1_5 0.000190731f
C4253 P_1_1_5 WL_1_6 0.000190731f
C4254 P_1_1_5 WL_1_7 0.000190731f
C4255 P_1_1_5 WL_1_8 0.000190731f
C4256 P_1_1_5 XB_0_1_3 1.62308e-05f
C4257 P_1_1_5 XB_1_1_2 0.00158848f
C4258 P_1_1_5 net134 4.31136e-05f
C4259 P_1_1_5 net134_10 3.92739e-05f
C4260 P_1_1_5 net134_2 3.74037e-05f
C4261 P_1_1_5 net134_3 4.0602e-05f
C4262 P_1_1_5 net134_4 4.09001e-05f
C4263 P_1_1_5 net134_5 1.63348e-05f
C4264 P_1_1_5 net134_6 1.63348e-05f
C4265 P_1_1_5 net134_8 1.63348e-05f
C4266 P_1_1_5 net134_9 2.52746e-05f
C4267 P_1_1_5 net80 0.000252614f
C4268 P_1_1_5 net81_5 1.40341e-05f
C4269 P_1_1_5 net81_7 2.13384e-05f
C4270 P_1_2 VDD_1 0.00100436f
C4271 P_1_2 VSS_0 0.00480245f
C4272 P_1_2 VSS_2 0.00297599f
C4273 P_1_2 WL_0_1 1.27804e-05f
C4274 P_1_2 WL_0_10 2.30473e-05f
C4275 P_1_2 WL_0_16 1.05957e-05f
C4276 P_1_2 WL_0_17 1.05957e-05f
C4277 P_1_2 WL_0_18 1.05957e-05f
C4278 P_1_2 WL_0_19 1.05957e-05f
C4279 P_1_2 WL_0_2 1.3915e-05f
C4280 P_1_2 WL_0_9 1.46665e-05f
C4281 P_1_2 WL_1 7.22082e-05f
C4282 P_1_2 WL_1_1 0.000173306f
C4283 P_1_2 WL_1_10 0.000312527f
C4284 P_1_2 WL_1_11 0.000284115f
C4285 P_1_2 WL_1_2 0.000188691f
C4286 P_1_2 WL_1_3 0.000188691f
C4287 P_1_2 WL_1_9 0.000198881f
C4288 P_1_2 XB_0_2_3 1.06383e-05f
C4289 P_1_2 XB_1_2 0.00183043f
C4290 P_1_2 net132 1.119e-05f
C4291 P_1_2 net132_3 1.05382e-05f
C4292 P_1_2 net132_4 1.06155e-05f
C4293 P_1_2 net134 0.00857298f
C4294 P_1_2 net134_3 0.00807355f
C4295 P_1_2 net134_4 0.00813283f
C4296 P_1_2 net134_6 0.0032481f
C4297 P_1_2 net134_9 0.00502576f
C4298 P_1_2 net83 0.000285262f
C4299 P_1_2_1 VDD_1 0.00215149f
C4300 P_1_2_1 VSS_0 0.0102876f
C4301 P_1_2_1 VSS_2 0.00637503f
C4302 P_1_2_1 XB_0_2_3 2.27889e-05f
C4303 P_1_2_1 XB_1_2 0.00392107f
C4304 P_1_2_1 net134_2 0.00743758f
C4305 P_1_2_1 net83 0.000611076f
C4306 P_1_2_2 VDD_1 0.00391404f
C4307 P_1_2_2 VSS_0 0.0187154f
C4308 P_1_2_2 VSS_2 0.0115976f
C4309 P_1_2_2 WL_1_16 0.00014368f
C4310 P_1_2_2 WL_1_17 0.00014368f
C4311 P_1_2_2 WL_1_18 0.00014368f
C4312 P_1_2_2 WL_1_19 0.00014368f
C4313 P_1_2_2 WL_1_20 0.00014368f
C4314 P_1_2_2 WL_1_21 0.00014368f
C4315 P_1_2_2 XB_0_1_3 1.01526e-05f
C4316 P_1_2_2 XB_0_2_3 4.14581e-05f
C4317 P_1_2_2 XB_1_1_1 1.35415e-05f
C4318 P_1_2_2 XB_1_2 0.0071333f
C4319 P_1_2_2 net132_10 1.01934e-05f
C4320 P_1_2_2 net134_10 0.00780946f
C4321 P_1_2_2 net134_5 0.0032481f
C4322 P_1_2_2 net83 0.00111168f
C4323 P_1_2_2 net84_5 1.47151e-05f
C4324 P_1_2_3 VDD_1 0.00171923f
C4325 P_1_2_3 VSS_0 0.00822067f
C4326 P_1_2_3 VSS_2 0.00509419f
C4327 P_1_2_3 WL_0_11 2.09521e-05f
C4328 P_1_2_3 WL_0_12 2.30473e-05f
C4329 P_1_2_3 WL_0_20 1.05957e-05f
C4330 P_1_2_3 WL_0_21 1.05957e-05f
C4331 P_1_2_3 WL_0_22 1.05957e-05f
C4332 P_1_2_3 WL_0_23 1.05957e-05f
C4333 P_1_2_3 WL_0_3 1.3915e-05f
C4334 P_1_2_3 WL_0_4 1.3915e-05f
C4335 P_1_2_3 XB_0_2_3 1.82103e-05f
C4336 P_1_2_3 XB_1_2_3 0.00313327f
C4337 P_1_2_3 net11 1.55115e-05f
C4338 P_1_2_3 net11_2 1.34572e-05f
C4339 P_1_2_3 net11_3 1.46078e-05f
C4340 P_1_2_3 net11_4 1.47151e-05f
C4341 P_1_2_3 net11_9 1.413e-05f
C4342 P_1_2_3 net134_8 0.0032481f
C4343 P_1_2_3 net13_4 1.00079e-05f
C4344 P_1_2_3 net13_7 1.52167e-05f
C4345 P_1_2_3 net83 0.000488301f
C4346 P_1_2_4 VDD_1 0.000434237f
C4347 P_1_2_4 VSS_0 0.00207635f
C4348 P_1_2_4 VSS_2 0.00128668f
C4349 P_1_2_4 XB_1_2 0.000791392f
C4350 P_1_2_4 net134_7 0.00162405f
C4351 P_1_2_4 net83 0.000123334f
C4352 P_1_2_5 VDD_1 0.000875367f
C4353 P_1_2_5 VSS_0 0.00418567f
C4354 P_1_2_5 VSS_2 0.00259378f
C4355 P_1_2_5 WL_0_13 2.30473e-05f
C4356 P_1_2_5 WL_0_14 2.30473e-05f
C4357 P_1_2_5 WL_0_15 5.0285e-05f
C4358 P_1_2_5 WL_0_24 1.05957e-05f
C4359 P_1_2_5 WL_0_25 1.05957e-05f
C4360 P_1_2_5 WL_0_26 1.05957e-05f
C4361 P_1_2_5 WL_0_27 1.05957e-05f
C4362 P_1_2_5 WL_0_28 1.05957e-05f
C4363 P_1_2_5 WL_0_29 1.05957e-05f
C4364 P_1_2_5 WL_0_30 1.05957e-05f
C4365 P_1_2_5 WL_0_31 1.05957e-05f
C4366 P_1_2_5 WL_0_5 1.3915e-05f
C4367 P_1_2_5 WL_0_6 1.3915e-05f
C4368 P_1_2_5 WL_0_7 1.3915e-05f
C4369 P_1_2_5 WL_0_8 1.3915e-05f
C4370 P_1_2_5 WL_1_12 0.000312527f
C4371 P_1_2_5 WL_1_13 0.000312527f
C4372 P_1_2_5 WL_1_14 0.000312527f
C4373 P_1_2_5 WL_1_15 0.000681876f
C4374 P_1_2_5 WL_1_22 0.00014368f
C4375 P_1_2_5 WL_1_23 0.00014368f
C4376 P_1_2_5 WL_1_24 0.00014368f
C4377 P_1_2_5 WL_1_25 0.00014368f
C4378 P_1_2_5 WL_1_26 0.00014368f
C4379 P_1_2_5 WL_1_27 0.00014368f
C4380 P_1_2_5 WL_1_28 0.00014368f
C4381 P_1_2_5 WL_1_29 0.00014368f
C4382 P_1_2_5 WL_1_30 0.00014368f
C4383 P_1_2_5 WL_1_31 0.00014368f
C4384 P_1_2_5 WL_1_4 0.000188691f
C4385 P_1_2_5 WL_1_5 0.000188691f
C4386 P_1_2_5 WL_1_6 0.000188691f
C4387 P_1_2_5 WL_1_7 0.000188691f
C4388 P_1_2_5 WL_1_8 0.000188691f
C4389 P_1_2_5 XB_1_2_2 0.00159535f
C4390 P_1_2_5 net135 3.74183e-05f
C4391 P_1_2_5 net135_10 3.40858e-05f
C4392 P_1_2_5 net135_2 3.24627e-05f
C4393 P_1_2_5 net135_3 3.52385e-05f
C4394 P_1_2_5 net135_4 3.54972e-05f
C4395 P_1_2_5 net135_5 1.41769e-05f
C4396 P_1_2_5 net135_6 1.41769e-05f
C4397 P_1_2_5 net135_8 1.41769e-05f
C4398 P_1_2_5 net135_9 2.19358e-05f
C4399 P_1_2_5 net83 0.000248625f
C4400 P_1_3 VDD_1 0.000985672f
C4401 P_1_3 VSS_0 0.00483522f
C4402 P_1_3 VSS_2 0.00293806f
C4403 P_1_3 WL_0_10 1.01488e-05f
C4404 P_1_3 WL_1 7.14007e-05f
C4405 P_1_3 WL_1_1 0.000171368f
C4406 P_1_3 WL_1_10 0.000309032f
C4407 P_1_3 WL_1_11 0.000280938f
C4408 P_1_3 WL_1_12 0.000309032f
C4409 P_1_3 WL_1_2 0.000186581f
C4410 P_1_3 WL_1_3 0.000186581f
C4411 P_1_3 WL_1_4 0.000186581f
C4412 P_1_3 WL_1_9 0.000196656f
C4413 P_1_3 XB_0_3_3 2.0084e-05f
C4414 P_1_3 XB_1_3 0.00185907f
C4415 P_1_3 net10_4 1.05877e-05f
C4416 P_1_3 net10_7 1.60983e-05f
C4417 P_1_3 net11 1.15809e-05f
C4418 P_1_3 net11_2 1.00471e-05f
C4419 P_1_3 net11_3 1.09062e-05f
C4420 P_1_3 net11_4 1.09863e-05f
C4421 P_1_3 net11_9 1.05495e-05f
C4422 P_1_3 net134 1.82117e-05f
C4423 P_1_3 net134_2 1.57998e-05f
C4424 P_1_3 net134_3 1.71508e-05f
C4425 P_1_3 net134_4 1.72767e-05f
C4426 P_1_3 net134_9 1.06763e-05f
C4427 P_1_3 net135 0.00862026f
C4428 P_1_3 net135_3 0.00811808f
C4429 P_1_3 net135_4 0.00817769f
C4430 P_1_3 net135_6 0.00326602f
C4431 P_1_3 net135_9 0.00505348f
C4432 P_1_3 net81_7 1.08709e-05f
C4433 P_1_3 net84_7 2.39242e-05f
C4434 P_1_3 net85 0.000291235f
C4435 P_1_3_1 VDD_1 0.00211146f
C4436 P_1_3_1 VSS_0 0.0103578f
C4437 P_1_3_1 VSS_2 0.00629379f
C4438 P_1_3_1 XB_0_3_3 4.30232e-05f
C4439 P_1_3_1 XB_1_3 0.00398243f
C4440 P_1_3_1 net135_2 0.0074786f
C4441 P_1_3_1 net85 0.000623871f
C4442 P_1_3_2 VDD_1 0.00384122f
C4443 P_1_3_2 VSS_0 0.0188431f
C4444 P_1_3_2 VSS_2 0.0114498f
C4445 P_1_3_2 WL_1_16 0.000142073f
C4446 P_1_3_2 WL_1_17 0.000142073f
C4447 P_1_3_2 WL_1_18 0.000142073f
C4448 P_1_3_2 WL_1_19 0.000142073f
C4449 P_1_3_2 WL_1_20 0.000142073f
C4450 P_1_3_2 WL_1_21 0.000142073f
C4451 P_1_3_2 WL_1_22 0.000142073f
C4452 P_1_3_2 WL_1_23 0.000142073f
C4453 P_1_3_2 XB_0_1_3 1.17734e-05f
C4454 P_1_3_2 XB_0_3_3 7.82687e-05f
C4455 P_1_3_2 XB_1_2_1 1.01945e-05f
C4456 P_1_3_2 XB_1_3 0.00724492f
C4457 P_1_3_2 net134_10 1.65898e-05f
C4458 P_1_3_2 net135_10 0.00785253f
C4459 P_1_3_2 net135_5 0.00326602f
C4460 P_1_3_2 net84_5 1.57347e-05f
C4461 P_1_3_2 net85 0.00113496f
C4462 P_1_3_3 VDD_1 0.00168724f
C4463 P_1_3_3 VSS_0 0.00827676f
C4464 P_1_3_3 VSS_2 0.00502928f
C4465 P_1_3_3 WL_0_12 1.01488e-05f
C4466 P_1_3_3 WL_0_13 1.01488e-05f
C4467 P_1_3_3 XB_0_3_3 3.43791e-05f
C4468 P_1_3_3 XB_1_3_3 0.0031823f
C4469 P_1_3_3 net135_8 0.00326602f
C4470 P_1_3_3 net13_4 1.12973e-05f
C4471 P_1_3_3 net13_7 1.71771e-05f
C4472 P_1_3_3 net14 3.46855e-05f
C4473 P_1_3_3 net14_11 2.03337e-05f
C4474 P_1_3_3 net14_2 3.00917e-05f
C4475 P_1_3_3 net14_3 3.26648e-05f
C4476 P_1_3_3 net14_4 3.29047e-05f
C4477 P_1_3_3 net14_5 1.31415e-05f
C4478 P_1_3_3 net14_6 1.31415e-05f
C4479 P_1_3_3 net14_8 1.31415e-05f
C4480 P_1_3_3 net14_9 3.15963e-05f
C4481 P_1_3_3 net16_4 1.29207e-05f
C4482 P_1_3_3 net16_7 1.96455e-05f
C4483 P_1_3_3 net85 0.000498526f
C4484 P_1_3_4 VDD_1 0.000426158f
C4485 P_1_3_4 VSS_0 0.00209052f
C4486 P_1_3_4 VSS_2 0.00127028f
C4487 P_1_3_4 XB_1_3 0.000803776f
C4488 P_1_3_4 net135_7 0.00163301f
C4489 P_1_3_4 net85 0.000125916f
C4490 P_1_3_5 VDD_1 0.000859081f
C4491 P_1_3_5 VSS_0 0.00421423f
C4492 P_1_3_5 VSS_2 0.00256072f
C4493 P_1_3_5 WL_0_14 1.01488e-05f
C4494 P_1_3_5 WL_0_15 2.21428e-05f
C4495 P_1_3_5 WL_1_13 0.000309032f
C4496 P_1_3_5 WL_1_14 0.000309032f
C4497 P_1_3_5 WL_1_15 0.000674251f
C4498 P_1_3_5 WL_1_24 0.000142073f
C4499 P_1_3_5 WL_1_25 0.000142073f
C4500 P_1_3_5 WL_1_26 0.000142073f
C4501 P_1_3_5 WL_1_27 0.000142073f
C4502 P_1_3_5 WL_1_28 0.000142073f
C4503 P_1_3_5 WL_1_29 0.000142073f
C4504 P_1_3_5 WL_1_30 0.000142073f
C4505 P_1_3_5 WL_1_31 0.000142073f
C4506 P_1_3_5 WL_1_5 0.000186581f
C4507 P_1_3_5 WL_1_6 0.000186581f
C4508 P_1_3_5 WL_1_7 0.000186581f
C4509 P_1_3_5 WL_1_8 0.000186581f
C4510 P_1_3_5 XB_0_3_3 1.75046e-05f
C4511 P_1_3_5 XB_1_3_2 0.00162031f
C4512 P_1_3_5 net137 3.84528e-05f
C4513 P_1_3_5 net137_10 3.50281e-05f
C4514 P_1_3_5 net137_2 3.33601e-05f
C4515 P_1_3_5 net137_3 3.62126e-05f
C4516 P_1_3_5 net137_4 3.64786e-05f
C4517 P_1_3_5 net137_5 1.45689e-05f
C4518 P_1_3_5 net137_6 1.45689e-05f
C4519 P_1_3_5 net137_8 1.45689e-05f
C4520 P_1_3_5 net137_9 2.25423e-05f
C4521 P_1_3_5 net85 0.000253831f
C4522 P_1_3_5 net86_5 1.32938e-05f
C4523 P_1_3_5 net86_7 2.02129e-05f
C4524 P_1_4 VDD_1 0.00101848f
C4525 P_1_4 VSS_0 0.00479579f
C4526 P_1_4 VSS_2 0.00297272f
C4527 P_1_4 WL_0_1 1.24244e-05f
C4528 P_1_4 WL_0_10 2.24053e-05f
C4529 P_1_4 WL_0_11 2.03685e-05f
C4530 P_1_4 WL_0_12 2.24053e-05f
C4531 P_1_4 WL_0_16 1.03005e-05f
C4532 P_1_4 WL_0_17 1.03005e-05f
C4533 P_1_4 WL_0_18 1.03005e-05f
C4534 P_1_4 WL_0_19 1.03005e-05f
C4535 P_1_4 WL_0_2 1.35274e-05f
C4536 P_1_4 WL_0_20 1.03005e-05f
C4537 P_1_4 WL_0_21 1.03005e-05f
C4538 P_1_4 WL_0_22 1.03005e-05f
C4539 P_1_4 WL_0_23 1.03005e-05f
C4540 P_1_4 WL_0_3 1.35274e-05f
C4541 P_1_4 WL_0_4 1.35274e-05f
C4542 P_1_4 WL_0_9 1.42579e-05f
C4543 P_1_4 WL_1 7.24617e-05f
C4544 P_1_4 WL_1_1 0.000173914f
C4545 P_1_4 WL_1_10 0.000313624f
C4546 P_1_4 WL_1_11 0.000285113f
C4547 P_1_4 WL_1_12 0.000313624f
C4548 P_1_4 WL_1_13 0.000313624f
C4549 P_1_4 WL_1_2 0.000189353f
C4550 P_1_4 WL_1_3 0.000189353f
C4551 P_1_4 WL_1_4 0.000189353f
C4552 P_1_4 WL_1_5 0.000189353f
C4553 P_1_4 WL_1_9 0.000199579f
C4554 P_1_4 XB_0_4_3 1.16717e-05f
C4555 P_1_4 XB_1_4 0.00183808f
C4556 P_1_4 net137 0.00859607f
C4557 P_1_4 net137_3 0.0080953f
C4558 P_1_4 net137_4 0.00815474f
C4559 P_1_4 net137_6 0.00325685f
C4560 P_1_4 net137_9 0.00503929f
C4561 P_1_4 net87 0.00027445f
C4562 P_1_4_1 VDD_1 0.00218174f
C4563 P_1_4_1 VSS_0 0.0102733f
C4564 P_1_4_1 VSS_2 0.00636803f
C4565 P_1_4_1 XB_0_3_3 1.02446e-05f
C4566 P_1_4_1 XB_0_4_3 2.50027e-05f
C4567 P_1_4_1 XB_1_3_2 1.42322e-05f
C4568 P_1_4_1 XB_1_4 0.00393746f
C4569 P_1_4_1 net137_2 0.00745762f
C4570 P_1_4_1 net87 0.000587914f
C4571 P_1_4_2 VDD_1 0.00396907f
C4572 P_1_4_2 VSS_0 0.0186895f
C4573 P_1_4_2 VSS_2 0.0115849f
C4574 P_1_4_2 WL_1_16 0.000144184f
C4575 P_1_4_2 WL_1_17 0.000144184f
C4576 P_1_4_2 WL_1_18 0.000144184f
C4577 P_1_4_2 WL_1_19 0.000144184f
C4578 P_1_4_2 WL_1_20 0.000144184f
C4579 P_1_4_2 WL_1_21 0.000144184f
C4580 P_1_4_2 WL_1_22 0.000144184f
C4581 P_1_4_2 WL_1_23 0.000144184f
C4582 P_1_4_2 WL_1_24 0.000144184f
C4583 P_1_4_2 WL_1_25 0.000144184f
C4584 P_1_4_2 XB_0_3_3 1.86372e-05f
C4585 P_1_4_2 XB_0_4_3 4.54854e-05f
C4586 P_1_4_2 XB_1_3_1 2.58916e-05f
C4587 P_1_4_2 XB_1_4 0.00716312f
C4588 P_1_4_2 net137_10 0.0078305f
C4589 P_1_4_2 net137_5 0.00325685f
C4590 P_1_4_2 net87 0.00106955f
C4591 P_1_4_3 VDD_1 0.0017434f
C4592 P_1_4_3 VSS_0 0.00820927f
C4593 P_1_4_3 VSS_2 0.0050886f
C4594 P_1_4_3 WL_0_13 2.24053e-05f
C4595 P_1_4_3 WL_0_14 2.24053e-05f
C4596 P_1_4_3 WL_0_24 1.03005e-05f
C4597 P_1_4_3 WL_0_25 1.03005e-05f
C4598 P_1_4_3 WL_0_26 1.03005e-05f
C4599 P_1_4_3 WL_0_27 1.03005e-05f
C4600 P_1_4_3 WL_0_5 1.35274e-05f
C4601 P_1_4_3 WL_0_6 1.35274e-05f
C4602 P_1_4_3 XB_0_4_3 1.99792e-05f
C4603 P_1_4_3 XB_1_3_3 1.13728e-05f
C4604 P_1_4_3 XB_1_4_3 0.00314637f
C4605 P_1_4_3 net137_8 0.00325685f
C4606 P_1_4_3 net87 0.000469793f
C4607 P_1_4_4 VDD_1 0.000440342f
C4608 P_1_4_4 VSS_0 0.00207347f
C4609 P_1_4_4 VSS_2 0.00128526f
C4610 P_1_4_4 XB_1_4 0.000794701f
C4611 P_1_4_4 net137_7 0.00162843f
C4612 P_1_4_4 net87 0.000118659f
C4613 P_1_4_5 VDD_1 0.000887674f
C4614 P_1_4_5 VSS_0 0.00417986f
C4615 P_1_4_5 VSS_2 0.00259093f
C4616 P_1_4_5 WL_0_15 4.88843e-05f
C4617 P_1_4_5 WL_0_28 1.03005e-05f
C4618 P_1_4_5 WL_0_29 1.03005e-05f
C4619 P_1_4_5 WL_0_30 1.03005e-05f
C4620 P_1_4_5 WL_0_31 1.03005e-05f
C4621 P_1_4_5 WL_0_7 1.35274e-05f
C4622 P_1_4_5 WL_0_8 1.35274e-05f
C4623 P_1_4_5 WL_1_14 0.000313624f
C4624 P_1_4_5 WL_1_15 0.00068427f
C4625 P_1_4_5 WL_1_26 0.000144184f
C4626 P_1_4_5 WL_1_27 0.000144184f
C4627 P_1_4_5 WL_1_28 0.000144184f
C4628 P_1_4_5 WL_1_29 0.000144184f
C4629 P_1_4_5 WL_1_30 0.000144184f
C4630 P_1_4_5 WL_1_31 0.000144184f
C4631 P_1_4_5 WL_1_6 0.000189353f
C4632 P_1_4_5 WL_1_7 0.000189353f
C4633 P_1_4_5 WL_1_8 0.000189353f
C4634 P_1_4_5 XB_0_4_3 1.01727e-05f
C4635 P_1_4_5 XB_1_4_2 0.00160202f
C4636 P_1_4_5 net139 3.21538e-05f
C4637 P_1_4_5 net139_10 2.92901e-05f
C4638 P_1_4_5 net139_2 2.78954e-05f
C4639 P_1_4_5 net139_3 3.02806e-05f
C4640 P_1_4_5 net139_4 3.0503e-05f
C4641 P_1_4_5 net139_5 1.21823e-05f
C4642 P_1_4_5 net139_6 1.21823e-05f
C4643 P_1_4_5 net139_8 1.21823e-05f
C4644 P_1_4_5 net139_9 1.88496e-05f
C4645 P_1_4_5 net87 0.000239202f
C4646 P_1_4_5 net88_7 1.05976e-05f
C4647 P_1_5 VDD_1 0.000993237f
C4648 P_1_5 VSS_0 0.00481139f
C4649 P_1_5 VSS_2 0.00297402f
C4650 P_1_5 WL_0_10 1.63863e-05f
C4651 P_1_5 WL_0_11 1.48966e-05f
C4652 P_1_5 WL_0_12 1.63863e-05f
C4653 P_1_5 WL_0_13 1.63863e-05f
C4654 P_1_5 WL_0_9 1.04276e-05f
C4655 P_1_5 WL_1 7.41571e-05f
C4656 P_1_5 WL_1_1 0.000177983f
C4657 P_1_5 WL_1_10 0.000320962f
C4658 P_1_5 WL_1_11 0.000291783f
C4659 P_1_5 WL_1_12 0.000320962f
C4660 P_1_5 WL_1_13 0.000320962f
C4661 P_1_5 WL_1_14 0.000320962f
C4662 P_1_5 WL_1_2 0.000193784f
C4663 P_1_5 WL_1_3 0.000193784f
C4664 P_1_5 WL_1_4 0.000193784f
C4665 P_1_5 WL_1_5 0.000193784f
C4666 P_1_5 WL_1_6 0.000193784f
C4667 P_1_5 WL_1_9 0.000204248f
C4668 P_1_5 XB_0_5_3 1.84008e-05f
C4669 P_1_5 XB_1_5 0.00182922f
C4670 P_1_5 net137 1.38222e-05f
C4671 P_1_5 net137_2 1.19916e-05f
C4672 P_1_5 net137_3 1.30169e-05f
C4673 P_1_5 net137_4 1.31125e-05f
C4674 P_1_5 net139 0.00856961f
C4675 P_1_5 net139_3 0.00807038f
C4676 P_1_5 net139_4 0.00812964f
C4677 P_1_5 net139_6 0.00324683f
C4678 P_1_5 net139_9 0.00502378f
C4679 P_1_5 net88_7 2.15425e-05f
C4680 P_1_5 net90 0.000291824f
C4681 P_1_5_1 VDD_1 0.00212767f
C4682 P_1_5_1 VSS_0 0.0103068f
C4683 P_1_5_1 VSS_2 0.00637081f
C4684 P_1_5_1 XB_0_5_3 3.94175e-05f
C4685 P_1_5_1 XB_1_5 0.00391848f
C4686 P_1_5_1 net139_2 0.00743466f
C4687 P_1_5_1 net90 0.000625132f
C4688 P_1_5_1 net91_5 1.32134e-05f
C4689 P_1_5_2 VDD_1 0.0038707f
C4690 P_1_5_2 VSS_0 0.0187503f
C4691 P_1_5_2 VSS_2 0.0115899f
C4692 P_1_5_2 WL_1_16 0.000147558f
C4693 P_1_5_2 WL_1_17 0.000147558f
C4694 P_1_5_2 WL_1_18 0.000147558f
C4695 P_1_5_2 WL_1_19 0.000147558f
C4696 P_1_5_2 WL_1_20 0.000147558f
C4697 P_1_5_2 WL_1_21 0.000147558f
C4698 P_1_5_2 WL_1_22 0.000147558f
C4699 P_1_5_2 WL_1_23 0.000147558f
C4700 P_1_5_2 WL_1_24 0.000147558f
C4701 P_1_5_2 WL_1_25 0.000147558f
C4702 P_1_5_2 WL_1_26 0.000147558f
C4703 P_1_5_2 WL_1_27 0.000147558f
C4704 P_1_5_2 XB_0_5_3 7.17091e-05f
C4705 P_1_5_2 XB_1_4_1 1.24107e-05f
C4706 P_1_5_2 XB_1_5 0.00712859f
C4707 P_1_5_2 net137_10 1.25912e-05f
C4708 P_1_5_2 net139_10 0.00780639f
C4709 P_1_5_2 net139_5 0.00324683f
C4710 P_1_5_2 net88_5 1.41683e-05f
C4711 P_1_5_2 net90 0.00113725f
C4712 P_1_5_2 net91_5 2.40381e-05f
C4713 P_1_5_3 VDD_1 0.00170019f
C4714 P_1_5_3 VSS_0 0.00823597f
C4715 P_1_5_3 VSS_2 0.00509082f
C4716 P_1_5_3 WL_0_14 1.63863e-05f
C4717 P_1_5_3 WL_0_15 3.57519e-05f
C4718 P_1_5_3 XB_0_5_3 3.14979e-05f
C4719 P_1_5_3 XB_1_5_3 0.0031312f
C4720 P_1_5_3 net139_8 0.00324683f
C4721 P_1_5_3 net19_4 1.34155e-05f
C4722 P_1_5_3 net19_7 2.03979e-05f
C4723 P_1_5_3 net20 2.72123e-05f
C4724 P_1_5_3 net20_11 1.59527e-05f
C4725 P_1_5_3 net20_2 2.36083e-05f
C4726 P_1_5_3 net20_3 2.5627e-05f
C4727 P_1_5_3 net20_4 2.58152e-05f
C4728 P_1_5_3 net20_5 1.03101e-05f
C4729 P_1_5_3 net20_6 1.03101e-05f
C4730 P_1_5_3 net20_8 1.03101e-05f
C4731 P_1_5_3 net20_9 2.47887e-05f
C4732 P_1_5_3 net23_2 1.05455e-05f
C4733 P_1_5_3 net23_3 1.05455e-05f
C4734 P_1_5_3 net23_4 1.7953e-05f
C4735 P_1_5_3 net23_7 2.7297e-05f
C4736 P_1_5_3 net90 0.000499534f
C4737 P_1_5_3 net91_4 1.05586e-05f
C4738 P_1_5_4 VDD_1 0.000429429f
C4739 P_1_5_4 VSS_0 0.00208022f
C4740 P_1_5_4 VSS_2 0.00128583f
C4741 P_1_5_4 XB_1_5 0.00079087f
C4742 P_1_5_4 net139_7 0.00162341f
C4743 P_1_5_4 net90 0.000126171f
C4744 P_1_5_5 VDD_1 0.000865674f
C4745 P_1_5_5 VSS_0 0.00419346f
C4746 P_1_5_5 VSS_2 0.00259206f
C4747 P_1_5_5 WL_1_15 0.00070028f
C4748 P_1_5_5 WL_1_28 0.000147558f
C4749 P_1_5_5 WL_1_29 0.000147558f
C4750 P_1_5_5 WL_1_30 0.000147558f
C4751 P_1_5_5 WL_1_31 0.000147558f
C4752 P_1_5_5 WL_1_7 0.000193784f
C4753 P_1_5_5 WL_1_8 0.000193784f
C4754 P_1_5_5 XB_0_5_3 1.60376e-05f
C4755 P_1_5_5 XB_1_5_2 0.00159429f
C4756 P_1_5_5 net141 4.60901e-05f
C4757 P_1_5_5 net141_10 4.19852e-05f
C4758 P_1_5_5 net141_2 3.99859e-05f
C4759 P_1_5_5 net141_3 4.3405e-05f
C4760 P_1_5_5 net141_4 4.37237e-05f
C4761 P_1_5_5 net141_5 1.74625e-05f
C4762 P_1_5_5 net141_6 1.74625e-05f
C4763 P_1_5_5 net141_8 1.74625e-05f
C4764 P_1_5_5 net141_9 2.70195e-05f
C4765 P_1_5_5 net90 0.000254344f
C4766 P_1_6 VDD_1 0.00101452f
C4767 P_1_6 VSS_0 0.00479178f
C4768 P_1_6 VSS_2 0.00294692f
C4769 P_1_6 WL_0_1 1.13767e-05f
C4770 P_1_6 WL_0_10 2.0516e-05f
C4771 P_1_6 WL_0_11 1.86509e-05f
C4772 P_1_6 WL_0_12 2.0516e-05f
C4773 P_1_6 WL_0_13 2.0516e-05f
C4774 P_1_6 WL_0_14 2.0516e-05f
C4775 P_1_6 WL_0_2 1.23867e-05f
C4776 P_1_6 WL_0_3 1.23867e-05f
C4777 P_1_6 WL_0_4 1.23867e-05f
C4778 P_1_6 WL_0_5 1.23867e-05f
C4779 P_1_6 WL_0_6 1.23867e-05f
C4780 P_1_6 WL_0_9 1.30556e-05f
C4781 P_1_6 WL_1 7.30231e-05f
C4782 P_1_6 WL_1_1 0.000175262f
C4783 P_1_6 WL_1_10 0.000316054f
C4784 P_1_6 WL_1_11 0.000287322f
C4785 P_1_6 WL_1_12 0.000316054f
C4786 P_1_6 WL_1_13 0.000316054f
C4787 P_1_6 WL_1_14 0.000316054f
C4788 P_1_6 WL_1_15 0.000689572f
C4789 P_1_6 WL_1_2 0.000190821f
C4790 P_1_6 WL_1_3 0.000190821f
C4791 P_1_6 WL_1_4 0.000190821f
C4792 P_1_6 WL_1_5 0.000190821f
C4793 P_1_6 WL_1_6 0.000190821f
C4794 P_1_6 WL_1_7 0.000190821f
C4795 P_1_6 WL_1_9 0.000201125f
C4796 P_1_6 XB_0_6_3 1.75116e-05f
C4797 P_1_6 XB_1_6 0.00183258f
C4798 P_1_6 net141 0.00855519f
C4799 P_1_6 net141_3 0.0080568f
C4800 P_1_6 net141_4 0.00811596f
C4801 P_1_6 net141_6 0.00324136f
C4802 P_1_6 net141_9 0.00501533f
C4803 P_1_6 net93 0.00029568f
C4804 P_1_6_1 VDD_1 0.00217325f
C4805 P_1_6_1 VSS_0 0.0102647f
C4806 P_1_6_1 VSS_2 0.00631277f
C4807 P_1_6_1 XB_0_5_3 1.28461e-05f
C4808 P_1_6_1 XB_0_6_3 3.75126e-05f
C4809 P_1_6_1 XB_1_6 0.00392568f
C4810 P_1_6_1 net141_2 0.00742215f
C4811 P_1_6_1 net93 0.000633392f
C4812 P_1_6_1 net94_5 1.05976e-05f
C4813 P_1_6_2 VDD_1 0.00395363f
C4814 P_1_6_2 VSS_0 0.0186738f
C4815 P_1_6_2 VSS_2 0.0114843f
C4816 P_1_6_2 WL_1_16 0.000145301f
C4817 P_1_6_2 WL_1_17 0.000145301f
C4818 P_1_6_2 WL_1_18 0.000145301f
C4819 P_1_6_2 WL_1_19 0.000145301f
C4820 P_1_6_2 WL_1_20 0.000145301f
C4821 P_1_6_2 WL_1_21 0.000145301f
C4822 P_1_6_2 WL_1_22 0.000145301f
C4823 P_1_6_2 WL_1_23 0.000145301f
C4824 P_1_6_2 WL_1_24 0.000145301f
C4825 P_1_6_2 WL_1_25 0.000145301f
C4826 P_1_6_2 WL_1_26 0.000145301f
C4827 P_1_6_2 WL_1_27 0.000145301f
C4828 P_1_6_2 WL_1_28 0.000145301f
C4829 P_1_6_2 WL_1_29 0.000145301f
C4830 P_1_6_2 XB_0_5_3 2.33699e-05f
C4831 P_1_6_2 XB_0_6_3 6.82438e-05f
C4832 P_1_6_2 XB_1_5_1 1.62532e-05f
C4833 P_1_6_2 XB_1_6 0.00714169f
C4834 P_1_6_2 net141_10 0.00779326f
C4835 P_1_6_2 net141_5 0.00324136f
C4836 P_1_6_2 net93 0.00115228f
C4837 P_1_6_2 net94_5 1.92794e-05f
C4838 P_1_6_3 VDD_1 0.00173661f
C4839 P_1_6_3 VSS_0 0.0082024f
C4840 P_1_6_3 VSS_2 0.00504444f
C4841 P_1_6_3 WL_0_15 4.47621e-05f
C4842 P_1_6_3 WL_0_7 1.23867e-05f
C4843 P_1_6_3 WL_0_8 1.23867e-05f
C4844 P_1_6_3 XB_0_5_3 1.02651e-05f
C4845 P_1_6_3 XB_0_6_3 2.99758e-05f
C4846 P_1_6_3 XB_1_6_3 0.00313695f
C4847 P_1_6_3 net141_8 0.00324136f
C4848 P_1_6_3 net93 0.000506134f
C4849 P_1_6_4 VDD_1 0.000438629f
C4850 P_1_6_4 VSS_0 0.00207174f
C4851 P_1_6_4 VSS_2 0.00127411f
C4852 P_1_6_4 XB_1_6 0.000792323f
C4853 P_1_6_4 net141_7 0.00162068f
C4854 P_1_6_4 net93 0.000127838f
C4855 P_1_6_5 VDD_1 0.00088422f
C4856 P_1_6_5 VSS_0 0.00417636f
C4857 P_1_6_5 VSS_2 0.00256844f
C4858 P_1_6_5 WL_1_30 0.000145301f
C4859 P_1_6_5 WL_1_31 0.000145301f
C4860 P_1_6_5 WL_1_8 0.000190821f
C4861 P_1_6_5 XB_0_6_3 1.52626e-05f
C4862 P_1_6_5 XB_1_6_2 0.00159722f
C4863 P_1_6_5 net142 3.74615e-05f
C4864 P_1_6_5 net142_10 3.41252e-05f
C4865 P_1_6_5 net142_2 3.25002e-05f
C4866 P_1_6_5 net142_3 3.52792e-05f
C4867 P_1_6_5 net142_4 3.55382e-05f
C4868 P_1_6_5 net142_5 1.41933e-05f
C4869 P_1_6_5 net142_6 1.41933e-05f
C4870 P_1_6_5 net142_8 1.41933e-05f
C4871 P_1_6_5 net142_9 2.19612e-05f
C4872 P_1_6_5 net93 0.000257705f
C4873 P_1_7 VDD_1 0.00100246f
C4874 P_1_7 VSS_0 0.0047842f
C4875 P_1_7 VSS_2 0.0029707f
C4876 P_1_7 WL_0_15 1.18381e-05f
C4877 P_1_7 WL_1 7.05202e-05f
C4878 P_1_7 WL_1_1 0.000169254f
C4879 P_1_7 WL_1_10 0.000305221f
C4880 P_1_7 WL_1_11 0.000277473f
C4881 P_1_7 WL_1_12 0.000305221f
C4882 P_1_7 WL_1_13 0.000305221f
C4883 P_1_7 WL_1_14 0.000305221f
C4884 P_1_7 WL_1_15 0.000665936f
C4885 P_1_7 WL_1_2 0.00018428f
C4886 P_1_7 WL_1_3 0.00018428f
C4887 P_1_7 WL_1_4 0.00018428f
C4888 P_1_7 WL_1_5 0.00018428f
C4889 P_1_7 WL_1_6 0.00018428f
C4890 P_1_7 WL_1_7 0.00018428f
C4891 P_1_7 WL_1_8 0.00018428f
C4892 P_1_7 WL_1_9 0.000194231f
C4893 P_1_7 XB_0_7_3 1.9314e-05f
C4894 P_1_7 XB_1_7 0.00183191f
C4895 P_1_7 net141 1.44114e-05f
C4896 P_1_7 net141_2 1.25027e-05f
C4897 P_1_7 net141_3 1.35718e-05f
C4898 P_1_7 net141_4 1.36715e-05f
C4899 P_1_7 net142 0.00858273f
C4900 P_1_7 net142_3 0.00808273f
C4901 P_1_7 net142_4 0.00814208f
C4902 P_1_7 net142_6 0.0032518f
C4903 P_1_7 net142_9 0.00503147f
C4904 P_1_7 net91_7 2.06334e-05f
C4905 P_1_7 net94 1.33703e-05f
C4906 P_1_7 net94_3 1.74161e-05f
C4907 P_1_7 net94_4 1.26142e-05f
C4908 P_1_7 net94_7 4.50815e-05f
C4909 P_1_7 net96 0.000292211f
C4910 P_1_7_1 VDD_1 0.00214744f
C4911 P_1_7_1 VSS_0 0.0102485f
C4912 P_1_7_1 VSS_2 0.0063637f
C4913 P_1_7_1 XB_0_7_3 4.13735e-05f
C4914 P_1_7_1 XB_1_7 0.00392423f
C4915 P_1_7_1 net142_2 0.00744604f
C4916 P_1_7_1 net96 0.000625962f
C4917 P_1_7_2 VDD_1 0.00390666f
C4918 P_1_7_2 VSS_0 0.0186443f
C4919 P_1_7_2 VSS_2 0.011577f
C4920 P_1_7_2 WL_1_16 0.000140321f
C4921 P_1_7_2 WL_1_17 0.000140321f
C4922 P_1_7_2 WL_1_18 0.000140321f
C4923 P_1_7_2 WL_1_19 0.000140321f
C4924 P_1_7_2 WL_1_20 0.000140321f
C4925 P_1_7_2 WL_1_21 0.000140321f
C4926 P_1_7_2 WL_1_22 0.000140321f
C4927 P_1_7_2 WL_1_23 0.000140321f
C4928 P_1_7_2 WL_1_24 0.000140321f
C4929 P_1_7_2 WL_1_25 0.000140321f
C4930 P_1_7_2 WL_1_26 0.000140321f
C4931 P_1_7_2 WL_1_27 0.000140321f
C4932 P_1_7_2 WL_1_28 0.000140321f
C4933 P_1_7_2 WL_1_29 0.000140321f
C4934 P_1_7_2 WL_1_30 0.000140321f
C4935 P_1_7_2 WL_1_31 0.000140321f
C4936 P_1_7_2 XB_0_7_3 7.52676e-05f
C4937 P_1_7_2 XB_1_7 0.00713905f
C4938 P_1_7_2 net141_10 1.31279e-05f
C4939 P_1_7_2 net142_10 0.00781834f
C4940 P_1_7_2 net142_5 0.0032518f
C4941 P_1_7_2 net91_5 1.35704e-05f
C4942 P_1_7_2 net94_2 1.74161e-05f
C4943 P_1_7_2 net94_5 2.96498e-05f
C4944 P_1_7_2 net96 0.00113876f
C4945 P_1_7_3 VDD_1 0.00171598f
C4946 P_1_7_3 VSS_0 0.00818942f
C4947 P_1_7_3 VSS_2 0.00508513f
C4948 P_1_7_3 XB_0_7_3 3.3061e-05f
C4949 P_1_7_3 XB_1_7_3 0.00313579f
C4950 P_1_7_3 net142_8 0.0032518f
C4951 P_1_7_3 net27_4 1.55167e-05f
C4952 P_1_7_3 net27_7 2.35927e-05f
C4953 P_1_7_3 net28 3.05204e-05f
C4954 P_1_7_3 net28_11 1.7892e-05f
C4955 P_1_7_3 net28_2 2.64783e-05f
C4956 P_1_7_3 net28_3 2.87424e-05f
C4957 P_1_7_3 net28_4 2.89535e-05f
C4958 P_1_7_3 net28_5 1.15635e-05f
C4959 P_1_7_3 net28_6 1.15635e-05f
C4960 P_1_7_3 net28_8 1.15635e-05f
C4961 P_1_7_3 net28_9 2.78022e-05f
C4962 P_1_7_3 net96 0.000500197f
C4963 P_1_7_4 VDD_1 0.000433418f
C4964 P_1_7_4 VSS_0 0.00206846f
C4965 P_1_7_4 VSS_2 0.00128439f
C4966 P_1_7_4 XB_1_7 0.000792031f
C4967 P_1_7_4 net142_7 0.0016259f
C4968 P_1_7_4 net96 0.000126338f
C4969 P_1_7_5 VDD_1 0.000873716f
C4970 P_1_7_5 VSS_0 0.00416976f
C4971 P_1_7_5 VSS_2 0.00258916f
C4972 P_1_7_5 XB_0_7_3 1.68334e-05f
C4973 P_1_7_5 XB_1_7_2 0.00159663f
C4974 P_1_7_5 net96 0.000254682f
C4975 VDD_1 VSS_0 0.529377f
C4976 VDD_1 VSS_2 0.00249195f
C4977 VDD_1 WL_0 0.0014062f
C4978 VDD_1 WL_0_1 0.00337499f
C4979 VDD_1 WL_0_10 0.00608621f
C4980 VDD_1 WL_0_11 0.00553291f
C4981 VDD_1 WL_0_12 0.00608621f
C4982 VDD_1 WL_0_13 0.00608621f
C4983 VDD_1 WL_0_14 0.00608621f
C4984 VDD_1 WL_0_15 0.013279f
C4985 VDD_1 WL_0_16 0.00279805f
C4986 VDD_1 WL_0_17 0.00279805f
C4987 VDD_1 WL_0_18 0.00279805f
C4988 VDD_1 WL_0_19 0.00279805f
C4989 VDD_1 WL_0_2 0.00367461f
C4990 VDD_1 WL_0_20 0.00279805f
C4991 VDD_1 WL_0_21 0.00279805f
C4992 VDD_1 WL_0_22 0.00279805f
C4993 VDD_1 WL_0_23 0.00279805f
C4994 VDD_1 WL_0_24 0.00279805f
C4995 VDD_1 WL_0_25 0.00279805f
C4996 VDD_1 WL_0_26 0.00279805f
C4997 VDD_1 WL_0_27 0.00279805f
C4998 VDD_1 WL_0_28 0.00279805f
C4999 VDD_1 WL_0_29 0.00279805f
C5000 VDD_1 WL_0_3 0.00367461f
C5001 VDD_1 WL_0_30 0.00279805f
C5002 VDD_1 WL_0_31 0.00279805f
C5003 VDD_1 WL_0_4 0.00367461f
C5004 VDD_1 WL_0_5 0.00367461f
C5005 VDD_1 WL_0_6 0.00367461f
C5006 VDD_1 WL_0_7 0.00367461f
C5007 VDD_1 WL_0_8 0.00367461f
C5008 VDD_1 WL_0_9 0.00387304f
C5009 VDD_1 WL_1 0.00145276f
C5010 VDD_1 WL_1_1 0.00348675f
C5011 VDD_1 WL_1_10 0.00628775f
C5012 VDD_1 WL_1_11 0.00571614f
C5013 VDD_1 WL_1_12 0.00628775f
C5014 VDD_1 WL_1_13 0.00628775f
C5015 VDD_1 WL_1_14 0.00628775f
C5016 VDD_1 WL_1_15 0.0137187f
C5017 VDD_1 WL_1_16 0.00289071f
C5018 VDD_1 WL_1_17 0.00289071f
C5019 VDD_1 WL_1_18 0.00289071f
C5020 VDD_1 WL_1_19 0.00289071f
C5021 VDD_1 WL_1_2 0.00379629f
C5022 VDD_1 WL_1_20 0.00289071f
C5023 VDD_1 WL_1_21 0.00289071f
C5024 VDD_1 WL_1_22 0.00289071f
C5025 VDD_1 WL_1_23 0.00289071f
C5026 VDD_1 WL_1_24 0.00289071f
C5027 VDD_1 WL_1_25 0.00289071f
C5028 VDD_1 WL_1_26 0.00289071f
C5029 VDD_1 WL_1_27 0.00289071f
C5030 VDD_1 WL_1_28 0.00289071f
C5031 VDD_1 WL_1_29 0.00289071f
C5032 VDD_1 WL_1_3 0.00379629f
C5033 VDD_1 WL_1_30 0.00289071f
C5034 VDD_1 WL_1_31 0.00289071f
C5035 VDD_1 WL_1_4 0.00379629f
C5036 VDD_1 WL_1_5 0.00379629f
C5037 VDD_1 WL_1_6 0.00379629f
C5038 VDD_1 WL_1_7 0.00379629f
C5039 VDD_1 WL_1_8 0.00379629f
C5040 VDD_1 WL_1_9 0.00400129f
C5041 VDD_1 XB_0_0 0.00354605f
C5042 VDD_1 XB_0_0_1 0.0148239f
C5043 VDD_1 XB_0_0_2 0.00209518f
C5044 VDD_1 XB_0_0_3 0.00419036f
C5045 VDD_1 XB_0_1 0.00349353f
C5046 VDD_1 XB_0_1_1 0.0146043f
C5047 VDD_1 XB_0_1_2 0.00206415f
C5048 VDD_1 XB_0_1_3 0.0041283f
C5049 VDD_1 XB_0_2 0.00351937f
C5050 VDD_1 XB_0_2_1 0.0147124f
C5051 VDD_1 XB_0_2_2 0.00207942f
C5052 VDD_1 XB_0_2_3 0.00415884f
C5053 VDD_1 XB_0_3 0.00353284f
C5054 VDD_1 XB_0_3_1 0.0147687f
C5055 VDD_1 XB_0_3_2 0.00208738f
C5056 VDD_1 XB_0_3_3 0.00417476f
C5057 VDD_1 XB_0_4 0.00353878f
C5058 VDD_1 XB_0_4_1 0.0147935f
C5059 VDD_1 XB_0_4_2 0.00209088f
C5060 VDD_1 XB_0_4_3 0.00418177f
C5061 VDD_1 XB_0_5 0.00352306f
C5062 VDD_1 XB_0_5_1 0.0147278f
C5063 VDD_1 XB_0_5_2 0.0020816f
C5064 VDD_1 XB_0_5_3 0.0041632f
C5065 VDD_1 XB_0_6 0.00365483f
C5066 VDD_1 XB_0_6_1 0.0152786f
C5067 VDD_1 XB_0_6_2 0.00215946f
C5068 VDD_1 XB_0_6_3 0.00431892f
C5069 VDD_1 XB_0_7 0.00355288f
C5070 VDD_1 XB_0_7_1 0.0148524f
C5071 VDD_1 XB_0_7_2 0.00209922f
C5072 VDD_1 XB_0_7_3 0.00419843f
C5073 VDD_1 XB_1_0 0.0036227f
C5074 VDD_1 XB_1_0_1 0.0151443f
C5075 VDD_1 XB_1_0_2 0.00214047f
C5076 VDD_1 XB_1_0_3 0.00428094f
C5077 VDD_1 XB_1_1 0.00356692f
C5078 VDD_1 XB_1_1_1 0.0149111f
C5079 VDD_1 XB_1_1_2 0.00210751f
C5080 VDD_1 XB_1_1_3 0.00421503f
C5081 VDD_1 XB_1_2 0.00354575f
C5082 VDD_1 XB_1_2_1 0.0148226f
C5083 VDD_1 XB_1_2_2 0.00209501f
C5084 VDD_1 XB_1_2_3 0.00419001f
C5085 VDD_1 XB_1_3 0.00352046f
C5086 VDD_1 XB_1_3_1 0.0147169f
C5087 VDD_1 XB_1_3_2 0.00208006f
C5088 VDD_1 XB_1_3_3 0.00416013f
C5089 VDD_1 XB_1_4 0.00360126f
C5090 VDD_1 XB_1_4_1 0.0150547f
C5091 VDD_1 XB_1_4_2 0.0021278f
C5092 VDD_1 XB_1_4_3 0.00425561f
C5093 VDD_1 XB_1_5 0.00346726f
C5094 VDD_1 XB_1_5_1 0.0144945f
C5095 VDD_1 XB_1_5_2 0.00204863f
C5096 VDD_1 XB_1_5_3 0.00409726f
C5097 VDD_1 XB_1_6 0.00370684f
C5098 VDD_1 XB_1_6_1 0.0154961f
C5099 VDD_1 XB_1_6_2 0.00219019f
C5100 VDD_1 XB_1_6_3 0.00438037f
C5101 VDD_1 XB_1_7 0.00355797f
C5102 VDD_1 XB_1_7_1 0.0148737f
C5103 VDD_1 XB_1_7_2 0.00210222f
C5104 VDD_1 XB_1_7_3 0.00420445f
C5105 VDD_1 net10 0.00239354f
C5106 VDD_1 net10_2 0.00311781f
C5107 VDD_1 net10_3 0.00311781f
C5108 VDD_1 net10_4 0.00530786f
C5109 VDD_1 net10_6 0.00225817f
C5110 VDD_1 net10_7 0.00807043f
C5111 VDD_1 net11 0.00433278f
C5112 VDD_1 net11_11 0.00254001f
C5113 VDD_1 net11_2 0.00375895f
C5114 VDD_1 net11_3 0.00408037f
C5115 VDD_1 net11_4 0.00411033f
C5116 VDD_1 net11_5 0.00164159f
C5117 VDD_1 net11_6 0.00164159f
C5118 VDD_1 net11_7 0.000820795f
C5119 VDD_1 net11_8 0.00164159f
C5120 VDD_1 net11_9 0.0039469f
C5121 VDD_1 net13 0.0024368f
C5122 VDD_1 net130 0.00443814f
C5123 VDD_1 net130_10 0.00404287f
C5124 VDD_1 net130_2 0.00385036f
C5125 VDD_1 net130_3 0.00417959f
C5126 VDD_1 net130_4 0.00421028f
C5127 VDD_1 net130_5 0.00168151f
C5128 VDD_1 net130_6 0.00168151f
C5129 VDD_1 net130_7 0.000840754f
C5130 VDD_1 net130_8 0.00168151f
C5131 VDD_1 net130_9 0.00260178f
C5132 VDD_1 net132 0.00435253f
C5133 VDD_1 net132_10 0.00396488f
C5134 VDD_1 net132_2 0.00377608f
C5135 VDD_1 net132_3 0.00409896f
C5136 VDD_1 net132_4 0.00412906f
C5137 VDD_1 net132_5 0.00164907f
C5138 VDD_1 net132_6 0.00164907f
C5139 VDD_1 net132_7 0.000824535f
C5140 VDD_1 net132_8 0.00164907f
C5141 VDD_1 net132_9 0.00255159f
C5142 VDD_1 net134 0.00438857f
C5143 VDD_1 net134_10 0.00399772f
C5144 VDD_1 net134_2 0.00380735f
C5145 VDD_1 net134_3 0.0041329f
C5146 VDD_1 net134_4 0.00416325f
C5147 VDD_1 net134_5 0.00166273f
C5148 VDD_1 net134_6 0.00166273f
C5149 VDD_1 net134_7 0.000831363f
C5150 VDD_1 net134_8 0.00166273f
C5151 VDD_1 net134_9 0.00257272f
C5152 VDD_1 net135 0.00435183f
C5153 VDD_1 net135_10 0.00396425f
C5154 VDD_1 net135_2 0.00377548f
C5155 VDD_1 net135_3 0.00409831f
C5156 VDD_1 net135_4 0.00412841f
C5157 VDD_1 net135_5 0.00164881f
C5158 VDD_1 net135_6 0.00164881f
C5159 VDD_1 net135_7 0.000824404f
C5160 VDD_1 net135_8 0.00164881f
C5161 VDD_1 net135_9 0.00255118f
C5162 VDD_1 net137 0.00440313f
C5163 VDD_1 net137_10 0.00401098f
C5164 VDD_1 net137_2 0.00381998f
C5165 VDD_1 net137_3 0.00414662f
C5166 VDD_1 net137_4 0.00417707f
C5167 VDD_1 net137_5 0.00166824f
C5168 VDD_1 net137_6 0.00166824f
C5169 VDD_1 net137_7 0.000834122f
C5170 VDD_1 net137_8 0.00166824f
C5171 VDD_1 net137_9 0.00258126f
C5172 VDD_1 net139 0.0043688f
C5173 VDD_1 net139_10 0.00397971f
C5174 VDD_1 net139_2 0.0037902f
C5175 VDD_1 net139_3 0.00411429f
C5176 VDD_1 net139_4 0.0041445f
C5177 VDD_1 net139_5 0.00165524f
C5178 VDD_1 net139_6 0.00165524f
C5179 VDD_1 net139_7 0.000827618f
C5180 VDD_1 net139_8 0.00165524f
C5181 VDD_1 net139_9 0.00256113f
C5182 VDD_1 net13_2 0.00317416f
C5183 VDD_1 net13_3 0.00317416f
C5184 VDD_1 net13_4 0.0054038f
C5185 VDD_1 net13_6 0.00229898f
C5186 VDD_1 net13_7 0.0082163f
C5187 VDD_1 net14 0.0043182f
C5188 VDD_1 net141 0.00446962f
C5189 VDD_1 net141_10 0.00407155f
C5190 VDD_1 net141_2 0.00387766f
C5191 VDD_1 net141_3 0.00420923f
C5192 VDD_1 net141_4 0.00424014f
C5193 VDD_1 net141_5 0.00169343f
C5194 VDD_1 net141_6 0.00169343f
C5195 VDD_1 net141_7 0.000846717f
C5196 VDD_1 net141_8 0.00169343f
C5197 VDD_1 net141_9 0.00262023f
C5198 VDD_1 net142 0.00437925f
C5199 VDD_1 net142_10 0.00398922f
C5200 VDD_1 net142_2 0.00379926f
C5201 VDD_1 net142_3 0.00412413f
C5202 VDD_1 net142_4 0.00415441f
C5203 VDD_1 net142_5 0.00165919f
C5204 VDD_1 net142_6 0.00165919f
C5205 VDD_1 net142_7 0.000829597f
C5206 VDD_1 net142_8 0.00165919f
C5207 VDD_1 net142_9 0.00256725f
C5208 VDD_1 net14_11 0.00253147f
C5209 VDD_1 net14_2 0.0037463f
C5210 VDD_1 net14_3 0.00406664f
C5211 VDD_1 net14_4 0.0040965f
C5212 VDD_1 net14_5 0.00163607f
C5213 VDD_1 net14_6 0.00163607f
C5214 VDD_1 net14_7 0.000818033f
C5215 VDD_1 net14_8 0.00163607f
C5216 VDD_1 net14_9 0.00393362f
C5217 VDD_1 net16 0.00236768f
C5218 VDD_1 net16_2 0.00308413f
C5219 VDD_1 net16_3 0.00308413f
C5220 VDD_1 net16_4 0.00525053f
C5221 VDD_1 net16_6 0.00223378f
C5222 VDD_1 net16_7 0.00798326f
C5223 VDD_1 net17 0.00437413f
C5224 VDD_1 net17_11 0.00256426f
C5225 VDD_1 net17_2 0.00379483f
C5226 VDD_1 net17_3 0.00411931f
C5227 VDD_1 net17_4 0.00414956f
C5228 VDD_1 net17_5 0.00165726f
C5229 VDD_1 net17_6 0.00165726f
C5230 VDD_1 net17_7 0.000828629f
C5231 VDD_1 net17_8 0.00165726f
C5232 VDD_1 net17_9 0.00398457f
C5233 VDD_1 net19 0.00237601f
C5234 VDD_1 net19_2 0.00309498f
C5235 VDD_1 net19_3 0.00309498f
C5236 VDD_1 net19_4 0.005269f
C5237 VDD_1 net19_6 0.00224164f
C5238 VDD_1 net19_7 0.00801134f
C5239 VDD_1 net2 0.00240832f
C5240 VDD_1 net20 0.00432694f
C5241 VDD_1 net20_11 0.00253659f
C5242 VDD_1 net20_2 0.00375389f
C5243 VDD_1 net20_3 0.00407487f
C5244 VDD_1 net20_4 0.00410479f
C5245 VDD_1 net20_5 0.00163938f
C5246 VDD_1 net20_6 0.00163938f
C5247 VDD_1 net20_7 0.000819689f
C5248 VDD_1 net20_8 0.00163938f
C5249 VDD_1 net20_9 0.00394158f
C5250 VDD_1 net23 0.0023814f
C5251 VDD_1 net23_2 0.003102f
C5252 VDD_1 net23_3 0.003102f
C5253 VDD_1 net23_4 0.00528094f
C5254 VDD_1 net23_6 0.00224672f
C5255 VDD_1 net23_7 0.0080295f
C5256 VDD_1 net24 0.00442435f
C5257 VDD_1 net24_11 0.0025937f
C5258 VDD_1 net24_2 0.00383839f
C5259 VDD_1 net24_3 0.0041666f
C5260 VDD_1 net24_4 0.0041972f
C5261 VDD_1 net24_5 0.00167628f
C5262 VDD_1 net24_6 0.00167628f
C5263 VDD_1 net24_7 0.000838142f
C5264 VDD_1 net24_8 0.00167628f
C5265 VDD_1 net24_9 0.00403031f
C5266 VDD_1 net27 0.00242493f
C5267 VDD_1 net27_2 0.0031587f
C5268 VDD_1 net27_3 0.0031587f
C5269 VDD_1 net27_4 0.00537748f
C5270 VDD_1 net27_6 0.00228779f
C5271 VDD_1 net27_7 0.00817629f
C5272 VDD_1 net28 0.00432903f
C5273 VDD_1 net28_11 0.00253781f
C5274 VDD_1 net28_2 0.00375569f
C5275 VDD_1 net28_3 0.00407683f
C5276 VDD_1 net28_4 0.00410677f
C5277 VDD_1 net28_5 0.00164017f
C5278 VDD_1 net28_6 0.00164017f
C5279 VDD_1 net28_7 0.000820084f
C5280 VDD_1 net28_8 0.00164017f
C5281 VDD_1 net28_9 0.00394348f
C5282 VDD_1 net2_2 0.00313707f
C5283 VDD_1 net2_3 0.00313707f
C5284 VDD_1 net2_4 0.00534065f
C5285 VDD_1 net2_6 0.00227212f
C5286 VDD_1 net2_7 0.00812028f
C5287 VDD_1 net3 0.00439487f
C5288 VDD_1 net3_11 0.00257642f
C5289 VDD_1 net3_2 0.00381282f
C5290 VDD_1 net3_3 0.00413884f
C5291 VDD_1 net3_4 0.00416924f
C5292 VDD_1 net3_5 0.00166512f
C5293 VDD_1 net3_6 0.00166512f
C5294 VDD_1 net3_7 0.000832558f
C5295 VDD_1 net3_8 0.00166512f
C5296 VDD_1 net3_9 0.00400346f
C5297 VDD_1 net6 0.00241969f
C5298 VDD_1 net67 0.00887926f
C5299 VDD_1 net68 0.00857134f
C5300 VDD_1 net69 0.00905833f
C5301 VDD_1 net6_2 0.00315187f
C5302 VDD_1 net6_3 0.00315187f
C5303 VDD_1 net6_4 0.00536585f
C5304 VDD_1 net6_6 0.00228284f
C5305 VDD_1 net6_7 0.0081586f
C5306 VDD_1 net7 0.00426794f
C5307 VDD_1 net70 0.00848309f
C5308 VDD_1 net71 0.00874906f
C5309 VDD_1 net72 0.00896008f
C5310 VDD_1 net73 0.008785f
C5311 VDD_1 net74 0.00912067f
C5312 VDD_1 net76 0.00238738f
C5313 VDD_1 net76_2 0.00310979f
C5314 VDD_1 net76_3 0.00310979f
C5315 VDD_1 net76_4 0.00225236f
C5316 VDD_1 net76_5 0.00529421f
C5317 VDD_1 net76_7 0.00804967f
C5318 VDD_1 net78 0.00878049f
C5319 VDD_1 net79 0.00238633f
C5320 VDD_1 net79_2 0.00310841f
C5321 VDD_1 net79_3 0.00310841f
C5322 VDD_1 net79_4 0.00225136f
C5323 VDD_1 net79_5 0.00529187f
C5324 VDD_1 net79_7 0.00804611f
C5325 VDD_1 net7_11 0.00250201f
C5326 VDD_1 net7_2 0.0037027f
C5327 VDD_1 net7_3 0.00401931f
C5328 VDD_1 net7_4 0.00404882f
C5329 VDD_1 net7_5 0.00161702f
C5330 VDD_1 net7_6 0.00161702f
C5331 VDD_1 net7_7 0.000808512f
C5332 VDD_1 net7_8 0.00161702f
C5333 VDD_1 net7_9 0.00388784f
C5334 VDD_1 net80 0.00865438f
C5335 VDD_1 net81 0.00238493f
C5336 VDD_1 net81_2 0.0031066f
C5337 VDD_1 net81_3 0.0031066f
C5338 VDD_1 net81_4 0.00225005f
C5339 VDD_1 net81_5 0.00528877f
C5340 VDD_1 net81_7 0.00804141f
C5341 VDD_1 net83 0.00937517f
C5342 VDD_1 net84 0.00241635f
C5343 VDD_1 net84_2 0.00314752f
C5344 VDD_1 net84_3 0.00314752f
C5345 VDD_1 net84_4 0.00227969f
C5346 VDD_1 net84_5 0.00535845f
C5347 VDD_1 net84_7 0.00814735f
C5348 VDD_1 net85 0.00853335f
C5349 VDD_1 net86 0.00237033f
C5350 VDD_1 net86_2 0.00308757f
C5351 VDD_1 net86_3 0.00308757f
C5352 VDD_1 net86_4 0.00223627f
C5353 VDD_1 net86_5 0.00525639f
C5354 VDD_1 net86_7 0.00799217f
C5355 VDD_1 net87 0.00884547f
C5356 VDD_1 net88 0.00237883f
C5357 VDD_1 net88_2 0.00309865f
C5358 VDD_1 net88_3 0.00309865f
C5359 VDD_1 net88_4 0.0022443f
C5360 VDD_1 net88_5 0.00527525f
C5361 VDD_1 net88_7 0.00802085f
C5362 VDD_1 net90 0.00900487f
C5363 VDD_1 net91 0.0023556f
C5364 VDD_1 net91_2 0.00306839f
C5365 VDD_1 net91_3 0.00306839f
C5366 VDD_1 net91_4 0.00222238f
C5367 VDD_1 net91_5 0.00522373f
C5368 VDD_1 net91_7 0.00794251f
C5369 VDD_1 net93 0.00888346f
C5370 VDD_1 net94 0.00240282f
C5371 VDD_1 net94_2 0.0031299f
C5372 VDD_1 net94_3 0.0031299f
C5373 VDD_1 net94_4 0.00226692f
C5374 VDD_1 net94_5 0.00532844f
C5375 VDD_1 net94_7 0.00810172f
C5376 VDD_1 net96 0.00897527f
C5377 VSS_0 VSS_2 0.310548f
C5378 VSS_0 WL_0 0.0083079f
C5379 VSS_0 WL_0_1 0.0199397f
C5380 VSS_0 WL_0_10 0.0359577f
C5381 VSS_0 WL_0_11 0.0326888f
C5382 VSS_0 WL_0_12 0.0359577f
C5383 VSS_0 WL_0_13 0.0359577f
C5384 VSS_0 WL_0_14 0.0359577f
C5385 VSS_0 WL_0_15 0.0784532f
C5386 VSS_0 WL_0_16 0.0165311f
C5387 VSS_0 WL_0_17 0.0165311f
C5388 VSS_0 WL_0_18 0.0165311f
C5389 VSS_0 WL_0_19 0.0165311f
C5390 VSS_0 WL_0_2 0.0217098f
C5391 VSS_0 WL_0_20 0.0165311f
C5392 VSS_0 WL_0_21 0.0165311f
C5393 VSS_0 WL_0_22 0.0165311f
C5394 VSS_0 WL_0_23 0.0165311f
C5395 VSS_0 WL_0_24 0.0165311f
C5396 VSS_0 WL_0_25 0.0165311f
C5397 VSS_0 WL_0_26 0.0165311f
C5398 VSS_0 WL_0_27 0.0165311f
C5399 VSS_0 WL_0_28 0.0165311f
C5400 VSS_0 WL_0_29 0.0165311f
C5401 VSS_0 WL_0_3 0.0217098f
C5402 VSS_0 WL_0_30 0.0165311f
C5403 VSS_0 WL_0_31 0.0165311f
C5404 VSS_0 WL_0_4 0.0217098f
C5405 VSS_0 WL_0_5 0.0217098f
C5406 VSS_0 WL_0_6 0.0217098f
C5407 VSS_0 WL_0_7 0.0217098f
C5408 VSS_0 WL_0_8 0.0217098f
C5409 VSS_0 WL_0_9 0.0228822f
C5410 VSS_0 WL_1 0.00803649f
C5411 VSS_0 WL_1_1 0.0192883f
C5412 VSS_0 WL_1_10 0.034783f
C5413 VSS_0 WL_1_11 0.0316209f
C5414 VSS_0 WL_1_12 0.034783f
C5415 VSS_0 WL_1_13 0.034783f
C5416 VSS_0 WL_1_14 0.034783f
C5417 VSS_0 WL_1_15 0.0758902f
C5418 VSS_0 WL_1_16 0.015991f
C5419 VSS_0 WL_1_17 0.015991f
C5420 VSS_0 WL_1_18 0.015991f
C5421 VSS_0 WL_1_19 0.015991f
C5422 VSS_0 WL_1_2 0.0210006f
C5423 VSS_0 WL_1_20 0.015991f
C5424 VSS_0 WL_1_21 0.015991f
C5425 VSS_0 WL_1_22 0.015991f
C5426 VSS_0 WL_1_23 0.015991f
C5427 VSS_0 WL_1_24 0.015991f
C5428 VSS_0 WL_1_25 0.015991f
C5429 VSS_0 WL_1_26 0.015991f
C5430 VSS_0 WL_1_27 0.015991f
C5431 VSS_0 WL_1_28 0.015991f
C5432 VSS_0 WL_1_29 0.015991f
C5433 VSS_0 WL_1_3 0.0210006f
C5434 VSS_0 WL_1_30 0.015991f
C5435 VSS_0 WL_1_31 0.015991f
C5436 VSS_0 WL_1_4 0.0210006f
C5437 VSS_0 WL_1_5 0.0210006f
C5438 VSS_0 WL_1_6 0.0210006f
C5439 VSS_0 WL_1_7 0.0210006f
C5440 VSS_0 WL_1_8 0.0210006f
C5441 VSS_0 WL_1_9 0.0221346f
C5442 VSS_0 XB_0_0 0.00893434f
C5443 VSS_0 XB_0_0_1 0.0373491f
C5444 VSS_0 XB_0_0_2 0.00527885f
C5445 VSS_0 XB_0_0_3 0.0105577f
C5446 VSS_0 XB_0_1 0.00907426f
C5447 VSS_0 XB_0_1_1 0.037934f
C5448 VSS_0 XB_0_1_2 0.00536152f
C5449 VSS_0 XB_0_1_3 0.010723f
C5450 VSS_0 XB_0_2 0.00901791f
C5451 VSS_0 XB_0_2_1 0.0376984f
C5452 VSS_0 XB_0_2_2 0.00532823f
C5453 VSS_0 XB_0_2_3 0.0106565f
C5454 VSS_0 XB_0_3 0.00911733f
C5455 VSS_0 XB_0_3_1 0.038114f
C5456 VSS_0 XB_0_3_2 0.00538697f
C5457 VSS_0 XB_0_3_3 0.0107739f
C5458 VSS_0 XB_0_4 0.00899677f
C5459 VSS_0 XB_0_4_1 0.03761f
C5460 VSS_0 XB_0_4_2 0.00531574f
C5461 VSS_0 XB_0_4_3 0.0106315f
C5462 VSS_0 XB_0_5 0.0091295f
C5463 VSS_0 XB_0_5_1 0.0381649f
C5464 VSS_0 XB_0_5_2 0.00539416f
C5465 VSS_0 XB_0_5_3 0.0107883f
C5466 VSS_0 XB_0_6 0.00901951f
C5467 VSS_0 XB_0_6_1 0.0377051f
C5468 VSS_0 XB_0_6_2 0.00532917f
C5469 VSS_0 XB_0_6_3 0.0106583f
C5470 VSS_0 XB_0_7 0.00966673f
C5471 VSS_0 XB_0_7_1 0.0404107f
C5472 VSS_0 XB_0_7_2 0.00571158f
C5473 VSS_0 XB_0_7_3 0.0114232f
C5474 VSS_0 XB_1_0 0.00677353f
C5475 VSS_0 XB_1_0_1 0.028316f
C5476 VSS_0 XB_1_0_2 0.00400214f
C5477 VSS_0 XB_1_0_3 0.00800428f
C5478 VSS_0 XB_1_1 0.00683731f
C5479 VSS_0 XB_1_1_1 0.0285826f
C5480 VSS_0 XB_1_1_2 0.00403982f
C5481 VSS_0 XB_1_1_3 0.00807965f
C5482 VSS_0 XB_1_2 0.00686586f
C5483 VSS_0 XB_1_2_1 0.028702f
C5484 VSS_0 XB_1_2_2 0.00405669f
C5485 VSS_0 XB_1_2_3 0.00811338f
C5486 VSS_0 XB_1_3 0.00682538f
C5487 VSS_0 XB_1_3_1 0.0285328f
C5488 VSS_0 XB_1_3_2 0.00403277f
C5489 VSS_0 XB_1_3_3 0.00806555f
C5490 VSS_0 XB_1_4 0.0068052f
C5491 VSS_0 XB_1_4_1 0.0284484f
C5492 VSS_0 XB_1_4_2 0.00402085f
C5493 VSS_0 XB_1_4_3 0.0080417f
C5494 VSS_0 XB_1_5 0.00684607f
C5495 VSS_0 XB_1_5_1 0.0286192f
C5496 VSS_0 XB_1_5_2 0.004045f
C5497 VSS_0 XB_1_5_3 0.00808999f
C5498 VSS_0 XB_1_6 0.00673479f
C5499 VSS_0 XB_1_6_1 0.0281541f
C5500 VSS_0 XB_1_6_2 0.00397925f
C5501 VSS_0 XB_1_6_3 0.0079585f
C5502 VSS_0 XB_1_7 0.00749326f
C5503 VSS_0 XB_1_7_1 0.0313248f
C5504 VSS_0 XB_1_7_2 0.00442739f
C5505 VSS_0 XB_1_7_3 0.00885478f
C5506 VSS_0 net10 0.0063026f
C5507 VSS_0 net10_2 0.00820973f
C5508 VSS_0 net10_3 0.00820973f
C5509 VSS_0 net10_4 0.0139765f
C5510 VSS_0 net10_6 0.00594615f
C5511 VSS_0 net10_7 0.0212509f
C5512 VSS_0 net11 0.0196143f
C5513 VSS_0 net11_11 0.0114985f
C5514 VSS_0 net11_2 0.0170166f
C5515 VSS_0 net11_3 0.0184717f
C5516 VSS_0 net11_4 0.0186073f
C5517 VSS_0 net11_5 0.00743141f
C5518 VSS_0 net11_6 0.00743141f
C5519 VSS_0 net11_7 0.00371571f
C5520 VSS_0 net11_8 0.00743141f
C5521 VSS_0 net11_9 0.0178674f
C5522 VSS_0 net13 0.00636437f
C5523 VSS_0 net130 0.0120766f
C5524 VSS_0 net130_10 0.011001f
C5525 VSS_0 net130_2 0.0104771f
C5526 VSS_0 net130_3 0.011373f
C5527 VSS_0 net130_4 0.0114565f
C5528 VSS_0 net130_5 0.00457553f
C5529 VSS_0 net130_6 0.00457553f
C5530 VSS_0 net130_7 0.00228776f
C5531 VSS_0 net130_8 0.00457553f
C5532 VSS_0 net130_9 0.00707966f
C5533 VSS_0 net132 0.011763f
C5534 VSS_0 net132_10 0.0107154f
C5535 VSS_0 net132_2 0.0102051f
C5536 VSS_0 net132_3 0.0110778f
C5537 VSS_0 net132_4 0.0111591f
C5538 VSS_0 net132_5 0.00445674f
C5539 VSS_0 net132_6 0.00445674f
C5540 VSS_0 net132_7 0.00222837f
C5541 VSS_0 net132_8 0.00445674f
C5542 VSS_0 net132_9 0.00689587f
C5543 VSS_0 net134 0.0116466f
C5544 VSS_0 net134_10 0.0106093f
C5545 VSS_0 net134_2 0.0101041f
C5546 VSS_0 net134_3 0.0109681f
C5547 VSS_0 net134_4 0.0110487f
C5548 VSS_0 net134_5 0.00441263f
C5549 VSS_0 net134_6 0.00441263f
C5550 VSS_0 net134_7 0.00220631f
C5551 VSS_0 net134_8 0.00441263f
C5552 VSS_0 net134_9 0.00682761f
C5553 VSS_0 net135 0.0117701f
C5554 VSS_0 net135_10 0.0107219f
C5555 VSS_0 net135_2 0.0102113f
C5556 VSS_0 net135_3 0.0110845f
C5557 VSS_0 net135_4 0.0111659f
C5558 VSS_0 net135_5 0.00445944f
C5559 VSS_0 net135_6 0.00445944f
C5560 VSS_0 net135_7 0.00222972f
C5561 VSS_0 net135_8 0.00445944f
C5562 VSS_0 net135_9 0.00690004f
C5563 VSS_0 net137 0.011905f
C5564 VSS_0 net137_10 0.0108447f
C5565 VSS_0 net137_2 0.0103283f
C5566 VSS_0 net137_3 0.0112115f
C5567 VSS_0 net137_4 0.0112938f
C5568 VSS_0 net137_5 0.00451054f
C5569 VSS_0 net137_6 0.00451054f
C5570 VSS_0 net137_7 0.00225527f
C5571 VSS_0 net137_8 0.00451054f
C5572 VSS_0 net137_9 0.00697911f
C5573 VSS_0 net139 0.0116843f
C5574 VSS_0 net139_10 0.0106437f
C5575 VSS_0 net139_2 0.0101369f
C5576 VSS_0 net139_3 0.0110037f
C5577 VSS_0 net139_4 0.0110845f
C5578 VSS_0 net139_5 0.00442693f
C5579 VSS_0 net139_6 0.00442693f
C5580 VSS_0 net139_7 0.00221346f
C5581 VSS_0 net139_8 0.00442693f
C5582 VSS_0 net139_9 0.00684974f
C5583 VSS_0 net13_2 0.00829018f
C5584 VSS_0 net13_3 0.00829018f
C5585 VSS_0 net13_4 0.0141135f
C5586 VSS_0 net13_6 0.00600442f
C5587 VSS_0 net13_7 0.0214591f
C5588 VSS_0 net14 0.0196763f
C5589 VSS_0 net141 0.0118557f
C5590 VSS_0 net141_10 0.0107999f
C5591 VSS_0 net141_2 0.0102856f
C5592 VSS_0 net141_3 0.0111651f
C5593 VSS_0 net141_4 0.0112471f
C5594 VSS_0 net141_5 0.00449187f
C5595 VSS_0 net141_6 0.00449187f
C5596 VSS_0 net141_7 0.00224593f
C5597 VSS_0 net141_8 0.00449187f
C5598 VSS_0 net141_9 0.00695022f
C5599 VSS_0 net142 0.0119875f
C5600 VSS_0 net142_10 0.0109199f
C5601 VSS_0 net142_2 0.0103999f
C5602 VSS_0 net142_3 0.0112892f
C5603 VSS_0 net142_4 0.0113721f
C5604 VSS_0 net142_5 0.00454179f
C5605 VSS_0 net142_6 0.00454179f
C5606 VSS_0 net142_7 0.0022709f
C5607 VSS_0 net142_8 0.00454179f
C5608 VSS_0 net142_9 0.00702747f
C5609 VSS_0 net14_11 0.0115349f
C5610 VSS_0 net14_2 0.0170704f
C5611 VSS_0 net14_3 0.01853f
C5612 VSS_0 net14_4 0.0186661f
C5613 VSS_0 net14_5 0.00745488f
C5614 VSS_0 net14_6 0.00745488f
C5615 VSS_0 net14_7 0.00372744f
C5616 VSS_0 net14_8 0.00745488f
C5617 VSS_0 net14_9 0.0179239f
C5618 VSS_0 net16 0.00638087f
C5619 VSS_0 net16_2 0.00831169f
C5620 VSS_0 net16_3 0.00831169f
C5621 VSS_0 net16_4 0.0141501f
C5622 VSS_0 net16_6 0.00602f
C5623 VSS_0 net16_7 0.0215148f
C5624 VSS_0 net17 0.0197248f
C5625 VSS_0 net17_11 0.0115633f
C5626 VSS_0 net17_2 0.0171125f
C5627 VSS_0 net17_3 0.0185757f
C5628 VSS_0 net17_4 0.0187121f
C5629 VSS_0 net17_5 0.00747328f
C5630 VSS_0 net17_6 0.00747328f
C5631 VSS_0 net17_7 0.00373664f
C5632 VSS_0 net17_8 0.00747328f
C5633 VSS_0 net17_9 0.0179681f
C5634 VSS_0 net19 0.00627183f
C5635 VSS_0 net19_2 0.00816965f
C5636 VSS_0 net19_3 0.00816965f
C5637 VSS_0 net19_4 0.0139083f
C5638 VSS_0 net19_6 0.00591712f
C5639 VSS_0 net19_7 0.0211471f
C5640 VSS_0 net2 0.00632693f
C5641 VSS_0 net20 0.0195426f
C5642 VSS_0 net20_11 0.0114565f
C5643 VSS_0 net20_2 0.0169544f
C5644 VSS_0 net20_3 0.0184041f
C5645 VSS_0 net20_4 0.0185392f
C5646 VSS_0 net20_5 0.00740423f
C5647 VSS_0 net20_6 0.00740423f
C5648 VSS_0 net20_7 0.00370211f
C5649 VSS_0 net20_8 0.00740423f
C5650 VSS_0 net20_9 0.0178021f
C5651 VSS_0 net23 0.00641589f
C5652 VSS_0 net23_2 0.0083573f
C5653 VSS_0 net23_3 0.0083573f
C5654 VSS_0 net23_4 0.0142277f
C5655 VSS_0 net23_6 0.00605303f
C5656 VSS_0 net23_7 0.0216328f
C5657 VSS_0 net24 0.0197389f
C5658 VSS_0 net24_11 0.0115716f
C5659 VSS_0 net24_2 0.0171247f
C5660 VSS_0 net24_3 0.018589f
C5661 VSS_0 net24_4 0.0187255f
C5662 VSS_0 net24_5 0.00747862f
C5663 VSS_0 net24_6 0.00747862f
C5664 VSS_0 net24_7 0.00373931f
C5665 VSS_0 net24_8 0.00747862f
C5666 VSS_0 net24_9 0.0179809f
C5667 VSS_0 net27 0.00630736f
C5668 VSS_0 net27_2 0.00821593f
C5669 VSS_0 net27_3 0.00821593f
C5670 VSS_0 net27_4 0.0139871f
C5671 VSS_0 net27_6 0.00595064f
C5672 VSS_0 net27_7 0.0212669f
C5673 VSS_0 net28 0.0196379f
C5674 VSS_0 net28_11 0.0115124f
C5675 VSS_0 net28_2 0.0170371f
C5676 VSS_0 net28_3 0.0184938f
C5677 VSS_0 net28_4 0.0186296f
C5678 VSS_0 net28_5 0.00744034f
C5679 VSS_0 net28_6 0.00744034f
C5680 VSS_0 net28_7 0.00372017f
C5681 VSS_0 net28_8 0.00744034f
C5682 VSS_0 net28_9 0.0178889f
C5683 VSS_0 net2_2 0.00824142f
C5684 VSS_0 net2_3 0.00824142f
C5685 VSS_0 net2_4 0.0140305f
C5686 VSS_0 net2_6 0.0059691f
C5687 VSS_0 net2_7 0.0213329f
C5688 VSS_0 net3 0.0198772f
C5689 VSS_0 net3_11 0.0116527f
C5690 VSS_0 net3_2 0.0172447f
C5691 VSS_0 net3_3 0.0187192f
C5692 VSS_0 net3_4 0.0188567f
C5693 VSS_0 net3_5 0.00753101f
C5694 VSS_0 net3_6 0.00753101f
C5695 VSS_0 net3_7 0.0037655f
C5696 VSS_0 net3_8 0.00753101f
C5697 VSS_0 net3_9 0.0181069f
C5698 VSS_0 net6 0.00628649f
C5699 VSS_0 net67 0.000410748f
C5700 VSS_0 net68 0.000432329f
C5701 VSS_0 net69 0.000387123f
C5702 VSS_0 net6_2 0.00818874f
C5703 VSS_0 net6_3 0.00818874f
C5704 VSS_0 net6_4 0.0139408f
C5705 VSS_0 net6_6 0.00593095f
C5706 VSS_0 net6_7 0.0211965f
C5707 VSS_0 net7 0.0196347f
C5708 VSS_0 net70 0.000568286f
C5709 VSS_0 net71 0.000347061f
C5710 VSS_0 net72 0.000604042f
C5711 VSS_0 net73 0.000414099f
C5712 VSS_0 net74 0.000450893f
C5713 VSS_0 net76 0.00290455f
C5714 VSS_0 net76_2 0.00378345f
C5715 VSS_0 net76_3 0.00378345f
C5716 VSS_0 net76_4 0.00274028f
C5717 VSS_0 net76_5 0.00644108f
C5718 VSS_0 net76_7 0.00979345f
C5719 VSS_0 net78 0.000307342f
C5720 VSS_0 net79 0.0028627f
C5721 VSS_0 net79_2 0.00372894f
C5722 VSS_0 net79_3 0.00372894f
C5723 VSS_0 net79_4 0.0027008f
C5724 VSS_0 net79_5 0.00634827f
C5725 VSS_0 net79_7 0.00965234f
C5726 VSS_0 net7_11 0.0115105f
C5727 VSS_0 net7_2 0.0170343f
C5728 VSS_0 net7_3 0.0184908f
C5729 VSS_0 net7_4 0.0186266f
C5730 VSS_0 net7_5 0.00743912f
C5731 VSS_0 net7_6 0.00743912f
C5732 VSS_0 net7_7 0.00371956f
C5733 VSS_0 net7_8 0.00743912f
C5734 VSS_0 net7_9 0.017886f
C5735 VSS_0 net80 0.000350259f
C5736 VSS_0 net81 0.00289078f
C5737 VSS_0 net81_2 0.00376551f
C5738 VSS_0 net81_3 0.00376551f
C5739 VSS_0 net81_4 0.00272729f
C5740 VSS_0 net81_5 0.00641053f
C5741 VSS_0 net81_7 0.00974701f
C5742 VSS_0 net83 0.000246769f
C5743 VSS_0 net84 0.00293785f
C5744 VSS_0 net84_2 0.00382682f
C5745 VSS_0 net84_3 0.00382682f
C5746 VSS_0 net84_4 0.0027717f
C5747 VSS_0 net84_5 0.00651491f
C5748 VSS_0 net84_7 0.00990572f
C5749 VSS_0 net85 0.000425806f
C5750 VSS_0 net86 0.00297343f
C5751 VSS_0 net86_2 0.00387318f
C5752 VSS_0 net86_3 0.00387318f
C5753 VSS_0 net86_4 0.00280527f
C5754 VSS_0 net86_5 0.00659382f
C5755 VSS_0 net86_7 0.0100257f
C5756 VSS_0 net87 0.000283764f
C5757 VSS_0 net88 0.00287253f
C5758 VSS_0 net88_2 0.00374174f
C5759 VSS_0 net88_3 0.00374174f
C5760 VSS_0 net88_4 0.00271007f
C5761 VSS_0 net88_5 0.00637007f
C5762 VSS_0 net88_7 0.00968549f
C5763 VSS_0 net90 0.00048025f
C5764 VSS_0 net91 0.00299433f
C5765 VSS_0 net91_2 0.0039004f
C5766 VSS_0 net91_3 0.0039004f
C5767 VSS_0 net91_4 0.00282498f
C5768 VSS_0 net91_5 0.00664017f
C5769 VSS_0 net91_7 0.0100962f
C5770 VSS_0 net93 0.000321483f
C5771 VSS_0 net94 0.00287498f
C5772 VSS_0 net94_2 0.00374494f
C5773 VSS_0 net94_3 0.00374494f
C5774 VSS_0 net94_4 0.00271239f
C5775 VSS_0 net94_5 0.0063755f
C5776 VSS_0 net94_7 0.00969375f
C5777 VSS_0 net96 0.000398059f
C5778 VSS_2 WL_0 1.48216e-05f
C5779 VSS_2 WL_0_1 3.5573e-05f
C5780 VSS_2 WL_0_10 6.41496e-05f
C5781 VSS_2 WL_0_11 5.83178e-05f
C5782 VSS_2 WL_0_12 6.41496e-05f
C5783 VSS_2 WL_0_13 6.41496e-05f
C5784 VSS_2 WL_0_14 6.41496e-05f
C5785 VSS_2 WL_0_15 0.000139963f
C5786 VSS_2 WL_0_16 2.94919e-05f
C5787 VSS_2 WL_0_17 2.94919e-05f
C5788 VSS_2 WL_0_18 2.94919e-05f
C5789 VSS_2 WL_0_19 2.94919e-05f
C5790 VSS_2 WL_0_2 3.8731e-05f
C5791 VSS_2 WL_0_20 2.94919e-05f
C5792 VSS_2 WL_0_21 2.94919e-05f
C5793 VSS_2 WL_0_22 2.94919e-05f
C5794 VSS_2 WL_0_23 2.94919e-05f
C5795 VSS_2 WL_0_24 2.94919e-05f
C5796 VSS_2 WL_0_25 2.94919e-05f
C5797 VSS_2 WL_0_26 2.94919e-05f
C5798 VSS_2 WL_0_27 2.94919e-05f
C5799 VSS_2 WL_0_28 2.94919e-05f
C5800 VSS_2 WL_0_29 2.94919e-05f
C5801 VSS_2 WL_0_3 3.8731e-05f
C5802 VSS_2 WL_0_30 2.94919e-05f
C5803 VSS_2 WL_0_31 2.94919e-05f
C5804 VSS_2 WL_0_4 3.8731e-05f
C5805 VSS_2 WL_0_5 3.8731e-05f
C5806 VSS_2 WL_0_6 3.8731e-05f
C5807 VSS_2 WL_0_7 3.8731e-05f
C5808 VSS_2 WL_0_8 3.8731e-05f
C5809 VSS_2 WL_0_9 4.08225e-05f
C5810 VSS_2 WL_1 0.000287958f
C5811 VSS_2 WL_1_1 0.000691124f
C5812 VSS_2 WL_1_10 0.00124632f
C5813 VSS_2 WL_1_11 0.00113302f
C5814 VSS_2 WL_1_12 0.00124632f
C5815 VSS_2 WL_1_13 0.00124632f
C5816 VSS_2 WL_1_14 0.00124632f
C5817 VSS_2 WL_1_15 0.00271924f
C5818 VSS_2 WL_1_16 0.000572979f
C5819 VSS_2 WL_1_17 0.000572979f
C5820 VSS_2 WL_1_18 0.000572979f
C5821 VSS_2 WL_1_19 0.000572979f
C5822 VSS_2 WL_1_2 0.000752478f
C5823 VSS_2 WL_1_20 0.000572979f
C5824 VSS_2 WL_1_21 0.000572979f
C5825 VSS_2 WL_1_22 0.000572979f
C5826 VSS_2 WL_1_23 0.000572979f
C5827 VSS_2 WL_1_24 0.000572979f
C5828 VSS_2 WL_1_25 0.000572979f
C5829 VSS_2 WL_1_26 0.000572979f
C5830 VSS_2 WL_1_27 0.000572979f
C5831 VSS_2 WL_1_28 0.000572979f
C5832 VSS_2 WL_1_29 0.000572979f
C5833 VSS_2 WL_1_3 0.000752478f
C5834 VSS_2 WL_1_30 0.000572979f
C5835 VSS_2 WL_1_31 0.000572979f
C5836 VSS_2 WL_1_4 0.000752478f
C5837 VSS_2 WL_1_5 0.000752478f
C5838 VSS_2 WL_1_6 0.000752478f
C5839 VSS_2 WL_1_7 0.000752478f
C5840 VSS_2 WL_1_8 0.000752478f
C5841 VSS_2 WL_1_9 0.000793113f
C5842 VSS_2 XB_0_0 2.19443e-05f
C5843 VSS_2 XB_0_0_1 9.17358e-05f
C5844 VSS_2 XB_0_0_2 1.29658e-05f
C5845 VSS_2 XB_0_0_3 2.59316e-05f
C5846 VSS_2 XB_0_2 3.466e-05f
C5847 VSS_2 XB_0_2_1 0.000144892f
C5848 VSS_2 XB_0_2_2 2.04789e-05f
C5849 VSS_2 XB_0_2_3 4.09577e-05f
C5850 VSS_2 XB_0_3_1 3.79919e-05f
C5851 VSS_2 XB_0_3_3 1.07394e-05f
C5852 VSS_2 XB_0_4 2.88245e-05f
C5853 VSS_2 XB_0_4_1 0.000120498f
C5854 VSS_2 XB_0_4_2 1.70309e-05f
C5855 VSS_2 XB_0_4_3 3.40619e-05f
C5856 VSS_2 XB_0_6 3.98339e-05f
C5857 VSS_2 XB_0_6_1 0.000166521f
C5858 VSS_2 XB_0_6_2 2.35358e-05f
C5859 VSS_2 XB_0_6_3 4.70717e-05f
C5860 VSS_2 XB_1_0 0.00228056f
C5861 VSS_2 XB_1_0_1 0.00953364f
C5862 VSS_2 XB_1_0_2 0.00134747f
C5863 VSS_2 XB_1_0_3 0.00269494f
C5864 VSS_2 XB_1_1 0.00224841f
C5865 VSS_2 XB_1_1_1 0.00939923f
C5866 VSS_2 XB_1_1_2 0.00132847f
C5867 VSS_2 XB_1_1_3 0.00265694f
C5868 VSS_2 XB_1_2 0.00224553f
C5869 VSS_2 XB_1_2_1 0.0093872f
C5870 VSS_2 XB_1_2_2 0.00132677f
C5871 VSS_2 XB_1_2_3 0.00265354f
C5872 VSS_2 XB_1_3 0.00220077f
C5873 VSS_2 XB_1_3_1 0.0092001f
C5874 VSS_2 XB_1_3_2 0.00130033f
C5875 VSS_2 XB_1_3_3 0.00260065f
C5876 VSS_2 XB_1_4 0.00222919f
C5877 VSS_2 XB_1_4_1 0.0093189f
C5878 VSS_2 XB_1_4_2 0.00131712f
C5879 VSS_2 XB_1_4_3 0.00263424f
C5880 VSS_2 XB_1_5 0.00220058f
C5881 VSS_2 XB_1_5_1 0.00919929f
C5882 VSS_2 XB_1_5_2 0.00130021f
C5883 VSS_2 XB_1_5_3 0.00260042f
C5884 VSS_2 XB_1_6 0.00223846f
C5885 VSS_2 XB_1_6_1 0.00935765f
C5886 VSS_2 XB_1_6_2 0.00132259f
C5887 VSS_2 XB_1_6_3 0.00264519f
C5888 VSS_2 XB_1_7 0.00229993f
C5889 VSS_2 XB_1_7_1 0.00961462f
C5890 VSS_2 XB_1_7_2 0.00135891f
C5891 VSS_2 XB_1_7_3 0.00271783f
C5892 VSS_2 net130 0.00777653f
C5893 VSS_2 net130_10 0.00708395f
C5894 VSS_2 net130_2 0.00674662f
C5895 VSS_2 net130_3 0.0073235f
C5896 VSS_2 net130_4 0.00737728f
C5897 VSS_2 net130_5 0.00294635f
C5898 VSS_2 net130_6 0.00294635f
C5899 VSS_2 net130_7 0.00147317f
C5900 VSS_2 net130_8 0.00294635f
C5901 VSS_2 net130_9 0.00455885f
C5902 VSS_2 net132 0.00772559f
C5903 VSS_2 net132_10 0.00703754f
C5904 VSS_2 net132_2 0.00670242f
C5905 VSS_2 net132_3 0.00727553f
C5906 VSS_2 net132_4 0.00732895f
C5907 VSS_2 net132_5 0.00292705f
C5908 VSS_2 net132_6 0.00292705f
C5909 VSS_2 net132_7 0.00146352f
C5910 VSS_2 net132_8 0.00292705f
C5911 VSS_2 net132_9 0.00452899f
C5912 VSS_2 net134 0.00768739f
C5913 VSS_2 net134_10 0.00700274f
C5914 VSS_2 net134_2 0.00666927f
C5915 VSS_2 net134_3 0.00723955f
C5916 VSS_2 net134_4 0.00729271f
C5917 VSS_2 net134_5 0.00291257f
C5918 VSS_2 net134_6 0.00291257f
C5919 VSS_2 net134_7 0.00145629f
C5920 VSS_2 net134_8 0.00291257f
C5921 VSS_2 net134_9 0.00450659f
C5922 VSS_2 net135 0.00768408f
C5923 VSS_2 net135_10 0.00699973f
C5924 VSS_2 net135_2 0.00666641f
C5925 VSS_2 net135_3 0.00723643f
C5926 VSS_2 net135_4 0.00728957f
C5927 VSS_2 net135_5 0.00291132f
C5928 VSS_2 net135_6 0.00291132f
C5929 VSS_2 net135_7 0.00145566f
C5930 VSS_2 net135_8 0.00291132f
C5931 VSS_2 net135_9 0.00450466f
C5932 VSS_2 net137 0.00766949f
C5933 VSS_2 net137_10 0.00698644f
C5934 VSS_2 net137_2 0.00665375f
C5935 VSS_2 net137_3 0.0072227f
C5936 VSS_2 net137_4 0.00727573f
C5937 VSS_2 net137_5 0.00290579f
C5938 VSS_2 net137_6 0.00290579f
C5939 VSS_2 net137_7 0.0014529f
C5940 VSS_2 net137_8 0.00290579f
C5941 VSS_2 net137_9 0.0044961f
C5942 VSS_2 net139 0.0076173f
C5943 VSS_2 net139_10 0.00693889f
C5944 VSS_2 net139_2 0.00660847f
C5945 VSS_2 net139_3 0.00717354f
C5946 VSS_2 net139_4 0.00722622f
C5947 VSS_2 net139_5 0.00288602f
C5948 VSS_2 net139_6 0.00288602f
C5949 VSS_2 net139_7 0.00144301f
C5950 VSS_2 net139_8 0.00288602f
C5951 VSS_2 net139_9 0.00446551f
C5952 VSS_2 net13_4 1.29097e-05f
C5953 VSS_2 net13_7 1.96288e-05f
C5954 VSS_2 net141 0.00775294f
C5955 VSS_2 net141_10 0.00706245f
C5956 VSS_2 net141_2 0.00672614f
C5957 VSS_2 net141_3 0.00730128f
C5958 VSS_2 net141_4 0.00735489f
C5959 VSS_2 net141_5 0.00293741f
C5960 VSS_2 net141_6 0.00293741f
C5961 VSS_2 net141_7 0.0014687f
C5962 VSS_2 net141_8 0.00293741f
C5963 VSS_2 net141_9 0.00454502f
C5964 VSS_2 net142 0.00769085f
C5965 VSS_2 net142_10 0.00700589f
C5966 VSS_2 net142_2 0.00667228f
C5967 VSS_2 net142_3 0.00724281f
C5968 VSS_2 net142_4 0.00729599f
C5969 VSS_2 net142_5 0.00291388f
C5970 VSS_2 net142_6 0.00291388f
C5971 VSS_2 net142_7 0.00145694f
C5972 VSS_2 net142_8 0.00291388f
C5973 VSS_2 net142_9 0.00450862f
C5974 VSS_2 net17 2.03818e-05f
C5975 VSS_2 net17_11 1.19485e-05f
C5976 VSS_2 net17_2 1.76824e-05f
C5977 VSS_2 net17_3 1.91944e-05f
C5978 VSS_2 net17_4 1.93353e-05f
C5979 VSS_2 net17_9 1.85665e-05f
C5980 VSS_2 net24 3.23457e-05f
C5981 VSS_2 net24_11 1.89621e-05f
C5982 VSS_2 net24_2 2.80619e-05f
C5983 VSS_2 net24_3 3.04614e-05f
C5984 VSS_2 net24_4 3.06851e-05f
C5985 VSS_2 net24_5 1.2255e-05f
C5986 VSS_2 net24_6 1.2255e-05f
C5987 VSS_2 net24_8 1.2255e-05f
C5988 VSS_2 net24_9 2.9465e-05f
C5989 VSS_2 net2_7 1.06197e-05f
C5990 VSS_2 net3 3.19111e-05f
C5991 VSS_2 net3_11 1.87073e-05f
C5992 VSS_2 net3_2 2.76849e-05f
C5993 VSS_2 net3_3 3.00521e-05f
C5994 VSS_2 net3_4 3.02728e-05f
C5995 VSS_2 net3_5 1.20904e-05f
C5996 VSS_2 net3_6 1.20904e-05f
C5997 VSS_2 net3_8 1.20904e-05f
C5998 VSS_2 net3_9 2.90691e-05f
C5999 VSS_2 net67 0.00010013f
C6000 VSS_2 net69 6.65578e-05f
C6001 VSS_2 net71 6.70449e-05f
C6002 VSS_2 net73 0.000127168f
C6003 VSS_2 net76 0.00343526f
C6004 VSS_2 net76_2 0.00447475f
C6005 VSS_2 net76_3 0.00447475f
C6006 VSS_2 net76_4 0.00324098f
C6007 VSS_2 net76_5 0.00761797f
C6008 VSS_2 net76_7 0.0115829f
C6009 VSS_2 net78 7.8029e-05f
C6010 VSS_2 net79 0.0034288f
C6011 VSS_2 net79_2 0.00446634f
C6012 VSS_2 net79_3 0.00446634f
C6013 VSS_2 net79_4 0.00323488f
C6014 VSS_2 net79_5 0.00760364f
C6015 VSS_2 net79_7 0.0115611f
C6016 VSS_2 net81 0.00340439f
C6017 VSS_2 net81_2 0.00443454f
C6018 VSS_2 net81_3 0.00443454f
C6019 VSS_2 net81_4 0.00321185f
C6020 VSS_2 net81_5 0.00754951f
C6021 VSS_2 net81_7 0.0114788f
C6022 VSS_2 net83 0.0001319f
C6023 VSS_2 net84 0.00341184f
C6024 VSS_2 net84_2 0.00444424f
C6025 VSS_2 net84_3 0.00444424f
C6026 VSS_2 net84_4 0.00321888f
C6027 VSS_2 net84_5 0.00756603f
C6028 VSS_2 net84_7 0.0115039f
C6029 VSS_2 net86 0.00337568f
C6030 VSS_2 net86_2 0.00439713f
C6031 VSS_2 net86_3 0.00439713f
C6032 VSS_2 net86_4 0.00318476f
C6033 VSS_2 net86_5 0.00748583f
C6034 VSS_2 net86_7 0.011382f
C6035 VSS_2 net87 0.000114223f
C6036 VSS_2 net88 0.00337603f
C6037 VSS_2 net88_2 0.00439759f
C6038 VSS_2 net88_3 0.00439759f
C6039 VSS_2 net88_4 0.00318509f
C6040 VSS_2 net88_5 0.00748661f
C6041 VSS_2 net88_7 0.0113831f
C6042 VSS_2 net91 0.00340381f
C6043 VSS_2 net91_2 0.00443378f
C6044 VSS_2 net91_3 0.00443378f
C6045 VSS_2 net91_4 0.0032113f
C6046 VSS_2 net91_5 0.00754821f
C6047 VSS_2 net91_7 0.0114768f
C6048 VSS_2 net93 0.000158406f
C6049 VSS_2 net94 0.00339344f
C6050 VSS_2 net94_2 0.00442028f
C6051 VSS_2 net94_3 0.00442028f
C6052 VSS_2 net94_4 0.00320152f
C6053 VSS_2 net94_5 0.00752522f
C6054 VSS_2 net94_7 0.0114419f
C6055 WL_0 WL_1 0.000264093f
C6056 WL_0 XB_0_0 5.78179e-05f
C6057 WL_0 XB_0_1 5.98916e-05f
C6058 WL_0 XB_0_2 6.1649e-05f
C6059 WL_0 XB_0_3 6.17364e-05f
C6060 WL_0 XB_0_4 6.00377e-05f
C6061 WL_0 XB_0_5 6.05629e-05f
C6062 WL_0 XB_0_6 6.18307e-05f
C6063 WL_0 XB_0_7 6.0855e-05f
C6064 WL_0 net10_6 0.000755157f
C6065 WL_0 net11 0.00108167f
C6066 WL_0 net13_6 0.000753916f
C6067 WL_0 net14 0.00108536f
C6068 WL_0 net16_6 0.000757671f
C6069 WL_0 net17 0.00108235f
C6070 WL_0 net19_4 0.000758147f
C6071 WL_0 net20 0.00108787f
C6072 WL_0 net23_4 0.000754199f
C6073 WL_0 net24 0.00108577f
C6074 WL_0 net27_4 0.000750684f
C6075 WL_0 net28 0.00108369f
C6076 WL_0 net2_6 0.00075537f
C6077 WL_0 net3 0.00108195f
C6078 WL_0 net6_6 0.000755052f
C6079 WL_0 net7 0.00108719f
C6080 WL_0_1 WL_1_1 0.000633847f
C6081 WL_0_1 XB_0_0 0.000138768f
C6082 WL_0_1 XB_0_1 0.000143745f
C6083 WL_0_1 XB_0_2 0.000147963f
C6084 WL_0_1 XB_0_3 0.000148173f
C6085 WL_0_1 XB_0_4 0.000144096f
C6086 WL_0_1 XB_0_5 0.000145356f
C6087 WL_0_1 XB_0_6 0.000148399f
C6088 WL_0_1 XB_0_7 0.000146057f
C6089 WL_0_1 net10_6 0.00181244f
C6090 WL_0_1 net11 0.00259609f
C6091 WL_0_1 net130_6 2.15901e-05f
C6092 WL_0_1 net132_6 1.11051e-05f
C6093 WL_0_1 net134_6 1.38298e-05f
C6094 WL_0_1 net135_6 1.4003e-05f
C6095 WL_0_1 net137_6 1.15509e-05f
C6096 WL_0_1 net139_6 1.12574e-05f
C6097 WL_0_1 net13_6 0.00180946f
C6098 WL_0_1 net14 0.00260495f
C6099 WL_0_1 net141_6 1.24136e-05f
C6100 WL_0_1 net142_6 1.71551e-05f
C6101 WL_0_1 net16_6 0.00181848f
C6102 WL_0_1 net17 0.00259774f
C6103 WL_0_1 net19_6 0.00181962f
C6104 WL_0_1 net2 0.00181295f
C6105 WL_0_1 net20 0.00261098f
C6106 WL_0_1 net23_4 0.00181014f
C6107 WL_0_1 net24 0.00260593f
C6108 WL_0_1 net27_4 0.0018017f
C6109 WL_0_1 net28 0.00260095f
C6110 WL_0_1 net3 0.00259678f
C6111 WL_0_1 net67 2.13976e-05f
C6112 WL_0_1 net68 1.41572e-05f
C6113 WL_0_1 net69 2.18164e-05f
C6114 WL_0_1 net6_6 0.00181219f
C6115 WL_0_1 net7 0.00260935f
C6116 WL_0_1 net70 1.5263e-05f
C6117 WL_0_1 net71 1.92364e-05f
C6118 WL_0_1 net72 1.44258e-05f
C6119 WL_0_1 net73 2.17863e-05f
C6120 WL_0_1 net74 1.18544e-05f
C6121 WL_0_1 net76_3 1.61439e-05f
C6122 WL_0_1 net79_4 1.30283e-05f
C6123 WL_0_1 net81_4 1.51585e-05f
C6124 WL_0_1 net84_4 1.401e-05f
C6125 WL_0_1 net86_4 1.04801e-05f
C6126 WL_0_1 net88_4 1.20168e-05f
C6127 WL_0_1 net94_4 1.60539e-05f
C6128 WL_0_10 WL_1_2 0.00114303f
C6129 WL_0_10 XB_0_0_3 0.000250243f
C6130 WL_0_10 XB_0_1 0.000259219f
C6131 WL_0_10 XB_0_2 0.000266825f
C6132 WL_0_10 XB_0_3 0.000267203f
C6133 WL_0_10 XB_0_4 0.000259851f
C6134 WL_0_10 XB_0_5 0.000262124f
C6135 WL_0_10 XB_0_6 0.000267611f
C6136 WL_0_10 XB_0_7 0.000263388f
C6137 WL_0_10 XB_1_0_3 1.70836e-05f
C6138 WL_0_10 XB_1_2_3 1.21228e-05f
C6139 WL_0_10 XB_1_4 1.00037e-05f
C6140 WL_0_10 XB_1_6 1.79283e-05f
C6141 WL_0_10 net10_6 0.00326842f
C6142 WL_0_10 net11 0.00468159f
C6143 WL_0_10 net130_8 3.8934e-05f
C6144 WL_0_10 net132_6 2.0026e-05f
C6145 WL_0_10 net134_6 2.49396e-05f
C6146 WL_0_10 net135_6 2.5252e-05f
C6147 WL_0_10 net137_6 2.083e-05f
C6148 WL_0_10 net139_6 2.03008e-05f
C6149 WL_0_10 net13_6 0.00326305f
C6150 WL_0_10 net14 0.00469757f
C6151 WL_0_10 net141_6 2.23857e-05f
C6152 WL_0_10 net142_6 3.09362e-05f
C6153 WL_0_10 net16_6 0.0032793f
C6154 WL_0_10 net17 0.00468456f
C6155 WL_0_10 net19_6 0.00328136f
C6156 WL_0_10 net2 0.00326934f
C6157 WL_0_10 net20 0.00470844f
C6158 WL_0_10 net23_6 0.00326427f
C6159 WL_0_10 net24 0.00469934f
C6160 WL_0_10 net27_4 0.00324906f
C6161 WL_0_10 net28 0.00469036f
C6162 WL_0_10 net3_8 0.00468283f
C6163 WL_0_10 net6 0.00326796f
C6164 WL_0_10 net67 3.85867e-05f
C6165 WL_0_10 net68 2.553e-05f
C6166 WL_0_10 net69 3.9342e-05f
C6167 WL_0_10 net7 0.00470551f
C6168 WL_0_10 net70 2.75241e-05f
C6169 WL_0_10 net71 3.46895e-05f
C6170 WL_0_10 net72 2.60145e-05f
C6171 WL_0_10 net73 3.92878e-05f
C6172 WL_0_10 net74 2.13774e-05f
C6173 WL_0_10 net76_3 2.91127e-05f
C6174 WL_0_10 net79_3 2.34942e-05f
C6175 WL_0_10 net81_4 2.73356e-05f
C6176 WL_0_10 net84_4 2.52646e-05f
C6177 WL_0_10 net86_4 1.8899e-05f
C6178 WL_0_10 net88_4 2.16702e-05f
C6179 WL_0_10 net93 1.16081e-05f
C6180 WL_0_10 net94_4 2.89503e-05f
C6181 WL_0_11 WL_1_3 0.00103912f
C6182 WL_0_11 XB_0_0_3 0.000227494f
C6183 WL_0_11 XB_0_1_3 0.000235653f
C6184 WL_0_11 XB_0_2 0.000242568f
C6185 WL_0_11 XB_0_3 0.000242912f
C6186 WL_0_11 XB_0_4 0.000236228f
C6187 WL_0_11 XB_0_5 0.000238295f
C6188 WL_0_11 XB_0_6 0.000243283f
C6189 WL_0_11 XB_0_7 0.000239444f
C6190 WL_0_11 XB_1_0_3 1.55305e-05f
C6191 WL_0_11 XB_1_2_3 1.10207e-05f
C6192 WL_0_11 XB_1_6 1.62984e-05f
C6193 WL_0_11 net10 0.00297129f
C6194 WL_0_11 net11 0.00425599f
C6195 WL_0_11 net130_8 3.53946e-05f
C6196 WL_0_11 net132_8 1.82055e-05f
C6197 WL_0_11 net134_6 2.26724e-05f
C6198 WL_0_11 net135_6 2.29564e-05f
C6199 WL_0_11 net137_6 1.89364e-05f
C6200 WL_0_11 net139_6 1.84553e-05f
C6201 WL_0_11 net13_6 0.00296641f
C6202 WL_0_11 net14 0.00427052f
C6203 WL_0_11 net141_6 2.03506e-05f
C6204 WL_0_11 net142_6 2.81238e-05f
C6205 WL_0_11 net16_6 0.00298118f
C6206 WL_0_11 net17 0.00425869f
C6207 WL_0_11 net19_6 0.00298305f
C6208 WL_0_11 net2 0.00297213f
C6209 WL_0_11 net20 0.0042804f
C6210 WL_0_11 net23_6 0.00296752f
C6211 WL_0_11 net24 0.00427213f
C6212 WL_0_11 net27_6 0.00295369f
C6213 WL_0_11 net28 0.00426397f
C6214 WL_0_11 net3_8 0.00425712f
C6215 WL_0_11 net6 0.00297088f
C6216 WL_0_11 net67 3.50789e-05f
C6217 WL_0_11 net68 2.32091e-05f
C6218 WL_0_11 net69 3.57655e-05f
C6219 WL_0_11 net70 2.50219e-05f
C6220 WL_0_11 net71 3.15359e-05f
C6221 WL_0_11 net72 2.36495e-05f
C6222 WL_0_11 net73 3.57162e-05f
C6223 WL_0_11 net74 1.9434e-05f
C6224 WL_0_11 net76_3 2.64661e-05f
C6225 WL_0_11 net79_3 2.13584e-05f
C6226 WL_0_11 net7_8 0.00427774f
C6227 WL_0_11 net81_3 2.48506e-05f
C6228 WL_0_11 net84_4 2.29678e-05f
C6229 WL_0_11 net86_4 1.71809e-05f
C6230 WL_0_11 net88_4 1.97002e-05f
C6231 WL_0_11 net93 1.05528e-05f
C6232 WL_0_11 net94_4 2.63185e-05f
C6233 WL_0_12 WL_1_4 0.00114303f
C6234 WL_0_12 XB_0_0_3 0.000250243f
C6235 WL_0_12 XB_0_1_3 0.000259219f
C6236 WL_0_12 XB_0_2_3 0.000266825f
C6237 WL_0_12 XB_0_3 0.000267203f
C6238 WL_0_12 XB_0_4 0.000259851f
C6239 WL_0_12 XB_0_5 0.000262124f
C6240 WL_0_12 XB_0_6 0.000267611f
C6241 WL_0_12 XB_0_7 0.000263388f
C6242 WL_0_12 XB_1_0_3 1.70836e-05f
C6243 WL_0_12 XB_1_2_3 1.21228e-05f
C6244 WL_0_12 XB_1_4_3 1.00037e-05f
C6245 WL_0_12 XB_1_6 1.79283e-05f
C6246 WL_0_12 net10 0.00326842f
C6247 WL_0_12 net11_8 0.00468159f
C6248 WL_0_12 net13 0.00326305f
C6249 WL_0_12 net130_8 3.8934e-05f
C6250 WL_0_12 net132_8 2.0026e-05f
C6251 WL_0_12 net134_8 2.49396e-05f
C6252 WL_0_12 net135_6 2.5252e-05f
C6253 WL_0_12 net137_6 2.083e-05f
C6254 WL_0_12 net139_6 2.03008e-05f
C6255 WL_0_12 net14 0.00469757f
C6256 WL_0_12 net141_6 2.23857e-05f
C6257 WL_0_12 net142_6 3.09362e-05f
C6258 WL_0_12 net16_6 0.0032793f
C6259 WL_0_12 net17 0.00468456f
C6260 WL_0_12 net19_6 0.00328136f
C6261 WL_0_12 net2 0.00326934f
C6262 WL_0_12 net20 0.00470844f
C6263 WL_0_12 net23_6 0.00326427f
C6264 WL_0_12 net24 0.00469934f
C6265 WL_0_12 net27_6 0.00324906f
C6266 WL_0_12 net28 0.00469036f
C6267 WL_0_12 net3_8 0.00468283f
C6268 WL_0_12 net6 0.00326796f
C6269 WL_0_12 net67 3.85867e-05f
C6270 WL_0_12 net68 2.553e-05f
C6271 WL_0_12 net69 3.9342e-05f
C6272 WL_0_12 net70 2.75241e-05f
C6273 WL_0_12 net71 3.46895e-05f
C6274 WL_0_12 net72 2.60145e-05f
C6275 WL_0_12 net73 3.92878e-05f
C6276 WL_0_12 net74 2.13774e-05f
C6277 WL_0_12 net76_3 2.91127e-05f
C6278 WL_0_12 net79_3 2.34942e-05f
C6279 WL_0_12 net7_8 0.00470551f
C6280 WL_0_12 net81_3 2.73356e-05f
C6281 WL_0_12 net84_3 2.52646e-05f
C6282 WL_0_12 net86_4 1.8899e-05f
C6283 WL_0_12 net88_4 2.16702e-05f
C6284 WL_0_12 net93 1.16081e-05f
C6285 WL_0_12 net94_4 2.89503e-05f
C6286 WL_0_13 WL_1_5 0.00114303f
C6287 WL_0_13 XB_0_0_3 0.000250243f
C6288 WL_0_13 XB_0_1_3 0.000259219f
C6289 WL_0_13 XB_0_2_3 0.000266825f
C6290 WL_0_13 XB_0_3_3 0.000267203f
C6291 WL_0_13 XB_0_4 0.000259851f
C6292 WL_0_13 XB_0_5 0.000262124f
C6293 WL_0_13 XB_0_6 0.000267611f
C6294 WL_0_13 XB_0_7 0.000263388f
C6295 WL_0_13 XB_1_0_3 1.70836e-05f
C6296 WL_0_13 XB_1_2_3 1.21228e-05f
C6297 WL_0_13 XB_1_4_3 1.00037e-05f
C6298 WL_0_13 XB_1_6_3 1.79283e-05f
C6299 WL_0_13 net10 0.00326842f
C6300 WL_0_13 net11_8 0.00468159f
C6301 WL_0_13 net13 0.00326305f
C6302 WL_0_13 net130_8 3.8934e-05f
C6303 WL_0_13 net132_8 2.0026e-05f
C6304 WL_0_13 net134_8 2.49396e-05f
C6305 WL_0_13 net135_8 2.5252e-05f
C6306 WL_0_13 net137_6 2.083e-05f
C6307 WL_0_13 net139_6 2.03008e-05f
C6308 WL_0_13 net141_6 2.23857e-05f
C6309 WL_0_13 net142_6 3.09362e-05f
C6310 WL_0_13 net14_8 0.00469757f
C6311 WL_0_13 net16 0.0032793f
C6312 WL_0_13 net17 0.00468456f
C6313 WL_0_13 net19_6 0.00328136f
C6314 WL_0_13 net2 0.00326934f
C6315 WL_0_13 net20 0.00470844f
C6316 WL_0_13 net23_6 0.00326427f
C6317 WL_0_13 net24 0.00469934f
C6318 WL_0_13 net27_6 0.00324906f
C6319 WL_0_13 net28 0.00469036f
C6320 WL_0_13 net3_8 0.00468283f
C6321 WL_0_13 net6 0.00326796f
C6322 WL_0_13 net67 3.85867e-05f
C6323 WL_0_13 net68 2.553e-05f
C6324 WL_0_13 net69 3.9342e-05f
C6325 WL_0_13 net70 2.75241e-05f
C6326 WL_0_13 net71 3.46895e-05f
C6327 WL_0_13 net72 2.60145e-05f
C6328 WL_0_13 net73 3.92878e-05f
C6329 WL_0_13 net74 2.13774e-05f
C6330 WL_0_13 net76_3 2.91127e-05f
C6331 WL_0_13 net79_3 2.34942e-05f
C6332 WL_0_13 net7_8 0.00470551f
C6333 WL_0_13 net81_3 2.73356e-05f
C6334 WL_0_13 net84_3 2.52646e-05f
C6335 WL_0_13 net86_3 1.8899e-05f
C6336 WL_0_13 net88_4 2.16702e-05f
C6337 WL_0_13 net93 1.16081e-05f
C6338 WL_0_13 net94_4 2.89503e-05f
C6339 WL_0_14 WL_1_6 0.00114303f
C6340 WL_0_14 XB_0_0_3 0.000250243f
C6341 WL_0_14 XB_0_1_3 0.000259219f
C6342 WL_0_14 XB_0_2_3 0.000266825f
C6343 WL_0_14 XB_0_3_3 0.000267203f
C6344 WL_0_14 XB_0_4_3 0.000259851f
C6345 WL_0_14 XB_0_5 0.000262124f
C6346 WL_0_14 XB_0_6 0.000267611f
C6347 WL_0_14 XB_0_7 0.000263388f
C6348 WL_0_14 XB_1_0_3 1.70836e-05f
C6349 WL_0_14 XB_1_2_3 1.21228e-05f
C6350 WL_0_14 XB_1_4_3 1.00037e-05f
C6351 WL_0_14 XB_1_6_3 1.79283e-05f
C6352 WL_0_14 net10 0.00326842f
C6353 WL_0_14 net11_8 0.00468159f
C6354 WL_0_14 net13 0.00326305f
C6355 WL_0_14 net130_8 3.8934e-05f
C6356 WL_0_14 net132_8 2.0026e-05f
C6357 WL_0_14 net134_8 2.49396e-05f
C6358 WL_0_14 net135_8 2.5252e-05f
C6359 WL_0_14 net137_8 2.083e-05f
C6360 WL_0_14 net139_6 2.03008e-05f
C6361 WL_0_14 net141_6 2.23857e-05f
C6362 WL_0_14 net142_6 3.09362e-05f
C6363 WL_0_14 net14_8 0.00469757f
C6364 WL_0_14 net16 0.0032793f
C6365 WL_0_14 net17_8 0.00468456f
C6366 WL_0_14 net19 0.00328136f
C6367 WL_0_14 net2 0.00326934f
C6368 WL_0_14 net20 0.00470844f
C6369 WL_0_14 net23_6 0.00326427f
C6370 WL_0_14 net24 0.00469934f
C6371 WL_0_14 net27_6 0.00324906f
C6372 WL_0_14 net28 0.00469036f
C6373 WL_0_14 net3_8 0.00468283f
C6374 WL_0_14 net6 0.00326796f
C6375 WL_0_14 net67 3.85867e-05f
C6376 WL_0_14 net68 2.553e-05f
C6377 WL_0_14 net69 3.9342e-05f
C6378 WL_0_14 net70 2.75241e-05f
C6379 WL_0_14 net71 3.46895e-05f
C6380 WL_0_14 net72 2.60145e-05f
C6381 WL_0_14 net73 3.92878e-05f
C6382 WL_0_14 net74 2.13774e-05f
C6383 WL_0_14 net76_3 2.91127e-05f
C6384 WL_0_14 net79_3 2.34942e-05f
C6385 WL_0_14 net7_8 0.00470551f
C6386 WL_0_14 net81_3 2.73356e-05f
C6387 WL_0_14 net84_3 2.52646e-05f
C6388 WL_0_14 net86_3 1.8899e-05f
C6389 WL_0_14 net88_3 2.16702e-05f
C6390 WL_0_14 net93 1.16081e-05f
C6391 WL_0_14 net94_4 2.89503e-05f
C6392 WL_0_15 WL_1_7 0.00249389f
C6393 WL_0_15 XB_0_0_3 0.000545986f
C6394 WL_0_15 XB_0_1_3 0.000565568f
C6395 WL_0_15 XB_0_2_3 0.000582164f
C6396 WL_0_15 XB_0_3_3 0.000582989f
C6397 WL_0_15 XB_0_4_3 0.000566948f
C6398 WL_0_15 XB_0_5_3 0.000571907f
C6399 WL_0_15 XB_0_6 0.000583879f
C6400 WL_0_15 XB_0_7 0.000574665f
C6401 WL_0_15 XB_1_0_3 3.72733e-05f
C6402 WL_0_15 XB_1_2_3 2.64497e-05f
C6403 WL_0_15 XB_1_4_3 2.18263e-05f
C6404 WL_0_15 XB_1_6_3 3.91162e-05f
C6405 WL_0_15 net10 0.00713109f
C6406 WL_0_15 net11_8 0.0102144f
C6407 WL_0_15 net13 0.00711938f
C6408 WL_0_15 net130_8 8.4947e-05f
C6409 WL_0_15 net132_8 4.36931e-05f
C6410 WL_0_15 net134_8 5.44137e-05f
C6411 WL_0_15 net135_8 5.50953e-05f
C6412 WL_0_15 net137_8 4.54472e-05f
C6413 WL_0_15 net139_8 4.42927e-05f
C6414 WL_0_15 net141_6 4.88415e-05f
C6415 WL_0_15 net142_6 6.74972e-05f
C6416 WL_0_15 net14_8 0.0102492f
C6417 WL_0_15 net16 0.00715484f
C6418 WL_0_15 net17_8 0.0102209f
C6419 WL_0_15 net19 0.00715933f
C6420 WL_0_15 net2 0.00713311f
C6421 WL_0_15 net20_8 0.010273f
C6422 WL_0_15 net23 0.00712205f
C6423 WL_0_15 net24 0.0102531f
C6424 WL_0_15 net27_6 0.00708885f
C6425 WL_0_15 net28 0.0102335f
C6426 WL_0_15 net3_8 0.0102171f
C6427 WL_0_15 net6 0.0071301f
C6428 WL_0_15 net67 8.41892e-05f
C6429 WL_0_15 net68 5.57019e-05f
C6430 WL_0_15 net69 8.58371e-05f
C6431 WL_0_15 net70 6.00526e-05f
C6432 WL_0_15 net71 7.56863e-05f
C6433 WL_0_15 net72 5.67588e-05f
C6434 WL_0_15 net73 8.57189e-05f
C6435 WL_0_15 net74 4.66416e-05f
C6436 WL_0_15 net76_3 6.35185e-05f
C6437 WL_0_15 net79_3 5.12602e-05f
C6438 WL_0_15 net7_8 0.0102666f
C6439 WL_0_15 net81_3 5.96414e-05f
C6440 WL_0_15 net83 1.97161e-05f
C6441 WL_0_15 net84_3 5.51227e-05f
C6442 WL_0_15 net86_3 4.12341e-05f
C6443 WL_0_15 net87 1.26423e-05f
C6444 WL_0_15 net88_3 4.72804e-05f
C6445 WL_0_15 net91_3 1.2316e-05f
C6446 WL_0_15 net93 2.53267e-05f
C6447 WL_0_15 net94_4 6.31643e-05f
C6448 WL_0_16 WL_1 0.000525493f
C6449 WL_0_16 XB_0_0 0.000115046f
C6450 WL_0_16 XB_0_1 0.000119172f
C6451 WL_0_16 XB_0_2 0.000122669f
C6452 WL_0_16 XB_0_3 0.000122843f
C6453 WL_0_16 XB_0_4 0.000119463f
C6454 WL_0_16 XB_0_5 0.000120508f
C6455 WL_0_16 XB_0_6 0.000123031f
C6456 WL_0_16 XB_0_7 0.000121089f
C6457 WL_0_16 net10_4 0.00150261f
C6458 WL_0_16 net11_5 0.0021523f
C6459 WL_0_16 net130_6 1.78994e-05f
C6460 WL_0_16 net134_6 1.14656e-05f
C6461 WL_0_16 net135_6 1.16093e-05f
C6462 WL_0_16 net13_4 0.00150014f
C6463 WL_0_16 net141_6 1.02915e-05f
C6464 WL_0_16 net142_6 1.42225e-05f
C6465 WL_0_16 net14_5 0.00215964f
C6466 WL_0_16 net16_4 0.00150761f
C6467 WL_0_16 net17_5 0.00215366f
C6468 WL_0_16 net19_4 0.00150856f
C6469 WL_0_16 net20_5 0.00216464f
C6470 WL_0_16 net23_4 0.0015007f
C6471 WL_0_16 net24_5 0.00216046f
C6472 WL_0_16 net27_4 0.00149371f
C6473 WL_0_16 net28_5 0.00215633f
C6474 WL_0_16 net2_4 0.00150303f
C6475 WL_0_16 net3_5 0.00215287f
C6476 WL_0_16 net67 1.77397e-05f
C6477 WL_0_16 net68 1.17371e-05f
C6478 WL_0_16 net69 1.8087e-05f
C6479 WL_0_16 net6_4 0.0015024f
C6480 WL_0_16 net70 1.26538e-05f
C6481 WL_0_16 net71 1.5948e-05f
C6482 WL_0_16 net72 1.19598e-05f
C6483 WL_0_16 net73 1.8062e-05f
C6484 WL_0_16 net76_4 1.33841e-05f
C6485 WL_0_16 net79_4 1.08012e-05f
C6486 WL_0_16 net7_5 0.00216329f
C6487 WL_0_16 net81_4 1.25672e-05f
C6488 WL_0_16 net84_4 1.1615e-05f
C6489 WL_0_16 net94_4 1.33095e-05f
C6490 WL_0_17 WL_1_1 0.000525493f
C6491 WL_0_17 XB_0_0 0.000115046f
C6492 WL_0_17 XB_0_1 0.000119172f
C6493 WL_0_17 XB_0_2 0.000122669f
C6494 WL_0_17 XB_0_3 0.000122843f
C6495 WL_0_17 XB_0_4 0.000119463f
C6496 WL_0_17 XB_0_5 0.000120508f
C6497 WL_0_17 XB_0_6 0.000123031f
C6498 WL_0_17 XB_0_7 0.000121089f
C6499 WL_0_17 net10_4 0.00150261f
C6500 WL_0_17 net11_5 0.0021523f
C6501 WL_0_17 net130_9 1.78994e-05f
C6502 WL_0_17 net134_6 1.14656e-05f
C6503 WL_0_17 net135_6 1.16093e-05f
C6504 WL_0_17 net13_4 0.00150014f
C6505 WL_0_17 net141_6 1.02915e-05f
C6506 WL_0_17 net142_6 1.42225e-05f
C6507 WL_0_17 net14_5 0.00215964f
C6508 WL_0_17 net16_4 0.00150761f
C6509 WL_0_17 net17_5 0.00215366f
C6510 WL_0_17 net19_4 0.00150856f
C6511 WL_0_17 net20_5 0.00216464f
C6512 WL_0_17 net23_4 0.0015007f
C6513 WL_0_17 net24_5 0.00216046f
C6514 WL_0_17 net27_4 0.00149371f
C6515 WL_0_17 net28_5 0.00215633f
C6516 WL_0_17 net2_2 0.00150303f
C6517 WL_0_17 net3_9 0.00215287f
C6518 WL_0_17 net67 1.77397e-05f
C6519 WL_0_17 net68 1.17371e-05f
C6520 WL_0_17 net69 1.8087e-05f
C6521 WL_0_17 net6_4 0.0015024f
C6522 WL_0_17 net70 1.26538e-05f
C6523 WL_0_17 net71 1.5948e-05f
C6524 WL_0_17 net72 1.19598e-05f
C6525 WL_0_17 net73 1.8062e-05f
C6526 WL_0_17 net76_3 1.33841e-05f
C6527 WL_0_17 net79_4 1.08012e-05f
C6528 WL_0_17 net7_5 0.00216329f
C6529 WL_0_17 net81_4 1.25672e-05f
C6530 WL_0_17 net84_4 1.1615e-05f
C6531 WL_0_17 net94_4 1.33095e-05f
C6532 WL_0_18 WL_1_2 0.000525493f
C6533 WL_0_18 XB_0_0_2 0.000115046f
C6534 WL_0_18 XB_0_1 0.000119172f
C6535 WL_0_18 XB_0_2 0.000122669f
C6536 WL_0_18 XB_0_3 0.000122843f
C6537 WL_0_18 XB_0_4 0.000119463f
C6538 WL_0_18 XB_0_5 0.000120508f
C6539 WL_0_18 XB_0_6 0.000123031f
C6540 WL_0_18 XB_0_7 0.000121089f
C6541 WL_0_18 net10_4 0.00150261f
C6542 WL_0_18 net11_5 0.0021523f
C6543 WL_0_18 net130_8 1.78994e-05f
C6544 WL_0_18 net134_6 1.14656e-05f
C6545 WL_0_18 net135_6 1.16093e-05f
C6546 WL_0_18 net13_4 0.00150014f
C6547 WL_0_18 net141_6 1.02915e-05f
C6548 WL_0_18 net142_6 1.42225e-05f
C6549 WL_0_18 net14_5 0.00215964f
C6550 WL_0_18 net16_4 0.00150761f
C6551 WL_0_18 net17_5 0.00215366f
C6552 WL_0_18 net19_4 0.00150856f
C6553 WL_0_18 net20_5 0.00216464f
C6554 WL_0_18 net23_4 0.0015007f
C6555 WL_0_18 net24_5 0.00216046f
C6556 WL_0_18 net27_4 0.00149371f
C6557 WL_0_18 net28_5 0.00215633f
C6558 WL_0_18 net2_2 0.00150303f
C6559 WL_0_18 net3_7 0.00215287f
C6560 WL_0_18 net67 1.77397e-05f
C6561 WL_0_18 net68 1.17371e-05f
C6562 WL_0_18 net69 1.8087e-05f
C6563 WL_0_18 net6_4 0.0015024f
C6564 WL_0_18 net70 1.26538e-05f
C6565 WL_0_18 net71 1.5948e-05f
C6566 WL_0_18 net72 1.19598e-05f
C6567 WL_0_18 net73 1.8062e-05f
C6568 WL_0_18 net76_3 1.33841e-05f
C6569 WL_0_18 net79_4 1.08012e-05f
C6570 WL_0_18 net7_5 0.00216329f
C6571 WL_0_18 net81_4 1.25672e-05f
C6572 WL_0_18 net84_4 1.1615e-05f
C6573 WL_0_18 net94_4 1.33095e-05f
C6574 WL_0_19 WL_1_2 0.000525493f
C6575 WL_0_19 XB_0_0_2 0.000115046f
C6576 WL_0_19 XB_0_1 0.000119172f
C6577 WL_0_19 XB_0_2 0.000122669f
C6578 WL_0_19 XB_0_3 0.000122843f
C6579 WL_0_19 XB_0_4 0.000119463f
C6580 WL_0_19 XB_0_5 0.000120508f
C6581 WL_0_19 XB_0_6 0.000123031f
C6582 WL_0_19 XB_0_7 0.000121089f
C6583 WL_0_19 net10_4 0.00150261f
C6584 WL_0_19 net11_5 0.0021523f
C6585 WL_0_19 net130_8 1.78994e-05f
C6586 WL_0_19 net134_6 1.14656e-05f
C6587 WL_0_19 net135_6 1.16093e-05f
C6588 WL_0_19 net13_4 0.00150014f
C6589 WL_0_19 net141_6 1.02915e-05f
C6590 WL_0_19 net142_6 1.42225e-05f
C6591 WL_0_19 net14_5 0.00215964f
C6592 WL_0_19 net16_4 0.00150761f
C6593 WL_0_19 net17_5 0.00215366f
C6594 WL_0_19 net19_4 0.00150856f
C6595 WL_0_19 net20_5 0.00216464f
C6596 WL_0_19 net23_4 0.0015007f
C6597 WL_0_19 net24_5 0.00216046f
C6598 WL_0_19 net27_4 0.00149371f
C6599 WL_0_19 net28_5 0.00215633f
C6600 WL_0_19 net2_2 0.00150303f
C6601 WL_0_19 net3_7 0.00215287f
C6602 WL_0_19 net67 1.77397e-05f
C6603 WL_0_19 net68 1.17371e-05f
C6604 WL_0_19 net69 1.8087e-05f
C6605 WL_0_19 net6_2 0.0015024f
C6606 WL_0_19 net70 1.26538e-05f
C6607 WL_0_19 net71 1.5948e-05f
C6608 WL_0_19 net72 1.19598e-05f
C6609 WL_0_19 net73 1.8062e-05f
C6610 WL_0_19 net76_3 1.33841e-05f
C6611 WL_0_19 net79_3 1.08012e-05f
C6612 WL_0_19 net7_9 0.00216329f
C6613 WL_0_19 net81_4 1.25672e-05f
C6614 WL_0_19 net84_4 1.1615e-05f
C6615 WL_0_19 net94_4 1.33095e-05f
C6616 WL_0_2 WL_1_2 0.000690116f
C6617 WL_0_2 XB_0_0_3 0.000151087f
C6618 WL_0_2 XB_0_1 0.000156506f
C6619 WL_0_2 XB_0_2 0.000161098f
C6620 WL_0_2 XB_0_3 0.000161327f
C6621 WL_0_2 XB_0_4 0.000156888f
C6622 WL_0_2 XB_0_5 0.00015826f
C6623 WL_0_2 XB_0_6 0.000161573f
C6624 WL_0_2 XB_0_7 0.000159023f
C6625 WL_0_2 XB_1_0_3 1.03144e-05f
C6626 WL_0_2 XB_1_6 1.08244e-05f
C6627 WL_0_2 net10_6 0.00197334f
C6628 WL_0_2 net11 0.00282656f
C6629 WL_0_2 net130_8 2.35068e-05f
C6630 WL_0_2 net132_6 1.20909e-05f
C6631 WL_0_2 net134_6 1.50575e-05f
C6632 WL_0_2 net135_6 1.52462e-05f
C6633 WL_0_2 net137_6 1.25763e-05f
C6634 WL_0_2 net139_6 1.22568e-05f
C6635 WL_0_2 net13_6 0.0019701f
C6636 WL_0_2 net14 0.0028362f
C6637 WL_0_2 net141_6 1.35156e-05f
C6638 WL_0_2 net142_6 1.8678e-05f
C6639 WL_0_2 net16_6 0.00197991f
C6640 WL_0_2 net17 0.00282835f
C6641 WL_0_2 net19_6 0.00198115f
C6642 WL_0_2 net2 0.0019739f
C6643 WL_0_2 net20 0.00284276f
C6644 WL_0_2 net23_6 0.00197084f
C6645 WL_0_2 net24 0.00283727f
C6646 WL_0_2 net27_4 0.00196165f
C6647 WL_0_2 net28 0.00283185f
C6648 WL_0_2 net3_8 0.00282731f
C6649 WL_0_2 net6 0.00197306f
C6650 WL_0_2 net67 2.32971e-05f
C6651 WL_0_2 net68 1.5414e-05f
C6652 WL_0_2 net69 2.37531e-05f
C6653 WL_0_2 net7 0.002841f
C6654 WL_0_2 net70 1.66179e-05f
C6655 WL_0_2 net71 2.09441e-05f
C6656 WL_0_2 net72 1.57065e-05f
C6657 WL_0_2 net73 2.37204e-05f
C6658 WL_0_2 net74 1.29068e-05f
C6659 WL_0_2 net76_3 1.75771e-05f
C6660 WL_0_2 net79_3 1.41849e-05f
C6661 WL_0_2 net81_4 1.65042e-05f
C6662 WL_0_2 net84_4 1.52537e-05f
C6663 WL_0_2 net86_4 1.14104e-05f
C6664 WL_0_2 net88_4 1.30836e-05f
C6665 WL_0_2 net94_4 1.7479e-05f
C6666 WL_0_20 WL_1_3 0.000525493f
C6667 WL_0_20 XB_0_0_2 0.000115046f
C6668 WL_0_20 XB_0_1_2 0.000119172f
C6669 WL_0_20 XB_0_2 0.000122669f
C6670 WL_0_20 XB_0_3 0.000122843f
C6671 WL_0_20 XB_0_4 0.000119463f
C6672 WL_0_20 XB_0_5 0.000120508f
C6673 WL_0_20 XB_0_6 0.000123031f
C6674 WL_0_20 XB_0_7 0.000121089f
C6675 WL_0_20 net10_4 0.00150261f
C6676 WL_0_20 net11_5 0.0021523f
C6677 WL_0_20 net130_8 1.78994e-05f
C6678 WL_0_20 net134_6 1.14656e-05f
C6679 WL_0_20 net135_6 1.16093e-05f
C6680 WL_0_20 net13_4 0.00150014f
C6681 WL_0_20 net141_6 1.02915e-05f
C6682 WL_0_20 net142_6 1.42225e-05f
C6683 WL_0_20 net14_5 0.00215964f
C6684 WL_0_20 net16_4 0.00150761f
C6685 WL_0_20 net17_5 0.00215366f
C6686 WL_0_20 net19_4 0.00150856f
C6687 WL_0_20 net20_5 0.00216464f
C6688 WL_0_20 net23_4 0.0015007f
C6689 WL_0_20 net24_5 0.00216046f
C6690 WL_0_20 net27_4 0.00149371f
C6691 WL_0_20 net28_5 0.00215633f
C6692 WL_0_20 net2_2 0.00150303f
C6693 WL_0_20 net3_7 0.00215287f
C6694 WL_0_20 net67 1.77397e-05f
C6695 WL_0_20 net68 1.17371e-05f
C6696 WL_0_20 net69 1.8087e-05f
C6697 WL_0_20 net6_2 0.0015024f
C6698 WL_0_20 net70 1.26538e-05f
C6699 WL_0_20 net71 1.5948e-05f
C6700 WL_0_20 net72 1.19598e-05f
C6701 WL_0_20 net73 1.8062e-05f
C6702 WL_0_20 net76_3 1.33841e-05f
C6703 WL_0_20 net79_3 1.08012e-05f
C6704 WL_0_20 net7_7 0.00216329f
C6705 WL_0_20 net81_4 1.25672e-05f
C6706 WL_0_20 net84_4 1.1615e-05f
C6707 WL_0_20 net94_4 1.33095e-05f
C6708 WL_0_21 WL_1_3 0.000525493f
C6709 WL_0_21 XB_0_0_2 0.000115046f
C6710 WL_0_21 XB_0_1_2 0.000119172f
C6711 WL_0_21 XB_0_2 0.000122669f
C6712 WL_0_21 XB_0_3 0.000122843f
C6713 WL_0_21 XB_0_4 0.000119463f
C6714 WL_0_21 XB_0_5 0.000120508f
C6715 WL_0_21 XB_0_6 0.000123031f
C6716 WL_0_21 XB_0_7 0.000121089f
C6717 WL_0_21 net10_2 0.00150261f
C6718 WL_0_21 net11_9 0.0021523f
C6719 WL_0_21 net130_8 1.78994e-05f
C6720 WL_0_21 net134_9 1.14656e-05f
C6721 WL_0_21 net135_6 1.16093e-05f
C6722 WL_0_21 net13_4 0.00150014f
C6723 WL_0_21 net141_6 1.02915e-05f
C6724 WL_0_21 net142_6 1.42225e-05f
C6725 WL_0_21 net14_5 0.00215964f
C6726 WL_0_21 net16_4 0.00150761f
C6727 WL_0_21 net17_5 0.00215366f
C6728 WL_0_21 net19_4 0.00150856f
C6729 WL_0_21 net20_5 0.00216464f
C6730 WL_0_21 net23_4 0.0015007f
C6731 WL_0_21 net24_5 0.00216046f
C6732 WL_0_21 net27_4 0.00149371f
C6733 WL_0_21 net28_5 0.00215633f
C6734 WL_0_21 net2_2 0.00150303f
C6735 WL_0_21 net3_7 0.00215287f
C6736 WL_0_21 net67 1.77397e-05f
C6737 WL_0_21 net68 1.17371e-05f
C6738 WL_0_21 net69 1.8087e-05f
C6739 WL_0_21 net6_2 0.0015024f
C6740 WL_0_21 net70 1.26538e-05f
C6741 WL_0_21 net71 1.5948e-05f
C6742 WL_0_21 net72 1.19598e-05f
C6743 WL_0_21 net73 1.8062e-05f
C6744 WL_0_21 net76_3 1.33841e-05f
C6745 WL_0_21 net79_3 1.08012e-05f
C6746 WL_0_21 net7_7 0.00216329f
C6747 WL_0_21 net81_3 1.25672e-05f
C6748 WL_0_21 net84_4 1.1615e-05f
C6749 WL_0_21 net94_4 1.33095e-05f
C6750 WL_0_22 WL_1_4 0.000525493f
C6751 WL_0_22 XB_0_0_2 0.000115046f
C6752 WL_0_22 XB_0_1_2 0.000119172f
C6753 WL_0_22 XB_0_2_2 0.000122669f
C6754 WL_0_22 XB_0_3 0.000122843f
C6755 WL_0_22 XB_0_4 0.000119463f
C6756 WL_0_22 XB_0_5 0.000120508f
C6757 WL_0_22 XB_0_6 0.000123031f
C6758 WL_0_22 XB_0_7 0.000121089f
C6759 WL_0_22 net10_2 0.00150261f
C6760 WL_0_22 net11_7 0.0021523f
C6761 WL_0_22 net130_8 1.78994e-05f
C6762 WL_0_22 net134_8 1.14656e-05f
C6763 WL_0_22 net135_6 1.16093e-05f
C6764 WL_0_22 net13_4 0.00150014f
C6765 WL_0_22 net141_6 1.02915e-05f
C6766 WL_0_22 net142_6 1.42225e-05f
C6767 WL_0_22 net14_5 0.00215964f
C6768 WL_0_22 net16_4 0.00150761f
C6769 WL_0_22 net17_5 0.00215366f
C6770 WL_0_22 net19_4 0.00150856f
C6771 WL_0_22 net20_5 0.00216464f
C6772 WL_0_22 net23_4 0.0015007f
C6773 WL_0_22 net24_5 0.00216046f
C6774 WL_0_22 net27_4 0.00149371f
C6775 WL_0_22 net28_5 0.00215633f
C6776 WL_0_22 net2_2 0.00150303f
C6777 WL_0_22 net3_7 0.00215287f
C6778 WL_0_22 net67 1.77397e-05f
C6779 WL_0_22 net68 1.17371e-05f
C6780 WL_0_22 net69 1.8087e-05f
C6781 WL_0_22 net6_2 0.0015024f
C6782 WL_0_22 net70 1.26538e-05f
C6783 WL_0_22 net71 1.5948e-05f
C6784 WL_0_22 net72 1.19598e-05f
C6785 WL_0_22 net73 1.8062e-05f
C6786 WL_0_22 net76_3 1.33841e-05f
C6787 WL_0_22 net79_3 1.08012e-05f
C6788 WL_0_22 net7_7 0.00216329f
C6789 WL_0_22 net81_3 1.25672e-05f
C6790 WL_0_22 net84_4 1.1615e-05f
C6791 WL_0_22 net94_4 1.33095e-05f
C6792 WL_0_23 WL_1_4 0.000525493f
C6793 WL_0_23 XB_0_0_2 0.000115046f
C6794 WL_0_23 XB_0_1_2 0.000119172f
C6795 WL_0_23 XB_0_2_2 0.000122669f
C6796 WL_0_23 XB_0_3 0.000122843f
C6797 WL_0_23 XB_0_4 0.000119463f
C6798 WL_0_23 XB_0_5 0.000120508f
C6799 WL_0_23 XB_0_6 0.000123031f
C6800 WL_0_23 XB_0_7 0.000121089f
C6801 WL_0_23 net10_2 0.00150261f
C6802 WL_0_23 net11_7 0.0021523f
C6803 WL_0_23 net130_8 1.78994e-05f
C6804 WL_0_23 net134_8 1.14656e-05f
C6805 WL_0_23 net135_9 1.16093e-05f
C6806 WL_0_23 net13_2 0.00150014f
C6807 WL_0_23 net141_6 1.02915e-05f
C6808 WL_0_23 net142_6 1.42225e-05f
C6809 WL_0_23 net14_9 0.00215964f
C6810 WL_0_23 net16_4 0.00150761f
C6811 WL_0_23 net17_5 0.00215366f
C6812 WL_0_23 net19_4 0.00150856f
C6813 WL_0_23 net20_5 0.00216464f
C6814 WL_0_23 net23_4 0.0015007f
C6815 WL_0_23 net24_5 0.00216046f
C6816 WL_0_23 net27_4 0.00149371f
C6817 WL_0_23 net28_5 0.00215633f
C6818 WL_0_23 net2_2 0.00150303f
C6819 WL_0_23 net3_7 0.00215287f
C6820 WL_0_23 net67 1.77397e-05f
C6821 WL_0_23 net68 1.17371e-05f
C6822 WL_0_23 net69 1.8087e-05f
C6823 WL_0_23 net6_2 0.0015024f
C6824 WL_0_23 net70 1.26538e-05f
C6825 WL_0_23 net71 1.5948e-05f
C6826 WL_0_23 net72 1.19598e-05f
C6827 WL_0_23 net73 1.8062e-05f
C6828 WL_0_23 net76_3 1.33841e-05f
C6829 WL_0_23 net79_3 1.08012e-05f
C6830 WL_0_23 net7_7 0.00216329f
C6831 WL_0_23 net81_3 1.25672e-05f
C6832 WL_0_23 net84_3 1.1615e-05f
C6833 WL_0_23 net94_4 1.33095e-05f
C6834 WL_0_24 WL_1_5 0.000525493f
C6835 WL_0_24 XB_0_0_2 0.000115046f
C6836 WL_0_24 XB_0_1_2 0.000119172f
C6837 WL_0_24 XB_0_2_2 0.000122669f
C6838 WL_0_24 XB_0_3_2 0.000122843f
C6839 WL_0_24 XB_0_4 0.000119463f
C6840 WL_0_24 XB_0_5 0.000120508f
C6841 WL_0_24 XB_0_6 0.000123031f
C6842 WL_0_24 XB_0_7 0.000121089f
C6843 WL_0_24 net10_2 0.00150261f
C6844 WL_0_24 net11_7 0.0021523f
C6845 WL_0_24 net130_8 1.78994e-05f
C6846 WL_0_24 net134_8 1.14656e-05f
C6847 WL_0_24 net135_8 1.16093e-05f
C6848 WL_0_24 net13_2 0.00150014f
C6849 WL_0_24 net141_6 1.02915e-05f
C6850 WL_0_24 net142_6 1.42225e-05f
C6851 WL_0_24 net14_7 0.00215964f
C6852 WL_0_24 net16_4 0.00150761f
C6853 WL_0_24 net17_5 0.00215366f
C6854 WL_0_24 net19_4 0.00150856f
C6855 WL_0_24 net20_5 0.00216464f
C6856 WL_0_24 net23_4 0.0015007f
C6857 WL_0_24 net24_5 0.00216046f
C6858 WL_0_24 net27_4 0.00149371f
C6859 WL_0_24 net28_5 0.00215633f
C6860 WL_0_24 net2_2 0.00150303f
C6861 WL_0_24 net3_7 0.00215287f
C6862 WL_0_24 net67 1.77397e-05f
C6863 WL_0_24 net68 1.17371e-05f
C6864 WL_0_24 net69 1.8087e-05f
C6865 WL_0_24 net6_2 0.0015024f
C6866 WL_0_24 net70 1.26538e-05f
C6867 WL_0_24 net71 1.5948e-05f
C6868 WL_0_24 net72 1.19598e-05f
C6869 WL_0_24 net73 1.8062e-05f
C6870 WL_0_24 net76_3 1.33841e-05f
C6871 WL_0_24 net79_3 1.08012e-05f
C6872 WL_0_24 net7_7 0.00216329f
C6873 WL_0_24 net81_3 1.25672e-05f
C6874 WL_0_24 net84_3 1.1615e-05f
C6875 WL_0_24 net94_4 1.33095e-05f
C6876 WL_0_25 WL_1_5 0.000525493f
C6877 WL_0_25 XB_0_0_2 0.000115046f
C6878 WL_0_25 XB_0_1_2 0.000119172f
C6879 WL_0_25 XB_0_2_2 0.000122669f
C6880 WL_0_25 XB_0_3_2 0.000122843f
C6881 WL_0_25 XB_0_4 0.000119463f
C6882 WL_0_25 XB_0_5 0.000120508f
C6883 WL_0_25 XB_0_6 0.000123031f
C6884 WL_0_25 XB_0_7 0.000121089f
C6885 WL_0_25 net10_2 0.00150261f
C6886 WL_0_25 net11_7 0.0021523f
C6887 WL_0_25 net130_8 1.78994e-05f
C6888 WL_0_25 net134_8 1.14656e-05f
C6889 WL_0_25 net135_8 1.16093e-05f
C6890 WL_0_25 net13_2 0.00150014f
C6891 WL_0_25 net141_6 1.02915e-05f
C6892 WL_0_25 net142_6 1.42225e-05f
C6893 WL_0_25 net14_7 0.00215964f
C6894 WL_0_25 net16_2 0.00150761f
C6895 WL_0_25 net17_9 0.00215366f
C6896 WL_0_25 net19_4 0.00150856f
C6897 WL_0_25 net20_5 0.00216464f
C6898 WL_0_25 net23_4 0.0015007f
C6899 WL_0_25 net24_5 0.00216046f
C6900 WL_0_25 net27_4 0.00149371f
C6901 WL_0_25 net28_5 0.00215633f
C6902 WL_0_25 net2_2 0.00150303f
C6903 WL_0_25 net3_7 0.00215287f
C6904 WL_0_25 net67 1.77397e-05f
C6905 WL_0_25 net68 1.17371e-05f
C6906 WL_0_25 net69 1.8087e-05f
C6907 WL_0_25 net6_2 0.0015024f
C6908 WL_0_25 net70 1.26538e-05f
C6909 WL_0_25 net71 1.5948e-05f
C6910 WL_0_25 net72 1.19598e-05f
C6911 WL_0_25 net73 1.8062e-05f
C6912 WL_0_25 net76_3 1.33841e-05f
C6913 WL_0_25 net79_3 1.08012e-05f
C6914 WL_0_25 net7_7 0.00216329f
C6915 WL_0_25 net81_3 1.25672e-05f
C6916 WL_0_25 net84_3 1.1615e-05f
C6917 WL_0_25 net94_4 1.33095e-05f
C6918 WL_0_26 WL_1_6 0.000525493f
C6919 WL_0_26 XB_0_0_2 0.000115046f
C6920 WL_0_26 XB_0_1_2 0.000119172f
C6921 WL_0_26 XB_0_2_2 0.000122669f
C6922 WL_0_26 XB_0_3_2 0.000122843f
C6923 WL_0_26 XB_0_4_2 0.000119463f
C6924 WL_0_26 XB_0_5 0.000120508f
C6925 WL_0_26 XB_0_6 0.000123031f
C6926 WL_0_26 XB_0_7 0.000121089f
C6927 WL_0_26 net10_2 0.00150261f
C6928 WL_0_26 net11_7 0.0021523f
C6929 WL_0_26 net130_8 1.78994e-05f
C6930 WL_0_26 net134_8 1.14656e-05f
C6931 WL_0_26 net135_8 1.16093e-05f
C6932 WL_0_26 net13_2 0.00150014f
C6933 WL_0_26 net141_6 1.02915e-05f
C6934 WL_0_26 net142_6 1.42225e-05f
C6935 WL_0_26 net14_7 0.00215964f
C6936 WL_0_26 net16_2 0.00150761f
C6937 WL_0_26 net17_7 0.00215366f
C6938 WL_0_26 net19_4 0.00150856f
C6939 WL_0_26 net20_5 0.00216464f
C6940 WL_0_26 net23_4 0.0015007f
C6941 WL_0_26 net24_5 0.00216046f
C6942 WL_0_26 net27_4 0.00149371f
C6943 WL_0_26 net28_5 0.00215633f
C6944 WL_0_26 net2_2 0.00150303f
C6945 WL_0_26 net3_7 0.00215287f
C6946 WL_0_26 net67 1.77397e-05f
C6947 WL_0_26 net68 1.17371e-05f
C6948 WL_0_26 net69 1.8087e-05f
C6949 WL_0_26 net6_2 0.0015024f
C6950 WL_0_26 net70 1.26538e-05f
C6951 WL_0_26 net71 1.5948e-05f
C6952 WL_0_26 net72 1.19598e-05f
C6953 WL_0_26 net73 1.8062e-05f
C6954 WL_0_26 net76_3 1.33841e-05f
C6955 WL_0_26 net79_3 1.08012e-05f
C6956 WL_0_26 net7_7 0.00216329f
C6957 WL_0_26 net81_3 1.25672e-05f
C6958 WL_0_26 net84_3 1.1615e-05f
C6959 WL_0_26 net94_4 1.33095e-05f
C6960 WL_0_27 WL_1_6 0.000525493f
C6961 WL_0_27 XB_0_0_2 0.000115046f
C6962 WL_0_27 XB_0_1_2 0.000119172f
C6963 WL_0_27 XB_0_2_2 0.000122669f
C6964 WL_0_27 XB_0_3_2 0.000122843f
C6965 WL_0_27 XB_0_4_2 0.000119463f
C6966 WL_0_27 XB_0_5 0.000120508f
C6967 WL_0_27 XB_0_6 0.000123031f
C6968 WL_0_27 XB_0_7 0.000121089f
C6969 WL_0_27 net10_2 0.00150261f
C6970 WL_0_27 net11_7 0.0021523f
C6971 WL_0_27 net130_8 1.78994e-05f
C6972 WL_0_27 net134_8 1.14656e-05f
C6973 WL_0_27 net135_8 1.16093e-05f
C6974 WL_0_27 net13_2 0.00150014f
C6975 WL_0_27 net141_6 1.02915e-05f
C6976 WL_0_27 net142_6 1.42225e-05f
C6977 WL_0_27 net14_7 0.00215964f
C6978 WL_0_27 net16_2 0.00150761f
C6979 WL_0_27 net17_7 0.00215366f
C6980 WL_0_27 net19_2 0.00150856f
C6981 WL_0_27 net20_9 0.00216464f
C6982 WL_0_27 net23_4 0.0015007f
C6983 WL_0_27 net24_5 0.00216046f
C6984 WL_0_27 net27_4 0.00149371f
C6985 WL_0_27 net28_5 0.00215633f
C6986 WL_0_27 net2_2 0.00150303f
C6987 WL_0_27 net3_7 0.00215287f
C6988 WL_0_27 net67 1.77397e-05f
C6989 WL_0_27 net68 1.17371e-05f
C6990 WL_0_27 net69 1.8087e-05f
C6991 WL_0_27 net6_2 0.0015024f
C6992 WL_0_27 net70 1.26538e-05f
C6993 WL_0_27 net71 1.5948e-05f
C6994 WL_0_27 net72 1.19598e-05f
C6995 WL_0_27 net73 1.8062e-05f
C6996 WL_0_27 net76_3 1.33841e-05f
C6997 WL_0_27 net79_3 1.08012e-05f
C6998 WL_0_27 net7_7 0.00216329f
C6999 WL_0_27 net81_3 1.25672e-05f
C7000 WL_0_27 net84_3 1.1615e-05f
C7001 WL_0_27 net94_4 1.33095e-05f
C7002 WL_0_28 WL_1_7 0.000525493f
C7003 WL_0_28 XB_0_0_2 0.000115046f
C7004 WL_0_28 XB_0_1_2 0.000119172f
C7005 WL_0_28 XB_0_2_2 0.000122669f
C7006 WL_0_28 XB_0_3_2 0.000122843f
C7007 WL_0_28 XB_0_4_2 0.000119463f
C7008 WL_0_28 XB_0_5_2 0.000120508f
C7009 WL_0_28 XB_0_6 0.000123031f
C7010 WL_0_28 XB_0_7 0.000121089f
C7011 WL_0_28 net10_2 0.00150261f
C7012 WL_0_28 net11_7 0.0021523f
C7013 WL_0_28 net130_8 1.78994e-05f
C7014 WL_0_28 net134_8 1.14656e-05f
C7015 WL_0_28 net135_8 1.16093e-05f
C7016 WL_0_28 net13_2 0.00150014f
C7017 WL_0_28 net141_6 1.02915e-05f
C7018 WL_0_28 net142_6 1.42225e-05f
C7019 WL_0_28 net14_7 0.00215964f
C7020 WL_0_28 net16_2 0.00150761f
C7021 WL_0_28 net17_7 0.00215366f
C7022 WL_0_28 net19_2 0.00150856f
C7023 WL_0_28 net20_7 0.00216464f
C7024 WL_0_28 net23_4 0.0015007f
C7025 WL_0_28 net24_5 0.00216046f
C7026 WL_0_28 net27_4 0.00149371f
C7027 WL_0_28 net28_5 0.00215633f
C7028 WL_0_28 net2_2 0.00150303f
C7029 WL_0_28 net3_7 0.00215287f
C7030 WL_0_28 net67 1.77397e-05f
C7031 WL_0_28 net68 1.17371e-05f
C7032 WL_0_28 net69 1.8087e-05f
C7033 WL_0_28 net6_2 0.0015024f
C7034 WL_0_28 net70 1.26538e-05f
C7035 WL_0_28 net71 1.5948e-05f
C7036 WL_0_28 net72 1.19598e-05f
C7037 WL_0_28 net73 1.8062e-05f
C7038 WL_0_28 net76_3 1.33841e-05f
C7039 WL_0_28 net79_3 1.08012e-05f
C7040 WL_0_28 net7_7 0.00216329f
C7041 WL_0_28 net81_3 1.25672e-05f
C7042 WL_0_28 net84_3 1.1615e-05f
C7043 WL_0_28 net94_4 1.33095e-05f
C7044 WL_0_29 WL_1_7 0.000525493f
C7045 WL_0_29 XB_0_0_2 0.000115046f
C7046 WL_0_29 XB_0_1_2 0.000119172f
C7047 WL_0_29 XB_0_2_2 0.000122669f
C7048 WL_0_29 XB_0_3_2 0.000122843f
C7049 WL_0_29 XB_0_4_2 0.000119463f
C7050 WL_0_29 XB_0_5_2 0.000120508f
C7051 WL_0_29 XB_0_6 0.000123031f
C7052 WL_0_29 XB_0_7 0.000121089f
C7053 WL_0_29 net10_2 0.00150261f
C7054 WL_0_29 net11_7 0.0021523f
C7055 WL_0_29 net130_8 1.78994e-05f
C7056 WL_0_29 net134_8 1.14656e-05f
C7057 WL_0_29 net135_8 1.16093e-05f
C7058 WL_0_29 net13_2 0.00150014f
C7059 WL_0_29 net141_9 1.02915e-05f
C7060 WL_0_29 net142_6 1.42225e-05f
C7061 WL_0_29 net14_7 0.00215964f
C7062 WL_0_29 net16_2 0.00150761f
C7063 WL_0_29 net17_7 0.00215366f
C7064 WL_0_29 net19_2 0.00150856f
C7065 WL_0_29 net20_7 0.00216464f
C7066 WL_0_29 net23_2 0.0015007f
C7067 WL_0_29 net24_9 0.00216046f
C7068 WL_0_29 net27_4 0.00149371f
C7069 WL_0_29 net28_5 0.00215633f
C7070 WL_0_29 net2_2 0.00150303f
C7071 WL_0_29 net3_7 0.00215287f
C7072 WL_0_29 net67 1.77397e-05f
C7073 WL_0_29 net68 1.17371e-05f
C7074 WL_0_29 net69 1.8087e-05f
C7075 WL_0_29 net6_2 0.0015024f
C7076 WL_0_29 net70 1.26538e-05f
C7077 WL_0_29 net71 1.5948e-05f
C7078 WL_0_29 net72 1.19598e-05f
C7079 WL_0_29 net73 1.8062e-05f
C7080 WL_0_29 net76_3 1.33841e-05f
C7081 WL_0_29 net79_3 1.08012e-05f
C7082 WL_0_29 net7_7 0.00216329f
C7083 WL_0_29 net81_3 1.25672e-05f
C7084 WL_0_29 net84_3 1.1615e-05f
C7085 WL_0_29 net94_4 1.33095e-05f
C7086 WL_0_3 WL_1_3 0.000690116f
C7087 WL_0_3 XB_0_0_3 0.000151087f
C7088 WL_0_3 XB_0_1_3 0.000156506f
C7089 WL_0_3 XB_0_2 0.000161098f
C7090 WL_0_3 XB_0_3 0.000161327f
C7091 WL_0_3 XB_0_4 0.000156888f
C7092 WL_0_3 XB_0_5 0.00015826f
C7093 WL_0_3 XB_0_6 0.000161573f
C7094 WL_0_3 XB_0_7 0.000159023f
C7095 WL_0_3 XB_1_0_3 1.03144e-05f
C7096 WL_0_3 XB_1_6 1.08244e-05f
C7097 WL_0_3 net10 0.00197334f
C7098 WL_0_3 net11 0.00282656f
C7099 WL_0_3 net130_8 2.35068e-05f
C7100 WL_0_3 net132_8 1.20909e-05f
C7101 WL_0_3 net134_6 1.50575e-05f
C7102 WL_0_3 net135_6 1.52462e-05f
C7103 WL_0_3 net137_6 1.25763e-05f
C7104 WL_0_3 net139_6 1.22568e-05f
C7105 WL_0_3 net13_6 0.0019701f
C7106 WL_0_3 net14 0.0028362f
C7107 WL_0_3 net141_6 1.35156e-05f
C7108 WL_0_3 net142_6 1.8678e-05f
C7109 WL_0_3 net16_6 0.00197991f
C7110 WL_0_3 net17 0.00282835f
C7111 WL_0_3 net19_6 0.00198115f
C7112 WL_0_3 net2 0.0019739f
C7113 WL_0_3 net20 0.00284276f
C7114 WL_0_3 net23_6 0.00197084f
C7115 WL_0_3 net24 0.00283727f
C7116 WL_0_3 net27_6 0.00196165f
C7117 WL_0_3 net28 0.00283185f
C7118 WL_0_3 net3_8 0.00282731f
C7119 WL_0_3 net6 0.00197306f
C7120 WL_0_3 net67 2.32971e-05f
C7121 WL_0_3 net68 1.5414e-05f
C7122 WL_0_3 net69 2.37531e-05f
C7123 WL_0_3 net70 1.66179e-05f
C7124 WL_0_3 net71 2.09441e-05f
C7125 WL_0_3 net72 1.57065e-05f
C7126 WL_0_3 net73 2.37204e-05f
C7127 WL_0_3 net74 1.29068e-05f
C7128 WL_0_3 net76_3 1.75771e-05f
C7129 WL_0_3 net79_3 1.41849e-05f
C7130 WL_0_3 net7_8 0.002841f
C7131 WL_0_3 net81_3 1.65042e-05f
C7132 WL_0_3 net84_4 1.52537e-05f
C7133 WL_0_3 net86_4 1.14104e-05f
C7134 WL_0_3 net88_4 1.30836e-05f
C7135 WL_0_3 net94_4 1.7479e-05f
C7136 WL_0_30 WL_1_8 0.000525493f
C7137 WL_0_30 XB_0_0_2 0.000115046f
C7138 WL_0_30 XB_0_1_2 0.000119172f
C7139 WL_0_30 XB_0_2_2 0.000122669f
C7140 WL_0_30 XB_0_3_2 0.000122843f
C7141 WL_0_30 XB_0_4_2 0.000119463f
C7142 WL_0_30 XB_0_5_2 0.000120508f
C7143 WL_0_30 XB_0_6_2 0.000123031f
C7144 WL_0_30 XB_0_7 0.000121089f
C7145 WL_0_30 net10_2 0.00150261f
C7146 WL_0_30 net11_7 0.0021523f
C7147 WL_0_30 net130_8 1.78994e-05f
C7148 WL_0_30 net134_8 1.14656e-05f
C7149 WL_0_30 net135_8 1.16093e-05f
C7150 WL_0_30 net13_2 0.00150014f
C7151 WL_0_30 net141_8 1.02915e-05f
C7152 WL_0_30 net142_6 1.42225e-05f
C7153 WL_0_30 net14_7 0.00215964f
C7154 WL_0_30 net16_2 0.00150761f
C7155 WL_0_30 net17_7 0.00215366f
C7156 WL_0_30 net19_2 0.00150856f
C7157 WL_0_30 net20_7 0.00216464f
C7158 WL_0_30 net23_2 0.0015007f
C7159 WL_0_30 net24_7 0.00216046f
C7160 WL_0_30 net27_4 0.00149371f
C7161 WL_0_30 net28_5 0.00215633f
C7162 WL_0_30 net2_2 0.00150303f
C7163 WL_0_30 net3_7 0.00215287f
C7164 WL_0_30 net67 1.77397e-05f
C7165 WL_0_30 net68 1.17371e-05f
C7166 WL_0_30 net69 1.8087e-05f
C7167 WL_0_30 net6_2 0.0015024f
C7168 WL_0_30 net70 1.26538e-05f
C7169 WL_0_30 net71 1.5948e-05f
C7170 WL_0_30 net72 1.19598e-05f
C7171 WL_0_30 net73 1.8062e-05f
C7172 WL_0_30 net76_3 1.33841e-05f
C7173 WL_0_30 net79_3 1.08012e-05f
C7174 WL_0_30 net7_7 0.00216329f
C7175 WL_0_30 net81_3 1.25672e-05f
C7176 WL_0_30 net84_3 1.1615e-05f
C7177 WL_0_30 net94_4 1.33095e-05f
C7178 WL_0_31 WL_1_8 0.000525493f
C7179 WL_0_31 XB_0_0_2 0.000115046f
C7180 WL_0_31 XB_0_1_2 0.000119172f
C7181 WL_0_31 XB_0_2_2 0.000122669f
C7182 WL_0_31 XB_0_3_2 0.000122843f
C7183 WL_0_31 XB_0_4_2 0.000119463f
C7184 WL_0_31 XB_0_5_2 0.000120508f
C7185 WL_0_31 XB_0_6_2 0.000123031f
C7186 WL_0_31 XB_0_7 0.000121089f
C7187 WL_0_31 net10_2 0.00150261f
C7188 WL_0_31 net11_7 0.0021523f
C7189 WL_0_31 net130_8 1.78994e-05f
C7190 WL_0_31 net134_8 1.14656e-05f
C7191 WL_0_31 net135_8 1.16093e-05f
C7192 WL_0_31 net13_2 0.00150014f
C7193 WL_0_31 net141_8 1.02915e-05f
C7194 WL_0_31 net142_9 1.42225e-05f
C7195 WL_0_31 net14_7 0.00215964f
C7196 WL_0_31 net16_2 0.00150761f
C7197 WL_0_31 net17_7 0.00215366f
C7198 WL_0_31 net19_2 0.00150856f
C7199 WL_0_31 net20_7 0.00216464f
C7200 WL_0_31 net23_2 0.0015007f
C7201 WL_0_31 net24_7 0.00216046f
C7202 WL_0_31 net27_2 0.00149371f
C7203 WL_0_31 net28_9 0.00215633f
C7204 WL_0_31 net2_2 0.00150303f
C7205 WL_0_31 net3_7 0.00215287f
C7206 WL_0_31 net67 1.77397e-05f
C7207 WL_0_31 net68 1.17371e-05f
C7208 WL_0_31 net69 1.8087e-05f
C7209 WL_0_31 net6_2 0.0015024f
C7210 WL_0_31 net70 1.26538e-05f
C7211 WL_0_31 net71 1.5948e-05f
C7212 WL_0_31 net72 1.19598e-05f
C7213 WL_0_31 net73 1.8062e-05f
C7214 WL_0_31 net76_3 1.33841e-05f
C7215 WL_0_31 net79_3 1.08012e-05f
C7216 WL_0_31 net7_7 0.00216329f
C7217 WL_0_31 net81_3 1.25672e-05f
C7218 WL_0_31 net84_3 1.1615e-05f
C7219 WL_0_31 net94_3 1.33095e-05f
C7220 WL_0_4 WL_1_4 0.000690116f
C7221 WL_0_4 XB_0_0_3 0.000151087f
C7222 WL_0_4 XB_0_1_3 0.000156506f
C7223 WL_0_4 XB_0_2_3 0.000161098f
C7224 WL_0_4 XB_0_3 0.000161327f
C7225 WL_0_4 XB_0_4 0.000156888f
C7226 WL_0_4 XB_0_5 0.00015826f
C7227 WL_0_4 XB_0_6 0.000161573f
C7228 WL_0_4 XB_0_7 0.000159023f
C7229 WL_0_4 XB_1_0_3 1.03144e-05f
C7230 WL_0_4 XB_1_6 1.08244e-05f
C7231 WL_0_4 net10 0.00197334f
C7232 WL_0_4 net11_8 0.00282656f
C7233 WL_0_4 net13 0.0019701f
C7234 WL_0_4 net130_8 2.35068e-05f
C7235 WL_0_4 net132_8 1.20909e-05f
C7236 WL_0_4 net134_8 1.50575e-05f
C7237 WL_0_4 net135_6 1.52462e-05f
C7238 WL_0_4 net137_6 1.25763e-05f
C7239 WL_0_4 net139_6 1.22568e-05f
C7240 WL_0_4 net14 0.0028362f
C7241 WL_0_4 net141_6 1.35156e-05f
C7242 WL_0_4 net142_6 1.8678e-05f
C7243 WL_0_4 net16_6 0.00197991f
C7244 WL_0_4 net17 0.00282835f
C7245 WL_0_4 net19_6 0.00198115f
C7246 WL_0_4 net2 0.0019739f
C7247 WL_0_4 net20 0.00284276f
C7248 WL_0_4 net23_6 0.00197084f
C7249 WL_0_4 net24 0.00283727f
C7250 WL_0_4 net27_6 0.00196165f
C7251 WL_0_4 net28 0.00283185f
C7252 WL_0_4 net3_8 0.00282731f
C7253 WL_0_4 net6 0.00197306f
C7254 WL_0_4 net67 2.32971e-05f
C7255 WL_0_4 net68 1.5414e-05f
C7256 WL_0_4 net69 2.37531e-05f
C7257 WL_0_4 net70 1.66179e-05f
C7258 WL_0_4 net71 2.09441e-05f
C7259 WL_0_4 net72 1.57065e-05f
C7260 WL_0_4 net73 2.37204e-05f
C7261 WL_0_4 net74 1.29068e-05f
C7262 WL_0_4 net76_3 1.75771e-05f
C7263 WL_0_4 net79_3 1.41849e-05f
C7264 WL_0_4 net7_8 0.002841f
C7265 WL_0_4 net81_3 1.65042e-05f
C7266 WL_0_4 net84_3 1.52537e-05f
C7267 WL_0_4 net86_4 1.14104e-05f
C7268 WL_0_4 net88_4 1.30836e-05f
C7269 WL_0_4 net94_4 1.7479e-05f
C7270 WL_0_5 WL_1_5 0.000690116f
C7271 WL_0_5 XB_0_0_3 0.000151087f
C7272 WL_0_5 XB_0_1_3 0.000156506f
C7273 WL_0_5 XB_0_2_3 0.000161098f
C7274 WL_0_5 XB_0_3_3 0.000161327f
C7275 WL_0_5 XB_0_4 0.000156888f
C7276 WL_0_5 XB_0_5 0.00015826f
C7277 WL_0_5 XB_0_6 0.000161573f
C7278 WL_0_5 XB_0_7 0.000159023f
C7279 WL_0_5 XB_1_0_3 1.03144e-05f
C7280 WL_0_5 XB_1_6_3 1.08244e-05f
C7281 WL_0_5 net10 0.00197334f
C7282 WL_0_5 net11_8 0.00282656f
C7283 WL_0_5 net13 0.0019701f
C7284 WL_0_5 net130_8 2.35068e-05f
C7285 WL_0_5 net132_8 1.20909e-05f
C7286 WL_0_5 net134_8 1.50575e-05f
C7287 WL_0_5 net135_8 1.52462e-05f
C7288 WL_0_5 net137_6 1.25763e-05f
C7289 WL_0_5 net139_6 1.22568e-05f
C7290 WL_0_5 net141_6 1.35156e-05f
C7291 WL_0_5 net142_6 1.8678e-05f
C7292 WL_0_5 net14_8 0.0028362f
C7293 WL_0_5 net16 0.00197991f
C7294 WL_0_5 net17 0.00282835f
C7295 WL_0_5 net19_6 0.00198115f
C7296 WL_0_5 net2 0.0019739f
C7297 WL_0_5 net20 0.00284276f
C7298 WL_0_5 net23_6 0.00197084f
C7299 WL_0_5 net24 0.00283727f
C7300 WL_0_5 net27_6 0.00196165f
C7301 WL_0_5 net28 0.00283185f
C7302 WL_0_5 net3_8 0.00282731f
C7303 WL_0_5 net6 0.00197306f
C7304 WL_0_5 net67 2.32971e-05f
C7305 WL_0_5 net68 1.5414e-05f
C7306 WL_0_5 net69 2.37531e-05f
C7307 WL_0_5 net70 1.66179e-05f
C7308 WL_0_5 net71 2.09441e-05f
C7309 WL_0_5 net72 1.57065e-05f
C7310 WL_0_5 net73 2.37204e-05f
C7311 WL_0_5 net74 1.29068e-05f
C7312 WL_0_5 net76_3 1.75771e-05f
C7313 WL_0_5 net79_3 1.41849e-05f
C7314 WL_0_5 net7_8 0.002841f
C7315 WL_0_5 net81_3 1.65042e-05f
C7316 WL_0_5 net84_3 1.52537e-05f
C7317 WL_0_5 net86_3 1.14104e-05f
C7318 WL_0_5 net88_4 1.30836e-05f
C7319 WL_0_5 net94_4 1.7479e-05f
C7320 WL_0_6 WL_1_6 0.000690116f
C7321 WL_0_6 XB_0_0_3 0.000151087f
C7322 WL_0_6 XB_0_1_3 0.000156506f
C7323 WL_0_6 XB_0_2_3 0.000161098f
C7324 WL_0_6 XB_0_3_3 0.000161327f
C7325 WL_0_6 XB_0_4_3 0.000156888f
C7326 WL_0_6 XB_0_5 0.00015826f
C7327 WL_0_6 XB_0_6 0.000161573f
C7328 WL_0_6 XB_0_7 0.000159023f
C7329 WL_0_6 XB_1_0_3 1.03144e-05f
C7330 WL_0_6 XB_1_6_3 1.08244e-05f
C7331 WL_0_6 net10 0.00197334f
C7332 WL_0_6 net11_8 0.00282656f
C7333 WL_0_6 net13 0.0019701f
C7334 WL_0_6 net130_8 2.35068e-05f
C7335 WL_0_6 net132_8 1.20909e-05f
C7336 WL_0_6 net134_8 1.50575e-05f
C7337 WL_0_6 net135_8 1.52462e-05f
C7338 WL_0_6 net137_8 1.25763e-05f
C7339 WL_0_6 net139_6 1.22568e-05f
C7340 WL_0_6 net141_6 1.35156e-05f
C7341 WL_0_6 net142_6 1.8678e-05f
C7342 WL_0_6 net14_8 0.0028362f
C7343 WL_0_6 net16 0.00197991f
C7344 WL_0_6 net17_8 0.00282835f
C7345 WL_0_6 net19 0.00198115f
C7346 WL_0_6 net2 0.0019739f
C7347 WL_0_6 net20 0.00284276f
C7348 WL_0_6 net23_6 0.00197084f
C7349 WL_0_6 net24 0.00283727f
C7350 WL_0_6 net27_6 0.00196165f
C7351 WL_0_6 net28 0.00283185f
C7352 WL_0_6 net3_8 0.00282731f
C7353 WL_0_6 net6 0.00197306f
C7354 WL_0_6 net67 2.32971e-05f
C7355 WL_0_6 net68 1.5414e-05f
C7356 WL_0_6 net69 2.37531e-05f
C7357 WL_0_6 net70 1.66179e-05f
C7358 WL_0_6 net71 2.09441e-05f
C7359 WL_0_6 net72 1.57065e-05f
C7360 WL_0_6 net73 2.37204e-05f
C7361 WL_0_6 net74 1.29068e-05f
C7362 WL_0_6 net76_3 1.75771e-05f
C7363 WL_0_6 net79_3 1.41849e-05f
C7364 WL_0_6 net7_8 0.002841f
C7365 WL_0_6 net81_3 1.65042e-05f
C7366 WL_0_6 net84_3 1.52537e-05f
C7367 WL_0_6 net86_3 1.14104e-05f
C7368 WL_0_6 net88_3 1.30836e-05f
C7369 WL_0_6 net94_4 1.7479e-05f
C7370 WL_0_7 WL_1_7 0.000690116f
C7371 WL_0_7 XB_0_0_3 0.000151087f
C7372 WL_0_7 XB_0_1_3 0.000156506f
C7373 WL_0_7 XB_0_2_3 0.000161098f
C7374 WL_0_7 XB_0_3_3 0.000161327f
C7375 WL_0_7 XB_0_4_3 0.000156888f
C7376 WL_0_7 XB_0_5_3 0.00015826f
C7377 WL_0_7 XB_0_6 0.000161573f
C7378 WL_0_7 XB_0_7 0.000159023f
C7379 WL_0_7 XB_1_0_3 1.03144e-05f
C7380 WL_0_7 XB_1_6_3 1.08244e-05f
C7381 WL_0_7 net10 0.00197334f
C7382 WL_0_7 net11_8 0.00282656f
C7383 WL_0_7 net13 0.0019701f
C7384 WL_0_7 net130_8 2.35068e-05f
C7385 WL_0_7 net132_8 1.20909e-05f
C7386 WL_0_7 net134_8 1.50575e-05f
C7387 WL_0_7 net135_8 1.52462e-05f
C7388 WL_0_7 net137_8 1.25763e-05f
C7389 WL_0_7 net139_8 1.22568e-05f
C7390 WL_0_7 net141_6 1.35156e-05f
C7391 WL_0_7 net142_6 1.8678e-05f
C7392 WL_0_7 net14_8 0.0028362f
C7393 WL_0_7 net16 0.00197991f
C7394 WL_0_7 net17_8 0.00282835f
C7395 WL_0_7 net19 0.00198115f
C7396 WL_0_7 net2 0.0019739f
C7397 WL_0_7 net20_8 0.00284276f
C7398 WL_0_7 net23 0.00197084f
C7399 WL_0_7 net24 0.00283727f
C7400 WL_0_7 net27_6 0.00196165f
C7401 WL_0_7 net28 0.00283185f
C7402 WL_0_7 net3_8 0.00282731f
C7403 WL_0_7 net6 0.00197306f
C7404 WL_0_7 net67 2.32971e-05f
C7405 WL_0_7 net68 1.5414e-05f
C7406 WL_0_7 net69 2.37531e-05f
C7407 WL_0_7 net70 1.66179e-05f
C7408 WL_0_7 net71 2.09441e-05f
C7409 WL_0_7 net72 1.57065e-05f
C7410 WL_0_7 net73 2.37204e-05f
C7411 WL_0_7 net74 1.29068e-05f
C7412 WL_0_7 net76_3 1.75771e-05f
C7413 WL_0_7 net79_3 1.41849e-05f
C7414 WL_0_7 net7_8 0.002841f
C7415 WL_0_7 net81_3 1.65042e-05f
C7416 WL_0_7 net84_3 1.52537e-05f
C7417 WL_0_7 net86_3 1.14104e-05f
C7418 WL_0_7 net88_3 1.30836e-05f
C7419 WL_0_7 net94_4 1.7479e-05f
C7420 WL_0_8 WL_1_8 0.000690116f
C7421 WL_0_8 XB_0_0_3 0.000151087f
C7422 WL_0_8 XB_0_1_3 0.000156506f
C7423 WL_0_8 XB_0_2_3 0.000161098f
C7424 WL_0_8 XB_0_3_3 0.000161327f
C7425 WL_0_8 XB_0_4_3 0.000156888f
C7426 WL_0_8 XB_0_5_3 0.00015826f
C7427 WL_0_8 XB_0_6_3 0.000161573f
C7428 WL_0_8 XB_0_7 0.000159023f
C7429 WL_0_8 XB_1_0_3 1.03144e-05f
C7430 WL_0_8 XB_1_6_3 1.08244e-05f
C7431 WL_0_8 net10 0.00197334f
C7432 WL_0_8 net11_8 0.00282656f
C7433 WL_0_8 net13 0.0019701f
C7434 WL_0_8 net130_8 2.35068e-05f
C7435 WL_0_8 net132_8 1.20909e-05f
C7436 WL_0_8 net134_8 1.50575e-05f
C7437 WL_0_8 net135_8 1.52462e-05f
C7438 WL_0_8 net137_8 1.25763e-05f
C7439 WL_0_8 net139_8 1.22568e-05f
C7440 WL_0_8 net141_8 1.35156e-05f
C7441 WL_0_8 net142_6 1.8678e-05f
C7442 WL_0_8 net14_8 0.0028362f
C7443 WL_0_8 net16 0.00197991f
C7444 WL_0_8 net17_8 0.00282835f
C7445 WL_0_8 net19 0.00198115f
C7446 WL_0_8 net2 0.0019739f
C7447 WL_0_8 net20_8 0.00284276f
C7448 WL_0_8 net23 0.00197084f
C7449 WL_0_8 net24_8 0.00283727f
C7450 WL_0_8 net27 0.00196165f
C7451 WL_0_8 net28 0.00283185f
C7452 WL_0_8 net3_8 0.00282731f
C7453 WL_0_8 net6 0.00197306f
C7454 WL_0_8 net67 2.32971e-05f
C7455 WL_0_8 net68 1.5414e-05f
C7456 WL_0_8 net69 2.37531e-05f
C7457 WL_0_8 net70 1.66179e-05f
C7458 WL_0_8 net71 2.09441e-05f
C7459 WL_0_8 net72 1.57065e-05f
C7460 WL_0_8 net73 2.37204e-05f
C7461 WL_0_8 net74 1.29068e-05f
C7462 WL_0_8 net76_3 1.75771e-05f
C7463 WL_0_8 net79_3 1.41849e-05f
C7464 WL_0_8 net7_8 0.002841f
C7465 WL_0_8 net81_3 1.65042e-05f
C7466 WL_0_8 net84_3 1.52537e-05f
C7467 WL_0_8 net86_3 1.14104e-05f
C7468 WL_0_8 net88_3 1.30836e-05f
C7469 WL_0_8 net94_3 1.7479e-05f
C7470 WL_0_9 WL_1_1 0.000727383f
C7471 WL_0_9 XB_0_0 0.000159246f
C7472 WL_0_9 XB_0_1 0.000164957f
C7473 WL_0_9 XB_0_2 0.000169798f
C7474 WL_0_9 XB_0_3 0.000170039f
C7475 WL_0_9 XB_0_4 0.00016536f
C7476 WL_0_9 XB_0_5 0.000166806f
C7477 WL_0_9 XB_0_6 0.000170298f
C7478 WL_0_9 XB_0_7 0.000167611f
C7479 WL_0_9 XB_1_0_3 1.08714e-05f
C7480 WL_0_9 XB_1_6 1.14089e-05f
C7481 WL_0_9 net10_6 0.0020799f
C7482 WL_0_9 net11 0.00297919f
C7483 WL_0_9 net130_6 2.47762e-05f
C7484 WL_0_9 net132_6 1.27438e-05f
C7485 WL_0_9 net134_6 1.58707e-05f
C7486 WL_0_9 net135_6 1.60695e-05f
C7487 WL_0_9 net137_6 1.32554e-05f
C7488 WL_0_9 net139_6 1.29187e-05f
C7489 WL_0_9 net13_6 0.00207649f
C7490 WL_0_9 net14 0.00298936f
C7491 WL_0_9 net141_6 1.42454e-05f
C7492 WL_0_9 net142_6 1.96867e-05f
C7493 WL_0_9 net16_6 0.00208683f
C7494 WL_0_9 net17 0.00298108f
C7495 WL_0_9 net19_6 0.00208814f
C7496 WL_0_9 net2 0.00208049f
C7497 WL_0_9 net20 0.00299628f
C7498 WL_0_9 net23_4 0.00207726f
C7499 WL_0_9 net24 0.00299049f
C7500 WL_0_9 net27_4 0.00206758f
C7501 WL_0_9 net28 0.00298478f
C7502 WL_0_9 net3 0.00297998f
C7503 WL_0_9 net67 2.45552e-05f
C7504 WL_0_9 net68 1.62464e-05f
C7505 WL_0_9 net69 2.50358e-05f
C7506 WL_0_9 net6_6 0.00207961f
C7507 WL_0_9 net7 0.00299442f
C7508 WL_0_9 net70 1.75153e-05f
C7509 WL_0_9 net71 2.20752e-05f
C7510 WL_0_9 net72 1.65547e-05f
C7511 WL_0_9 net73 2.50013e-05f
C7512 WL_0_9 net74 1.36038e-05f
C7513 WL_0_9 net76_3 1.85262e-05f
C7514 WL_0_9 net79_4 1.49509e-05f
C7515 WL_0_9 net81_4 1.73954e-05f
C7516 WL_0_9 net84_4 1.60774e-05f
C7517 WL_0_9 net86_4 1.20266e-05f
C7518 WL_0_9 net88_4 1.37901e-05f
C7519 WL_0_9 net94_4 1.84229e-05f
C7520 WL_1 XB_1_0 6.53358e-05f
C7521 WL_1 XB_1_1 5.84604e-05f
C7522 WL_1 XB_1_2 6.22868e-05f
C7523 WL_1 XB_1_3 5.89277e-05f
C7524 WL_1 XB_1_4 6.09573e-05f
C7525 WL_1 XB_1_5 5.92113e-05f
C7526 WL_1 XB_1_6 5.94363e-05f
C7527 WL_1 XB_1_7 5.59861e-05f
C7528 WL_1 net130 0.00108529f
C7529 WL_1 net132 0.00108703f
C7530 WL_1 net134 0.00108636f
C7531 WL_1 net135 0.00108768f
C7532 WL_1 net137 0.00108345f
C7533 WL_1 net139 0.0010899f
C7534 WL_1 net141 0.001084f
C7535 WL_1 net142 0.00108183f
C7536 WL_1 net3_6 1.14839e-05f
C7537 WL_1 net76_4 0.000751422f
C7538 WL_1 net79_4 0.0007522f
C7539 WL_1 net81_4 0.000748423f
C7540 WL_1 net84_4 0.000747253f
C7541 WL_1 net86_4 0.000751981f
C7542 WL_1 net88_5 0.00075288f
C7543 WL_1 net91_5 0.000744515f
C7544 WL_1 net93 1.02888e-05f
C7545 WL_1 net94_5 0.000748586f
C7546 WL_1_1 XB_0_6 1.11805e-05f
C7547 WL_1_1 XB_1_0 0.000156811f
C7548 WL_1_1 XB_1_1 0.00014031f
C7549 WL_1_1 XB_1_2 0.000149494f
C7550 WL_1_1 XB_1_3 0.000141431f
C7551 WL_1_1 XB_1_4 0.000146303f
C7552 WL_1_1 XB_1_5 0.000142112f
C7553 WL_1_1 XB_1_6 0.000142652f
C7554 WL_1_1 XB_1_7 0.000134371f
C7555 WL_1_1 net11_6 1.40303e-05f
C7556 WL_1_1 net130 0.00260479f
C7557 WL_1_1 net132 0.00260896f
C7558 WL_1_1 net134 0.00260734f
C7559 WL_1_1 net135 0.00261052f
C7560 WL_1_1 net137 0.00260037f
C7561 WL_1_1 net139 0.00261585f
C7562 WL_1_1 net13_6 1.792e-05f
C7563 WL_1_1 net141 0.00260169f
C7564 WL_1_1 net142 0.00259649f
C7565 WL_1_1 net14_6 2.02758e-05f
C7566 WL_1_1 net16_6 1.30239e-05f
C7567 WL_1_1 net17_6 1.61399e-05f
C7568 WL_1_1 net19_6 1.44284e-05f
C7569 WL_1_1 net20_6 1.95138e-05f
C7570 WL_1_1 net24_6 1.62274e-05f
C7571 WL_1_1 net27_6 1.22781e-05f
C7572 WL_1_1 net28_6 2.06025e-05f
C7573 WL_1_1 net3_6 2.75624e-05f
C7574 WL_1_1 net6_6 1.60237e-05f
C7575 WL_1_1 net76 0.00180348f
C7576 WL_1_1 net78 1.77078e-05f
C7577 WL_1_1 net79_4 0.00180534f
C7578 WL_1_1 net7_6 2.03112e-05f
C7579 WL_1_1 net80 1.4182e-05f
C7580 WL_1_1 net81_4 0.00179628f
C7581 WL_1_1 net83 2.30981e-05f
C7582 WL_1_1 net84_4 0.00179347f
C7583 WL_1_1 net85 1.41369e-05f
C7584 WL_1_1 net86_4 0.00180482f
C7585 WL_1_1 net87 2.03493e-05f
C7586 WL_1_1 net88_4 0.00180698f
C7587 WL_1_1 net90 1.31649e-05f
C7588 WL_1_1 net91_5 0.0017869f
C7589 WL_1_1 net93 2.46939e-05f
C7590 WL_1_1 net94_5 0.00179667f
C7591 WL_1_10 XB_0_0_3 1.19817e-05f
C7592 WL_1_10 XB_0_2_3 1.06089e-05f
C7593 WL_1_10 XB_0_6 2.01621e-05f
C7594 WL_1_10 XB_1_0_3 0.000282782f
C7595 WL_1_10 XB_1_1 0.000253025f
C7596 WL_1_10 XB_1_2 0.000269585f
C7597 WL_1_10 XB_1_3 0.000255047f
C7598 WL_1_10 XB_1_4 0.000263831f
C7599 WL_1_10 XB_1_5 0.000256274f
C7600 WL_1_10 XB_1_6 0.000257248f
C7601 WL_1_10 XB_1_7 0.000242315f
C7602 WL_1_10 net10_6 1.52745e-05f
C7603 WL_1_10 net11_6 2.53012e-05f
C7604 WL_1_10 net130_8 0.00469729f
C7605 WL_1_10 net132 0.0047048f
C7606 WL_1_10 net134 0.00470189f
C7607 WL_1_10 net135 0.00470762f
C7608 WL_1_10 net137 0.00468932f
C7609 WL_1_10 net139 0.00471722f
C7610 WL_1_10 net13_6 3.23155e-05f
C7611 WL_1_10 net141 0.00469169f
C7612 WL_1_10 net142 0.00468232f
C7613 WL_1_10 net14_6 3.65638e-05f
C7614 WL_1_10 net16_6 2.34863e-05f
C7615 WL_1_10 net17_6 2.91055e-05f
C7616 WL_1_10 net19_6 2.6019e-05f
C7617 WL_1_10 net20_6 3.51896e-05f
C7618 WL_1_10 net23_6 1.15383e-05f
C7619 WL_1_10 net24_6 2.92632e-05f
C7620 WL_1_10 net27_6 2.21415e-05f
C7621 WL_1_10 net28_6 3.71531e-05f
C7622 WL_1_10 net2_3 1.59864e-05f
C7623 WL_1_10 net3_8 4.97039e-05f
C7624 WL_1_10 net6_3 2.88959e-05f
C7625 WL_1_10 net73 1.57786e-05f
C7626 WL_1_10 net76 0.00325226f
C7627 WL_1_10 net78 3.19329e-05f
C7628 WL_1_10 net79 0.00325562f
C7629 WL_1_10 net7_6 3.66276e-05f
C7630 WL_1_10 net80 2.55748e-05f
C7631 WL_1_10 net81_4 0.00323927f
C7632 WL_1_10 net83 4.16533e-05f
C7633 WL_1_10 net84_4 0.00323421f
C7634 WL_1_10 net85 2.54934e-05f
C7635 WL_1_10 net86_4 0.00325467f
C7636 WL_1_10 net87 3.66964e-05f
C7637 WL_1_10 net88_4 0.00325857f
C7638 WL_1_10 net90 2.37406e-05f
C7639 WL_1_10 net91_4 0.00322236f
C7640 WL_1_10 net93 4.45312e-05f
C7641 WL_1_10 net94_5 0.00323998f
C7642 WL_1_10 net96 1.59781e-05f
C7643 WL_1_11 XB_0_0_3 1.08924e-05f
C7644 WL_1_11 XB_0_6 1.83291e-05f
C7645 WL_1_11 XB_1_0_3 0.000257074f
C7646 WL_1_11 XB_1_1_3 0.000230022f
C7647 WL_1_11 XB_1_2 0.000245078f
C7648 WL_1_11 XB_1_3 0.000231861f
C7649 WL_1_11 XB_1_4 0.000239847f
C7650 WL_1_11 XB_1_5 0.000232976f
C7651 WL_1_11 XB_1_6 0.000233862f
C7652 WL_1_11 XB_1_7 0.000220286f
C7653 WL_1_11 net10_3 1.38859e-05f
C7654 WL_1_11 net11_6 2.30011e-05f
C7655 WL_1_11 net130_8 0.00427026f
C7656 WL_1_11 net132_8 0.00427709f
C7657 WL_1_11 net134 0.00427444f
C7658 WL_1_11 net135 0.00427966f
C7659 WL_1_11 net137 0.00426302f
C7660 WL_1_11 net139 0.00428838f
C7661 WL_1_11 net13_6 2.93777e-05f
C7662 WL_1_11 net141 0.00426517f
C7663 WL_1_11 net142 0.00425665f
C7664 WL_1_11 net14_6 3.32398e-05f
C7665 WL_1_11 net16_6 2.13512e-05f
C7666 WL_1_11 net17_6 2.64595e-05f
C7667 WL_1_11 net19_6 2.36536e-05f
C7668 WL_1_11 net20_6 3.19906e-05f
C7669 WL_1_11 net23_6 1.04894e-05f
C7670 WL_1_11 net24_6 2.66029e-05f
C7671 WL_1_11 net27_6 2.01286e-05f
C7672 WL_1_11 net28_6 3.37755e-05f
C7673 WL_1_11 net2_3 1.45331e-05f
C7674 WL_1_11 net3_8 4.51854e-05f
C7675 WL_1_11 net6_3 2.6269e-05f
C7676 WL_1_11 net73 1.43442e-05f
C7677 WL_1_11 net76 0.0029566f
C7678 WL_1_11 net78 2.903e-05f
C7679 WL_1_11 net79 0.00295965f
C7680 WL_1_11 net7_8 3.32979e-05f
C7681 WL_1_11 net80 2.32498e-05f
C7682 WL_1_11 net81 0.00294479f
C7683 WL_1_11 net83 3.78666e-05f
C7684 WL_1_11 net84_4 0.00294019f
C7685 WL_1_11 net85 2.31758e-05f
C7686 WL_1_11 net86_4 0.00295879f
C7687 WL_1_11 net87 3.33603e-05f
C7688 WL_1_11 net88_4 0.00296233f
C7689 WL_1_11 net90 2.15824e-05f
C7690 WL_1_11 net91_4 0.00292942f
C7691 WL_1_11 net93 4.04829e-05f
C7692 WL_1_11 net94_4 0.00294544f
C7693 WL_1_11 net96 1.45255e-05f
C7694 WL_1_12 XB_0_0_3 1.19817e-05f
C7695 WL_1_12 XB_0_2_3 1.06089e-05f
C7696 WL_1_12 XB_0_6 2.01621e-05f
C7697 WL_1_12 XB_1_0_3 0.000282782f
C7698 WL_1_12 XB_1_1_3 0.000253025f
C7699 WL_1_12 XB_1_2_3 0.000269585f
C7700 WL_1_12 XB_1_3 0.000255047f
C7701 WL_1_12 XB_1_4 0.000263831f
C7702 WL_1_12 XB_1_5 0.000256274f
C7703 WL_1_12 XB_1_6 0.000257248f
C7704 WL_1_12 XB_1_7 0.000242315f
C7705 WL_1_12 net10_3 1.52745e-05f
C7706 WL_1_12 net11_8 2.53012e-05f
C7707 WL_1_12 net130_8 0.00469729f
C7708 WL_1_12 net132_8 0.0047048f
C7709 WL_1_12 net134_8 0.00470189f
C7710 WL_1_12 net135 0.00470762f
C7711 WL_1_12 net137 0.00468932f
C7712 WL_1_12 net139 0.00471722f
C7713 WL_1_12 net13_3 3.23155e-05f
C7714 WL_1_12 net141 0.00469169f
C7715 WL_1_12 net142 0.00468232f
C7716 WL_1_12 net14_6 3.65638e-05f
C7717 WL_1_12 net16_6 2.34863e-05f
C7718 WL_1_12 net17_6 2.91055e-05f
C7719 WL_1_12 net19_6 2.6019e-05f
C7720 WL_1_12 net20_6 3.51896e-05f
C7721 WL_1_12 net23_6 1.15383e-05f
C7722 WL_1_12 net24_6 2.92632e-05f
C7723 WL_1_12 net27_6 2.21415e-05f
C7724 WL_1_12 net28_6 3.71531e-05f
C7725 WL_1_12 net2_3 1.59864e-05f
C7726 WL_1_12 net3_8 4.97039e-05f
C7727 WL_1_12 net6_3 2.88959e-05f
C7728 WL_1_12 net73 1.57786e-05f
C7729 WL_1_12 net76 0.00325226f
C7730 WL_1_12 net78 3.19329e-05f
C7731 WL_1_12 net79 0.00325562f
C7732 WL_1_12 net7_8 3.66276e-05f
C7733 WL_1_12 net80 2.55748e-05f
C7734 WL_1_12 net81 0.00323927f
C7735 WL_1_12 net83 4.16533e-05f
C7736 WL_1_12 net84 0.00323421f
C7737 WL_1_12 net85 2.54934e-05f
C7738 WL_1_12 net86_4 0.00325467f
C7739 WL_1_12 net87 3.66964e-05f
C7740 WL_1_12 net88_4 0.00325857f
C7741 WL_1_12 net90 2.37406e-05f
C7742 WL_1_12 net91_4 0.00322236f
C7743 WL_1_12 net93 4.45312e-05f
C7744 WL_1_12 net94_4 0.00323998f
C7745 WL_1_12 net96 1.59781e-05f
C7746 WL_1_13 XB_0_0_3 1.19817e-05f
C7747 WL_1_13 XB_0_2_3 1.06089e-05f
C7748 WL_1_13 XB_0_6_3 2.01621e-05f
C7749 WL_1_13 XB_1_0_3 0.000282782f
C7750 WL_1_13 XB_1_1_3 0.000253025f
C7751 WL_1_13 XB_1_2_3 0.000269585f
C7752 WL_1_13 XB_1_3_3 0.000255047f
C7753 WL_1_13 XB_1_4 0.000263831f
C7754 WL_1_13 XB_1_5 0.000256274f
C7755 WL_1_13 XB_1_6 0.000257248f
C7756 WL_1_13 XB_1_7 0.000242315f
C7757 WL_1_13 net10_3 1.52745e-05f
C7758 WL_1_13 net11_8 2.53012e-05f
C7759 WL_1_13 net130_8 0.00469729f
C7760 WL_1_13 net132_8 0.0047048f
C7761 WL_1_13 net134_8 0.00470189f
C7762 WL_1_13 net135_8 0.00470762f
C7763 WL_1_13 net137 0.00468932f
C7764 WL_1_13 net139 0.00471722f
C7765 WL_1_13 net13_3 3.23155e-05f
C7766 WL_1_13 net141 0.00469169f
C7767 WL_1_13 net142 0.00468232f
C7768 WL_1_13 net14_8 3.65638e-05f
C7769 WL_1_13 net16_3 2.34863e-05f
C7770 WL_1_13 net17_6 2.91055e-05f
C7771 WL_1_13 net19_6 2.6019e-05f
C7772 WL_1_13 net20_6 3.51896e-05f
C7773 WL_1_13 net23_6 1.15383e-05f
C7774 WL_1_13 net24_6 2.92632e-05f
C7775 WL_1_13 net27_6 2.21415e-05f
C7776 WL_1_13 net28_6 3.71531e-05f
C7777 WL_1_13 net2_3 1.59864e-05f
C7778 WL_1_13 net3_8 4.97039e-05f
C7779 WL_1_13 net6_3 2.88959e-05f
C7780 WL_1_13 net73 1.57786e-05f
C7781 WL_1_13 net76 0.00325226f
C7782 WL_1_13 net78 3.19329e-05f
C7783 WL_1_13 net79 0.00325562f
C7784 WL_1_13 net7_8 3.66276e-05f
C7785 WL_1_13 net80 2.55748e-05f
C7786 WL_1_13 net81 0.00323927f
C7787 WL_1_13 net83 4.16533e-05f
C7788 WL_1_13 net84 0.00323421f
C7789 WL_1_13 net85 2.54934e-05f
C7790 WL_1_13 net86 0.00325467f
C7791 WL_1_13 net87 3.66964e-05f
C7792 WL_1_13 net88_4 0.00325857f
C7793 WL_1_13 net90 2.37406e-05f
C7794 WL_1_13 net91_4 0.00322236f
C7795 WL_1_13 net93 4.45312e-05f
C7796 WL_1_13 net94_4 0.00323998f
C7797 WL_1_13 net96 1.59781e-05f
C7798 WL_1_14 XB_0_0_3 1.19817e-05f
C7799 WL_1_14 XB_0_2_3 1.06089e-05f
C7800 WL_1_14 XB_0_6_3 2.01621e-05f
C7801 WL_1_14 XB_1_0_3 0.000282782f
C7802 WL_1_14 XB_1_1_3 0.000253025f
C7803 WL_1_14 XB_1_2_3 0.000269585f
C7804 WL_1_14 XB_1_3_3 0.000255047f
C7805 WL_1_14 XB_1_4_3 0.000263831f
C7806 WL_1_14 XB_1_5 0.000256274f
C7807 WL_1_14 XB_1_6 0.000257248f
C7808 WL_1_14 XB_1_7 0.000242315f
C7809 WL_1_14 net10_3 1.52745e-05f
C7810 WL_1_14 net11_8 2.53012e-05f
C7811 WL_1_14 net130_8 0.00469729f
C7812 WL_1_14 net132_8 0.0047048f
C7813 WL_1_14 net134_8 0.00470189f
C7814 WL_1_14 net135_8 0.00470762f
C7815 WL_1_14 net137_8 0.00468932f
C7816 WL_1_14 net139 0.00471722f
C7817 WL_1_14 net13_3 3.23155e-05f
C7818 WL_1_14 net141 0.00469169f
C7819 WL_1_14 net142 0.00468232f
C7820 WL_1_14 net14_8 3.65638e-05f
C7821 WL_1_14 net16_3 2.34863e-05f
C7822 WL_1_14 net17_8 2.91055e-05f
C7823 WL_1_14 net19_3 2.6019e-05f
C7824 WL_1_14 net20_6 3.51896e-05f
C7825 WL_1_14 net23_6 1.15383e-05f
C7826 WL_1_14 net24_6 2.92632e-05f
C7827 WL_1_14 net27_6 2.21415e-05f
C7828 WL_1_14 net28_6 3.71531e-05f
C7829 WL_1_14 net2_3 1.59864e-05f
C7830 WL_1_14 net3_8 4.97039e-05f
C7831 WL_1_14 net6_3 2.88959e-05f
C7832 WL_1_14 net73 1.57786e-05f
C7833 WL_1_14 net76 0.00325226f
C7834 WL_1_14 net78 3.19329e-05f
C7835 WL_1_14 net79 0.00325562f
C7836 WL_1_14 net7_8 3.66276e-05f
C7837 WL_1_14 net80 2.55748e-05f
C7838 WL_1_14 net81 0.00323927f
C7839 WL_1_14 net83 4.16533e-05f
C7840 WL_1_14 net84 0.00323421f
C7841 WL_1_14 net85 2.54934e-05f
C7842 WL_1_14 net86 0.00325467f
C7843 WL_1_14 net87 3.66964e-05f
C7844 WL_1_14 net88 0.00325857f
C7845 WL_1_14 net90 2.37406e-05f
C7846 WL_1_14 net91_4 0.00322236f
C7847 WL_1_14 net93 4.45312e-05f
C7848 WL_1_14 net94_4 0.00323998f
C7849 WL_1_14 net96 1.59781e-05f
C7850 WL_1_15 XB_0_0_3 2.61418e-05f
C7851 WL_1_15 XB_0_2_3 2.31466e-05f
C7852 WL_1_15 XB_0_6_3 4.399e-05f
C7853 WL_1_15 XB_1_0_3 0.000616978f
C7854 WL_1_15 XB_1_1_3 0.000552054f
C7855 WL_1_15 XB_1_2_3 0.000588186f
C7856 WL_1_15 XB_1_3_3 0.000556465f
C7857 WL_1_15 XB_1_4_3 0.000575632f
C7858 WL_1_15 XB_1_5_3 0.000559143f
C7859 WL_1_15 XB_1_6 0.000561269f
C7860 WL_1_15 XB_1_7 0.000528688f
C7861 WL_1_15 net10_3 3.33261e-05f
C7862 WL_1_15 net11_8 5.52026e-05f
C7863 WL_1_15 net130_8 0.0102486f
C7864 WL_1_15 net132_8 0.010265f
C7865 WL_1_15 net134_8 0.0102587f
C7866 WL_1_15 net135_8 0.0102712f
C7867 WL_1_15 net137_8 0.0102312f
C7868 WL_1_15 net139_8 0.0102921f
C7869 WL_1_15 net13_3 7.05066e-05f
C7870 WL_1_15 net141 0.0102364f
C7871 WL_1_15 net142 0.010216f
C7872 WL_1_15 net14_8 7.97755e-05f
C7873 WL_1_15 net16_3 5.12429e-05f
C7874 WL_1_15 net17_8 6.35028e-05f
C7875 WL_1_15 net19_3 5.67687e-05f
C7876 WL_1_15 net20_8 7.67774e-05f
C7877 WL_1_15 net23_3 2.51745e-05f
C7878 WL_1_15 net24_6 6.3847e-05f
C7879 WL_1_15 net27_6 4.83087e-05f
C7880 WL_1_15 net28_6 8.10612e-05f
C7881 WL_1_15 net2_3 3.48794e-05f
C7882 WL_1_15 net3_8 0.000108445f
C7883 WL_1_15 net67 1.91067e-05f
C7884 WL_1_15 net69 1.35872e-05f
C7885 WL_1_15 net6_3 6.30456e-05f
C7886 WL_1_15 net71 2.10591e-05f
C7887 WL_1_15 net73 3.4426e-05f
C7888 WL_1_15 net76 0.00709583f
C7889 WL_1_15 net78 6.96719e-05f
C7890 WL_1_15 net79 0.00710317f
C7891 WL_1_15 net7_8 7.99148e-05f
C7892 WL_1_15 net80 5.57996e-05f
C7893 WL_1_15 net81 0.00706751f
C7894 WL_1_15 net83 9.08799e-05f
C7895 WL_1_15 net84 0.00705645f
C7896 WL_1_15 net85 5.5622e-05f
C7897 WL_1_15 net86 0.0071011f
C7898 WL_1_15 net87 8.00648e-05f
C7899 WL_1_15 net88 0.0071096f
C7900 WL_1_15 net90 5.17977e-05f
C7901 WL_1_15 net91 0.0070306f
C7902 WL_1_15 net93 9.7159e-05f
C7903 WL_1_15 net94_4 0.00706905f
C7904 WL_1_15 net96 3.48612e-05f
C7905 WL_1_16 XB_1_0 0.000130005f
C7906 WL_1_16 XB_1_1 0.000116325f
C7907 WL_1_16 XB_1_2 0.000123938f
C7908 WL_1_16 XB_1_3 0.000117254f
C7909 WL_1_16 XB_1_4 0.000121293f
C7910 WL_1_16 XB_1_5 0.000117818f
C7911 WL_1_16 XB_1_6 0.000118266f
C7912 WL_1_16 XB_1_7 0.000111401f
C7913 WL_1_16 net11_6 1.16319e-05f
C7914 WL_1_16 net130_5 0.00215951f
C7915 WL_1_16 net132_5 0.00216297f
C7916 WL_1_16 net134_5 0.00216163f
C7917 WL_1_16 net135_5 0.00216426f
C7918 WL_1_16 net137_5 0.00215585f
C7919 WL_1_16 net139_5 0.00216868f
C7920 WL_1_16 net13_6 1.48566e-05f
C7921 WL_1_16 net141_5 0.00215694f
C7922 WL_1_16 net142_5 0.00215263f
C7923 WL_1_16 net14_6 1.68097e-05f
C7924 WL_1_16 net16_6 1.07975e-05f
C7925 WL_1_16 net17_6 1.33808e-05f
C7926 WL_1_16 net19_6 1.19619e-05f
C7927 WL_1_16 net20_6 1.6178e-05f
C7928 WL_1_16 net24_6 1.34534e-05f
C7929 WL_1_16 net27_6 1.01792e-05f
C7930 WL_1_16 net28_6 1.70806e-05f
C7931 WL_1_16 net3_6 2.28507e-05f
C7932 WL_1_16 net6_6 1.32845e-05f
C7933 WL_1_16 net76_5 0.00149518f
C7934 WL_1_16 net78 1.46807e-05f
C7935 WL_1_16 net79_5 0.00149673f
C7936 WL_1_16 net7_6 1.68391e-05f
C7937 WL_1_16 net80 1.17577e-05f
C7938 WL_1_16 net81_5 0.00148921f
C7939 WL_1_16 net83 1.91495e-05f
C7940 WL_1_16 net84_5 0.00148688f
C7941 WL_1_16 net85 1.17202e-05f
C7942 WL_1_16 net86_5 0.00149629f
C7943 WL_1_16 net87 1.68706e-05f
C7944 WL_1_16 net88_5 0.00149808f
C7945 WL_1_16 net90 1.09144e-05f
C7946 WL_1_16 net91_5 0.00148144f
C7947 WL_1_16 net93 2.04726e-05f
C7948 WL_1_16 net94_5 0.00148954f
C7949 WL_1_17 XB_1_0 0.000130005f
C7950 WL_1_17 XB_1_1 0.000116325f
C7951 WL_1_17 XB_1_2 0.000123938f
C7952 WL_1_17 XB_1_3 0.000117254f
C7953 WL_1_17 XB_1_4 0.000121293f
C7954 WL_1_17 XB_1_5 0.000117818f
C7955 WL_1_17 XB_1_6 0.000118266f
C7956 WL_1_17 XB_1_7 0.000111401f
C7957 WL_1_17 net11_6 1.16319e-05f
C7958 WL_1_17 net130_10 0.00215951f
C7959 WL_1_17 net132_5 0.00216297f
C7960 WL_1_17 net134_5 0.00216163f
C7961 WL_1_17 net135_5 0.00216426f
C7962 WL_1_17 net137_5 0.00215585f
C7963 WL_1_17 net139_5 0.00216868f
C7964 WL_1_17 net13_6 1.48566e-05f
C7965 WL_1_17 net141_5 0.00215694f
C7966 WL_1_17 net142_5 0.00215263f
C7967 WL_1_17 net14_6 1.68097e-05f
C7968 WL_1_17 net16_6 1.07975e-05f
C7969 WL_1_17 net17_6 1.33808e-05f
C7970 WL_1_17 net19_6 1.19619e-05f
C7971 WL_1_17 net20_6 1.6178e-05f
C7972 WL_1_17 net24_6 1.34534e-05f
C7973 WL_1_17 net27_6 1.01792e-05f
C7974 WL_1_17 net28_6 1.70806e-05f
C7975 WL_1_17 net3_11 2.28507e-05f
C7976 WL_1_17 net6_6 1.32845e-05f
C7977 WL_1_17 net76_2 0.00149518f
C7978 WL_1_17 net78 1.46807e-05f
C7979 WL_1_17 net79_5 0.00149673f
C7980 WL_1_17 net7_6 1.68391e-05f
C7981 WL_1_17 net80 1.17577e-05f
C7982 WL_1_17 net81_5 0.00148921f
C7983 WL_1_17 net83 1.91495e-05f
C7984 WL_1_17 net84_5 0.00148688f
C7985 WL_1_17 net85 1.17202e-05f
C7986 WL_1_17 net86_5 0.00149629f
C7987 WL_1_17 net87 1.68706e-05f
C7988 WL_1_17 net88_5 0.00149808f
C7989 WL_1_17 net90 1.09144e-05f
C7990 WL_1_17 net91_5 0.00148144f
C7991 WL_1_17 net93 2.04726e-05f
C7992 WL_1_17 net94_5 0.00148954f
C7993 WL_1_18 XB_1_0_2 0.000130005f
C7994 WL_1_18 XB_1_1 0.000116325f
C7995 WL_1_18 XB_1_2 0.000123938f
C7996 WL_1_18 XB_1_3 0.000117254f
C7997 WL_1_18 XB_1_4 0.000121293f
C7998 WL_1_18 XB_1_5 0.000117818f
C7999 WL_1_18 XB_1_6 0.000118266f
C8000 WL_1_18 XB_1_7 0.000111401f
C8001 WL_1_18 net11_6 1.16319e-05f
C8002 WL_1_18 net130_7 0.00215951f
C8003 WL_1_18 net132_5 0.00216297f
C8004 WL_1_18 net134_5 0.00216163f
C8005 WL_1_18 net135_5 0.00216426f
C8006 WL_1_18 net137_5 0.00215585f
C8007 WL_1_18 net139_5 0.00216868f
C8008 WL_1_18 net13_6 1.48566e-05f
C8009 WL_1_18 net141_5 0.00215694f
C8010 WL_1_18 net142_5 0.00215263f
C8011 WL_1_18 net14_6 1.68097e-05f
C8012 WL_1_18 net16_6 1.07975e-05f
C8013 WL_1_18 net17_6 1.33808e-05f
C8014 WL_1_18 net19_6 1.19619e-05f
C8015 WL_1_18 net20_6 1.6178e-05f
C8016 WL_1_18 net24_6 1.34534e-05f
C8017 WL_1_18 net27_6 1.01792e-05f
C8018 WL_1_18 net28_6 1.70806e-05f
C8019 WL_1_18 net3_8 2.28507e-05f
C8020 WL_1_18 net6_6 1.32845e-05f
C8021 WL_1_18 net76_2 0.00149518f
C8022 WL_1_18 net78 1.46807e-05f
C8023 WL_1_18 net79_5 0.00149673f
C8024 WL_1_18 net7_6 1.68391e-05f
C8025 WL_1_18 net80 1.17577e-05f
C8026 WL_1_18 net81_5 0.00148921f
C8027 WL_1_18 net83 1.91495e-05f
C8028 WL_1_18 net84_5 0.00148688f
C8029 WL_1_18 net85 1.17202e-05f
C8030 WL_1_18 net86_5 0.00149629f
C8031 WL_1_18 net87 1.68706e-05f
C8032 WL_1_18 net88_5 0.00149808f
C8033 WL_1_18 net90 1.09144e-05f
C8034 WL_1_18 net91_5 0.00148144f
C8035 WL_1_18 net93 2.04726e-05f
C8036 WL_1_18 net94_5 0.00148954f
C8037 WL_1_19 XB_1_0_2 0.000130005f
C8038 WL_1_19 XB_1_1 0.000116325f
C8039 WL_1_19 XB_1_2 0.000123938f
C8040 WL_1_19 XB_1_3 0.000117254f
C8041 WL_1_19 XB_1_4 0.000121293f
C8042 WL_1_19 XB_1_5 0.000117818f
C8043 WL_1_19 XB_1_6 0.000118266f
C8044 WL_1_19 XB_1_7 0.000111401f
C8045 WL_1_19 net11_6 1.16319e-05f
C8046 WL_1_19 net130_7 0.00215951f
C8047 WL_1_19 net132_10 0.00216297f
C8048 WL_1_19 net134_5 0.00216163f
C8049 WL_1_19 net135_5 0.00216426f
C8050 WL_1_19 net137_5 0.00215585f
C8051 WL_1_19 net139_5 0.00216868f
C8052 WL_1_19 net13_6 1.48566e-05f
C8053 WL_1_19 net141_5 0.00215694f
C8054 WL_1_19 net142_5 0.00215263f
C8055 WL_1_19 net14_6 1.68097e-05f
C8056 WL_1_19 net16_6 1.07975e-05f
C8057 WL_1_19 net17_6 1.33808e-05f
C8058 WL_1_19 net19_6 1.19619e-05f
C8059 WL_1_19 net20_6 1.6178e-05f
C8060 WL_1_19 net24_6 1.34534e-05f
C8061 WL_1_19 net27_6 1.01792e-05f
C8062 WL_1_19 net28_6 1.70806e-05f
C8063 WL_1_19 net3_8 2.28507e-05f
C8064 WL_1_19 net6_3 1.32845e-05f
C8065 WL_1_19 net76_2 0.00149518f
C8066 WL_1_19 net78 1.46807e-05f
C8067 WL_1_19 net79_2 0.00149673f
C8068 WL_1_19 net7_11 1.68391e-05f
C8069 WL_1_19 net80 1.17577e-05f
C8070 WL_1_19 net81_5 0.00148921f
C8071 WL_1_19 net83 1.91495e-05f
C8072 WL_1_19 net84_5 0.00148688f
C8073 WL_1_19 net85 1.17202e-05f
C8074 WL_1_19 net86_5 0.00149629f
C8075 WL_1_19 net87 1.68706e-05f
C8076 WL_1_19 net88_5 0.00149808f
C8077 WL_1_19 net90 1.09144e-05f
C8078 WL_1_19 net91_5 0.00148144f
C8079 WL_1_19 net93 2.04726e-05f
C8080 WL_1_19 net94_5 0.00148954f
C8081 WL_1_2 XB_0_6 1.2173e-05f
C8082 WL_1_2 XB_1_0_3 0.000170732f
C8083 WL_1_2 XB_1_1 0.000152766f
C8084 WL_1_2 XB_1_2 0.000162765f
C8085 WL_1_2 XB_1_3 0.000153987f
C8086 WL_1_2 XB_1_4 0.000159291f
C8087 WL_1_2 XB_1_5 0.000154728f
C8088 WL_1_2 XB_1_6 0.000155316f
C8089 WL_1_2 XB_1_7 0.0001463f
C8090 WL_1_2 net11_6 1.52759e-05f
C8091 WL_1_2 net130_8 0.00283603f
C8092 WL_1_2 net132 0.00284057f
C8093 WL_1_2 net134 0.00283881f
C8094 WL_1_2 net135 0.00284227f
C8095 WL_1_2 net137 0.00283122f
C8096 WL_1_2 net139 0.00284807f
C8097 WL_1_2 net13_6 1.95108e-05f
C8098 WL_1_2 net141 0.00283265f
C8099 WL_1_2 net142 0.00282699f
C8100 WL_1_2 net14_6 2.20757e-05f
C8101 WL_1_2 net16_6 1.41801e-05f
C8102 WL_1_2 net17_6 1.75727e-05f
C8103 WL_1_2 net19_6 1.57092e-05f
C8104 WL_1_2 net20_6 2.12461e-05f
C8105 WL_1_2 net24_6 1.7668e-05f
C8106 WL_1_2 net27_6 1.33681e-05f
C8107 WL_1_2 net28_6 2.24315e-05f
C8108 WL_1_2 net3_8 3.00092e-05f
C8109 WL_1_2 net6_3 1.74462e-05f
C8110 WL_1_2 net76 0.00196358f
C8111 WL_1_2 net78 1.92798e-05f
C8112 WL_1_2 net79 0.00196561f
C8113 WL_1_2 net7_6 2.21143e-05f
C8114 WL_1_2 net80 1.54411e-05f
C8115 WL_1_2 net81_4 0.00195574f
C8116 WL_1_2 net83 2.51486e-05f
C8117 WL_1_2 net84_4 0.00195268f
C8118 WL_1_2 net85 1.53919e-05f
C8119 WL_1_2 net86_4 0.00196504f
C8120 WL_1_2 net87 2.21558e-05f
C8121 WL_1_2 net88_4 0.00196739f
C8122 WL_1_2 net90 1.43336e-05f
C8123 WL_1_2 net91_4 0.00194553f
C8124 WL_1_2 net93 2.68861e-05f
C8125 WL_1_2 net94_5 0.00195617f
C8126 WL_1_20 XB_1_0_2 0.000130005f
C8127 WL_1_20 XB_1_1_2 0.000116325f
C8128 WL_1_20 XB_1_2 0.000123938f
C8129 WL_1_20 XB_1_3 0.000117254f
C8130 WL_1_20 XB_1_4 0.000121293f
C8131 WL_1_20 XB_1_5 0.000117818f
C8132 WL_1_20 XB_1_6 0.000118266f
C8133 WL_1_20 XB_1_7 0.000111401f
C8134 WL_1_20 net11_6 1.16319e-05f
C8135 WL_1_20 net130_7 0.00215951f
C8136 WL_1_20 net132_7 0.00216297f
C8137 WL_1_20 net134_5 0.00216163f
C8138 WL_1_20 net135_5 0.00216426f
C8139 WL_1_20 net137_5 0.00215585f
C8140 WL_1_20 net139_5 0.00216868f
C8141 WL_1_20 net13_6 1.48566e-05f
C8142 WL_1_20 net141_5 0.00215694f
C8143 WL_1_20 net142_5 0.00215263f
C8144 WL_1_20 net14_6 1.68097e-05f
C8145 WL_1_20 net16_6 1.07975e-05f
C8146 WL_1_20 net17_6 1.33808e-05f
C8147 WL_1_20 net19_6 1.19619e-05f
C8148 WL_1_20 net20_6 1.6178e-05f
C8149 WL_1_20 net24_6 1.34534e-05f
C8150 WL_1_20 net27_6 1.01792e-05f
C8151 WL_1_20 net28_6 1.70806e-05f
C8152 WL_1_20 net3_8 2.28507e-05f
C8153 WL_1_20 net6_3 1.32845e-05f
C8154 WL_1_20 net76_2 0.00149518f
C8155 WL_1_20 net78 1.46807e-05f
C8156 WL_1_20 net79_2 0.00149673f
C8157 WL_1_20 net7_8 1.68391e-05f
C8158 WL_1_20 net80 1.17577e-05f
C8159 WL_1_20 net81_5 0.00148921f
C8160 WL_1_20 net83 1.91495e-05f
C8161 WL_1_20 net84_5 0.00148688f
C8162 WL_1_20 net85 1.17202e-05f
C8163 WL_1_20 net86_5 0.00149629f
C8164 WL_1_20 net87 1.68706e-05f
C8165 WL_1_20 net88_5 0.00149808f
C8166 WL_1_20 net90 1.09144e-05f
C8167 WL_1_20 net91_5 0.00148144f
C8168 WL_1_20 net93 2.04726e-05f
C8169 WL_1_20 net94_5 0.00148954f
C8170 WL_1_21 XB_1_0_2 0.000130005f
C8171 WL_1_21 XB_1_1_2 0.000116325f
C8172 WL_1_21 XB_1_2 0.000123938f
C8173 WL_1_21 XB_1_3 0.000117254f
C8174 WL_1_21 XB_1_4 0.000121293f
C8175 WL_1_21 XB_1_5 0.000117818f
C8176 WL_1_21 XB_1_6 0.000118266f
C8177 WL_1_21 XB_1_7 0.000111401f
C8178 WL_1_21 net11_11 1.16319e-05f
C8179 WL_1_21 net130_7 0.00215951f
C8180 WL_1_21 net132_7 0.00216297f
C8181 WL_1_21 net134_10 0.00216163f
C8182 WL_1_21 net135_5 0.00216426f
C8183 WL_1_21 net137_5 0.00215585f
C8184 WL_1_21 net139_5 0.00216868f
C8185 WL_1_21 net13_6 1.48566e-05f
C8186 WL_1_21 net141_5 0.00215694f
C8187 WL_1_21 net142_5 0.00215263f
C8188 WL_1_21 net14_6 1.68097e-05f
C8189 WL_1_21 net16_6 1.07975e-05f
C8190 WL_1_21 net17_6 1.33808e-05f
C8191 WL_1_21 net19_6 1.19619e-05f
C8192 WL_1_21 net20_6 1.6178e-05f
C8193 WL_1_21 net24_6 1.34534e-05f
C8194 WL_1_21 net27_6 1.01792e-05f
C8195 WL_1_21 net28_6 1.70806e-05f
C8196 WL_1_21 net3_8 2.28507e-05f
C8197 WL_1_21 net6_3 1.32845e-05f
C8198 WL_1_21 net76_2 0.00149518f
C8199 WL_1_21 net78 1.46807e-05f
C8200 WL_1_21 net79_2 0.00149673f
C8201 WL_1_21 net7_8 1.68391e-05f
C8202 WL_1_21 net80 1.17577e-05f
C8203 WL_1_21 net81_2 0.00148921f
C8204 WL_1_21 net83 1.91495e-05f
C8205 WL_1_21 net84_5 0.00148688f
C8206 WL_1_21 net85 1.17202e-05f
C8207 WL_1_21 net86_5 0.00149629f
C8208 WL_1_21 net87 1.68706e-05f
C8209 WL_1_21 net88_5 0.00149808f
C8210 WL_1_21 net90 1.09144e-05f
C8211 WL_1_21 net91_5 0.00148144f
C8212 WL_1_21 net93 2.04726e-05f
C8213 WL_1_21 net94_5 0.00148954f
C8214 WL_1_22 XB_1_0_2 0.000130005f
C8215 WL_1_22 XB_1_1_2 0.000116325f
C8216 WL_1_22 XB_1_2_2 0.000123938f
C8217 WL_1_22 XB_1_3 0.000117254f
C8218 WL_1_22 XB_1_4 0.000121293f
C8219 WL_1_22 XB_1_5 0.000117818f
C8220 WL_1_22 XB_1_6 0.000118266f
C8221 WL_1_22 XB_1_7 0.000111401f
C8222 WL_1_22 net11_8 1.16319e-05f
C8223 WL_1_22 net130_7 0.00215951f
C8224 WL_1_22 net132_7 0.00216297f
C8225 WL_1_22 net134_7 0.00216163f
C8226 WL_1_22 net135_5 0.00216426f
C8227 WL_1_22 net137_5 0.00215585f
C8228 WL_1_22 net139_5 0.00216868f
C8229 WL_1_22 net13_6 1.48566e-05f
C8230 WL_1_22 net141_5 0.00215694f
C8231 WL_1_22 net142_5 0.00215263f
C8232 WL_1_22 net14_6 1.68097e-05f
C8233 WL_1_22 net16_6 1.07975e-05f
C8234 WL_1_22 net17_6 1.33808e-05f
C8235 WL_1_22 net19_6 1.19619e-05f
C8236 WL_1_22 net20_6 1.6178e-05f
C8237 WL_1_22 net24_6 1.34534e-05f
C8238 WL_1_22 net27_6 1.01792e-05f
C8239 WL_1_22 net28_6 1.70806e-05f
C8240 WL_1_22 net3_8 2.28507e-05f
C8241 WL_1_22 net6_3 1.32845e-05f
C8242 WL_1_22 net76_2 0.00149518f
C8243 WL_1_22 net78 1.46807e-05f
C8244 WL_1_22 net79_2 0.00149673f
C8245 WL_1_22 net7_8 1.68391e-05f
C8246 WL_1_22 net80 1.17577e-05f
C8247 WL_1_22 net81_2 0.00148921f
C8248 WL_1_22 net83 1.91495e-05f
C8249 WL_1_22 net84_5 0.00148688f
C8250 WL_1_22 net85 1.17202e-05f
C8251 WL_1_22 net86_5 0.00149629f
C8252 WL_1_22 net87 1.68706e-05f
C8253 WL_1_22 net88_5 0.00149808f
C8254 WL_1_22 net90 1.09144e-05f
C8255 WL_1_22 net91_5 0.00148144f
C8256 WL_1_22 net93 2.04726e-05f
C8257 WL_1_22 net94_5 0.00148954f
C8258 WL_1_23 XB_1_0_2 0.000130005f
C8259 WL_1_23 XB_1_1_2 0.000116325f
C8260 WL_1_23 XB_1_2_2 0.000123938f
C8261 WL_1_23 XB_1_3 0.000117254f
C8262 WL_1_23 XB_1_4 0.000121293f
C8263 WL_1_23 XB_1_5 0.000117818f
C8264 WL_1_23 XB_1_6 0.000118266f
C8265 WL_1_23 XB_1_7 0.000111401f
C8266 WL_1_23 net11_8 1.16319e-05f
C8267 WL_1_23 net130_7 0.00215951f
C8268 WL_1_23 net132_7 0.00216297f
C8269 WL_1_23 net134_7 0.00216163f
C8270 WL_1_23 net135_10 0.00216426f
C8271 WL_1_23 net137_5 0.00215585f
C8272 WL_1_23 net139_5 0.00216868f
C8273 WL_1_23 net13_3 1.48566e-05f
C8274 WL_1_23 net141_5 0.00215694f
C8275 WL_1_23 net142_5 0.00215263f
C8276 WL_1_23 net14_11 1.68097e-05f
C8277 WL_1_23 net16_6 1.07975e-05f
C8278 WL_1_23 net17_6 1.33808e-05f
C8279 WL_1_23 net19_6 1.19619e-05f
C8280 WL_1_23 net20_6 1.6178e-05f
C8281 WL_1_23 net24_6 1.34534e-05f
C8282 WL_1_23 net27_6 1.01792e-05f
C8283 WL_1_23 net28_6 1.70806e-05f
C8284 WL_1_23 net3_8 2.28507e-05f
C8285 WL_1_23 net6_3 1.32845e-05f
C8286 WL_1_23 net76_2 0.00149518f
C8287 WL_1_23 net78 1.46807e-05f
C8288 WL_1_23 net79_2 0.00149673f
C8289 WL_1_23 net7_8 1.68391e-05f
C8290 WL_1_23 net80 1.17577e-05f
C8291 WL_1_23 net81_2 0.00148921f
C8292 WL_1_23 net83 1.91495e-05f
C8293 WL_1_23 net84_2 0.00148688f
C8294 WL_1_23 net85 1.17202e-05f
C8295 WL_1_23 net86_5 0.00149629f
C8296 WL_1_23 net87 1.68706e-05f
C8297 WL_1_23 net88_5 0.00149808f
C8298 WL_1_23 net90 1.09144e-05f
C8299 WL_1_23 net91_5 0.00148144f
C8300 WL_1_23 net93 2.04726e-05f
C8301 WL_1_23 net94_5 0.00148954f
C8302 WL_1_24 XB_1_0_2 0.000130005f
C8303 WL_1_24 XB_1_1_2 0.000116325f
C8304 WL_1_24 XB_1_2_2 0.000123938f
C8305 WL_1_24 XB_1_3_2 0.000117254f
C8306 WL_1_24 XB_1_4 0.000121293f
C8307 WL_1_24 XB_1_5 0.000117818f
C8308 WL_1_24 XB_1_6 0.000118266f
C8309 WL_1_24 XB_1_7 0.000111401f
C8310 WL_1_24 net11_8 1.16319e-05f
C8311 WL_1_24 net130_7 0.00215951f
C8312 WL_1_24 net132_7 0.00216297f
C8313 WL_1_24 net134_7 0.00216163f
C8314 WL_1_24 net135_7 0.00216426f
C8315 WL_1_24 net137_5 0.00215585f
C8316 WL_1_24 net139_5 0.00216868f
C8317 WL_1_24 net13_3 1.48566e-05f
C8318 WL_1_24 net141_5 0.00215694f
C8319 WL_1_24 net142_5 0.00215263f
C8320 WL_1_24 net14_8 1.68097e-05f
C8321 WL_1_24 net16_6 1.07975e-05f
C8322 WL_1_24 net17_6 1.33808e-05f
C8323 WL_1_24 net19_6 1.19619e-05f
C8324 WL_1_24 net20_6 1.6178e-05f
C8325 WL_1_24 net24_6 1.34534e-05f
C8326 WL_1_24 net27_6 1.01792e-05f
C8327 WL_1_24 net28_6 1.70806e-05f
C8328 WL_1_24 net3_8 2.28507e-05f
C8329 WL_1_24 net6_3 1.32845e-05f
C8330 WL_1_24 net76_2 0.00149518f
C8331 WL_1_24 net78 1.46807e-05f
C8332 WL_1_24 net79_2 0.00149673f
C8333 WL_1_24 net7_8 1.68391e-05f
C8334 WL_1_24 net80 1.17577e-05f
C8335 WL_1_24 net81_2 0.00148921f
C8336 WL_1_24 net83 1.91495e-05f
C8337 WL_1_24 net84_2 0.00148688f
C8338 WL_1_24 net85 1.17202e-05f
C8339 WL_1_24 net86_5 0.00149629f
C8340 WL_1_24 net87 1.68706e-05f
C8341 WL_1_24 net88_5 0.00149808f
C8342 WL_1_24 net90 1.09144e-05f
C8343 WL_1_24 net91_5 0.00148144f
C8344 WL_1_24 net93 2.04726e-05f
C8345 WL_1_24 net94_5 0.00148954f
C8346 WL_1_25 XB_1_0_2 0.000130005f
C8347 WL_1_25 XB_1_1_2 0.000116325f
C8348 WL_1_25 XB_1_2_2 0.000123938f
C8349 WL_1_25 XB_1_3_2 0.000117254f
C8350 WL_1_25 XB_1_4 0.000121293f
C8351 WL_1_25 XB_1_5 0.000117818f
C8352 WL_1_25 XB_1_6 0.000118266f
C8353 WL_1_25 XB_1_7 0.000111401f
C8354 WL_1_25 net11_8 1.16319e-05f
C8355 WL_1_25 net130_7 0.00215951f
C8356 WL_1_25 net132_7 0.00216297f
C8357 WL_1_25 net134_7 0.00216163f
C8358 WL_1_25 net135_7 0.00216426f
C8359 WL_1_25 net137_10 0.00215585f
C8360 WL_1_25 net139_5 0.00216868f
C8361 WL_1_25 net13_3 1.48566e-05f
C8362 WL_1_25 net141_5 0.00215694f
C8363 WL_1_25 net142_5 0.00215263f
C8364 WL_1_25 net14_8 1.68097e-05f
C8365 WL_1_25 net16_3 1.07975e-05f
C8366 WL_1_25 net17_11 1.33808e-05f
C8367 WL_1_25 net19_6 1.19619e-05f
C8368 WL_1_25 net20_6 1.6178e-05f
C8369 WL_1_25 net24_6 1.34534e-05f
C8370 WL_1_25 net27_6 1.01792e-05f
C8371 WL_1_25 net28_6 1.70806e-05f
C8372 WL_1_25 net3_8 2.28507e-05f
C8373 WL_1_25 net6_3 1.32845e-05f
C8374 WL_1_25 net76_2 0.00149518f
C8375 WL_1_25 net78 1.46807e-05f
C8376 WL_1_25 net79_2 0.00149673f
C8377 WL_1_25 net7_8 1.68391e-05f
C8378 WL_1_25 net80 1.17577e-05f
C8379 WL_1_25 net81_2 0.00148921f
C8380 WL_1_25 net83 1.91495e-05f
C8381 WL_1_25 net84_2 0.00148688f
C8382 WL_1_25 net85 1.17202e-05f
C8383 WL_1_25 net86_2 0.00149629f
C8384 WL_1_25 net87 1.68706e-05f
C8385 WL_1_25 net88_5 0.00149808f
C8386 WL_1_25 net90 1.09144e-05f
C8387 WL_1_25 net91_5 0.00148144f
C8388 WL_1_25 net93 2.04726e-05f
C8389 WL_1_25 net94_5 0.00148954f
C8390 WL_1_26 XB_1_0_2 0.000130005f
C8391 WL_1_26 XB_1_1_2 0.000116325f
C8392 WL_1_26 XB_1_2_2 0.000123938f
C8393 WL_1_26 XB_1_3_2 0.000117254f
C8394 WL_1_26 XB_1_4_2 0.000121293f
C8395 WL_1_26 XB_1_5 0.000117818f
C8396 WL_1_26 XB_1_6 0.000118266f
C8397 WL_1_26 XB_1_7 0.000111401f
C8398 WL_1_26 net11_8 1.16319e-05f
C8399 WL_1_26 net130_7 0.00215951f
C8400 WL_1_26 net132_7 0.00216297f
C8401 WL_1_26 net134_7 0.00216163f
C8402 WL_1_26 net135_7 0.00216426f
C8403 WL_1_26 net137_7 0.00215585f
C8404 WL_1_26 net139_5 0.00216868f
C8405 WL_1_26 net13_3 1.48566e-05f
C8406 WL_1_26 net141_5 0.00215694f
C8407 WL_1_26 net142_5 0.00215263f
C8408 WL_1_26 net14_8 1.68097e-05f
C8409 WL_1_26 net16_3 1.07975e-05f
C8410 WL_1_26 net17_8 1.33808e-05f
C8411 WL_1_26 net19_6 1.19619e-05f
C8412 WL_1_26 net20_6 1.6178e-05f
C8413 WL_1_26 net24_6 1.34534e-05f
C8414 WL_1_26 net27_6 1.01792e-05f
C8415 WL_1_26 net28_6 1.70806e-05f
C8416 WL_1_26 net3_8 2.28507e-05f
C8417 WL_1_26 net6_3 1.32845e-05f
C8418 WL_1_26 net76_2 0.00149518f
C8419 WL_1_26 net78 1.46807e-05f
C8420 WL_1_26 net79_2 0.00149673f
C8421 WL_1_26 net7_8 1.68391e-05f
C8422 WL_1_26 net80 1.17577e-05f
C8423 WL_1_26 net81_2 0.00148921f
C8424 WL_1_26 net83 1.91495e-05f
C8425 WL_1_26 net84_2 0.00148688f
C8426 WL_1_26 net85 1.17202e-05f
C8427 WL_1_26 net86_2 0.00149629f
C8428 WL_1_26 net87 1.68706e-05f
C8429 WL_1_26 net88_5 0.00149808f
C8430 WL_1_26 net90 1.09144e-05f
C8431 WL_1_26 net91_5 0.00148144f
C8432 WL_1_26 net93 2.04726e-05f
C8433 WL_1_26 net94_5 0.00148954f
C8434 WL_1_27 XB_1_0_2 0.000130005f
C8435 WL_1_27 XB_1_1_2 0.000116325f
C8436 WL_1_27 XB_1_2_2 0.000123938f
C8437 WL_1_27 XB_1_3_2 0.000117254f
C8438 WL_1_27 XB_1_4_2 0.000121293f
C8439 WL_1_27 XB_1_5 0.000117818f
C8440 WL_1_27 XB_1_6 0.000118266f
C8441 WL_1_27 XB_1_7 0.000111401f
C8442 WL_1_27 net11_8 1.16319e-05f
C8443 WL_1_27 net130_7 0.00215951f
C8444 WL_1_27 net132_7 0.00216297f
C8445 WL_1_27 net134_7 0.00216163f
C8446 WL_1_27 net135_7 0.00216426f
C8447 WL_1_27 net137_7 0.00215585f
C8448 WL_1_27 net139_10 0.00216868f
C8449 WL_1_27 net13_3 1.48566e-05f
C8450 WL_1_27 net141_5 0.00215694f
C8451 WL_1_27 net142_5 0.00215263f
C8452 WL_1_27 net14_8 1.68097e-05f
C8453 WL_1_27 net16_3 1.07975e-05f
C8454 WL_1_27 net17_8 1.33808e-05f
C8455 WL_1_27 net19_3 1.19619e-05f
C8456 WL_1_27 net20_11 1.6178e-05f
C8457 WL_1_27 net24_6 1.34534e-05f
C8458 WL_1_27 net27_6 1.01792e-05f
C8459 WL_1_27 net28_6 1.70806e-05f
C8460 WL_1_27 net3_8 2.28507e-05f
C8461 WL_1_27 net6_3 1.32845e-05f
C8462 WL_1_27 net76_2 0.00149518f
C8463 WL_1_27 net78 1.46807e-05f
C8464 WL_1_27 net79_2 0.00149673f
C8465 WL_1_27 net7_8 1.68391e-05f
C8466 WL_1_27 net80 1.17577e-05f
C8467 WL_1_27 net81_2 0.00148921f
C8468 WL_1_27 net83 1.91495e-05f
C8469 WL_1_27 net84_2 0.00148688f
C8470 WL_1_27 net85 1.17202e-05f
C8471 WL_1_27 net86_2 0.00149629f
C8472 WL_1_27 net87 1.68706e-05f
C8473 WL_1_27 net88_2 0.00149808f
C8474 WL_1_27 net90 1.09144e-05f
C8475 WL_1_27 net91_5 0.00148144f
C8476 WL_1_27 net93 2.04726e-05f
C8477 WL_1_27 net94_5 0.00148954f
C8478 WL_1_28 XB_1_0_2 0.000130005f
C8479 WL_1_28 XB_1_1_2 0.000116325f
C8480 WL_1_28 XB_1_2_2 0.000123938f
C8481 WL_1_28 XB_1_3_2 0.000117254f
C8482 WL_1_28 XB_1_4_2 0.000121293f
C8483 WL_1_28 XB_1_5_2 0.000117818f
C8484 WL_1_28 XB_1_6 0.000118266f
C8485 WL_1_28 XB_1_7 0.000111401f
C8486 WL_1_28 net11_8 1.16319e-05f
C8487 WL_1_28 net130_7 0.00215951f
C8488 WL_1_28 net132_7 0.00216297f
C8489 WL_1_28 net134_7 0.00216163f
C8490 WL_1_28 net135_7 0.00216426f
C8491 WL_1_28 net137_7 0.00215585f
C8492 WL_1_28 net139_7 0.00216868f
C8493 WL_1_28 net13_3 1.48566e-05f
C8494 WL_1_28 net141_5 0.00215694f
C8495 WL_1_28 net142_5 0.00215263f
C8496 WL_1_28 net14_8 1.68097e-05f
C8497 WL_1_28 net16_3 1.07975e-05f
C8498 WL_1_28 net17_8 1.33808e-05f
C8499 WL_1_28 net19_3 1.19619e-05f
C8500 WL_1_28 net20_8 1.6178e-05f
C8501 WL_1_28 net24_6 1.34534e-05f
C8502 WL_1_28 net27_6 1.01792e-05f
C8503 WL_1_28 net28_6 1.70806e-05f
C8504 WL_1_28 net3_8 2.28507e-05f
C8505 WL_1_28 net6_3 1.32845e-05f
C8506 WL_1_28 net76_2 0.00149518f
C8507 WL_1_28 net78 1.46807e-05f
C8508 WL_1_28 net79_2 0.00149673f
C8509 WL_1_28 net7_8 1.68391e-05f
C8510 WL_1_28 net80 1.17577e-05f
C8511 WL_1_28 net81_2 0.00148921f
C8512 WL_1_28 net83 1.91495e-05f
C8513 WL_1_28 net84_2 0.00148688f
C8514 WL_1_28 net85 1.17202e-05f
C8515 WL_1_28 net86_2 0.00149629f
C8516 WL_1_28 net87 1.68706e-05f
C8517 WL_1_28 net88_2 0.00149808f
C8518 WL_1_28 net90 1.09144e-05f
C8519 WL_1_28 net91_5 0.00148144f
C8520 WL_1_28 net93 2.04726e-05f
C8521 WL_1_28 net94_5 0.00148954f
C8522 WL_1_29 XB_1_0_2 0.000130005f
C8523 WL_1_29 XB_1_1_2 0.000116325f
C8524 WL_1_29 XB_1_2_2 0.000123938f
C8525 WL_1_29 XB_1_3_2 0.000117254f
C8526 WL_1_29 XB_1_4_2 0.000121293f
C8527 WL_1_29 XB_1_5_2 0.000117818f
C8528 WL_1_29 XB_1_6 0.000118266f
C8529 WL_1_29 XB_1_7 0.000111401f
C8530 WL_1_29 net11_8 1.16319e-05f
C8531 WL_1_29 net130_7 0.00215951f
C8532 WL_1_29 net132_7 0.00216297f
C8533 WL_1_29 net134_7 0.00216163f
C8534 WL_1_29 net135_7 0.00216426f
C8535 WL_1_29 net137_7 0.00215585f
C8536 WL_1_29 net139_7 0.00216868f
C8537 WL_1_29 net13_3 1.48566e-05f
C8538 WL_1_29 net141_10 0.00215694f
C8539 WL_1_29 net142_5 0.00215263f
C8540 WL_1_29 net14_8 1.68097e-05f
C8541 WL_1_29 net16_3 1.07975e-05f
C8542 WL_1_29 net17_8 1.33808e-05f
C8543 WL_1_29 net19_3 1.19619e-05f
C8544 WL_1_29 net20_8 1.6178e-05f
C8545 WL_1_29 net24_11 1.34534e-05f
C8546 WL_1_29 net27_6 1.01792e-05f
C8547 WL_1_29 net28_6 1.70806e-05f
C8548 WL_1_29 net3_8 2.28507e-05f
C8549 WL_1_29 net6_3 1.32845e-05f
C8550 WL_1_29 net76_2 0.00149518f
C8551 WL_1_29 net78 1.46807e-05f
C8552 WL_1_29 net79_2 0.00149673f
C8553 WL_1_29 net7_8 1.68391e-05f
C8554 WL_1_29 net80 1.17577e-05f
C8555 WL_1_29 net81_2 0.00148921f
C8556 WL_1_29 net83 1.91495e-05f
C8557 WL_1_29 net84_2 0.00148688f
C8558 WL_1_29 net85 1.17202e-05f
C8559 WL_1_29 net86_2 0.00149629f
C8560 WL_1_29 net87 1.68706e-05f
C8561 WL_1_29 net88_2 0.00149808f
C8562 WL_1_29 net90 1.09144e-05f
C8563 WL_1_29 net91_2 0.00148144f
C8564 WL_1_29 net93 2.04726e-05f
C8565 WL_1_29 net94_5 0.00148954f
C8566 WL_1_3 XB_0_6 1.2173e-05f
C8567 WL_1_3 XB_1_0_3 0.000170732f
C8568 WL_1_3 XB_1_1_3 0.000152766f
C8569 WL_1_3 XB_1_2 0.000162765f
C8570 WL_1_3 XB_1_3 0.000153987f
C8571 WL_1_3 XB_1_4 0.000159291f
C8572 WL_1_3 XB_1_5 0.000154728f
C8573 WL_1_3 XB_1_6 0.000155316f
C8574 WL_1_3 XB_1_7 0.0001463f
C8575 WL_1_3 net11_6 1.52759e-05f
C8576 WL_1_3 net130_8 0.00283603f
C8577 WL_1_3 net132_8 0.00284057f
C8578 WL_1_3 net134 0.00283881f
C8579 WL_1_3 net135 0.00284227f
C8580 WL_1_3 net137 0.00283122f
C8581 WL_1_3 net139 0.00284807f
C8582 WL_1_3 net13_6 1.95108e-05f
C8583 WL_1_3 net141 0.00283265f
C8584 WL_1_3 net142 0.00282699f
C8585 WL_1_3 net14_6 2.20757e-05f
C8586 WL_1_3 net16_6 1.41801e-05f
C8587 WL_1_3 net17_6 1.75727e-05f
C8588 WL_1_3 net19_6 1.57092e-05f
C8589 WL_1_3 net20_6 2.12461e-05f
C8590 WL_1_3 net24_6 1.7668e-05f
C8591 WL_1_3 net27_6 1.33681e-05f
C8592 WL_1_3 net28_6 2.24315e-05f
C8593 WL_1_3 net3_8 3.00092e-05f
C8594 WL_1_3 net6_3 1.74462e-05f
C8595 WL_1_3 net76 0.00196358f
C8596 WL_1_3 net78 1.92798e-05f
C8597 WL_1_3 net79 0.00196561f
C8598 WL_1_3 net7_8 2.21143e-05f
C8599 WL_1_3 net80 1.54411e-05f
C8600 WL_1_3 net81 0.00195574f
C8601 WL_1_3 net83 2.51486e-05f
C8602 WL_1_3 net84_4 0.00195268f
C8603 WL_1_3 net85 1.53919e-05f
C8604 WL_1_3 net86_4 0.00196504f
C8605 WL_1_3 net87 2.21558e-05f
C8606 WL_1_3 net88_4 0.00196739f
C8607 WL_1_3 net90 1.43336e-05f
C8608 WL_1_3 net91_4 0.00194553f
C8609 WL_1_3 net93 2.68861e-05f
C8610 WL_1_3 net94_4 0.00195617f
C8611 WL_1_30 XB_1_0_2 0.000130005f
C8612 WL_1_30 XB_1_1_2 0.000116325f
C8613 WL_1_30 XB_1_2_2 0.000123938f
C8614 WL_1_30 XB_1_3_2 0.000117254f
C8615 WL_1_30 XB_1_4_2 0.000121293f
C8616 WL_1_30 XB_1_5_2 0.000117818f
C8617 WL_1_30 XB_1_6_2 0.000118266f
C8618 WL_1_30 XB_1_7 0.000111401f
C8619 WL_1_30 net11_8 1.16319e-05f
C8620 WL_1_30 net130_7 0.00215951f
C8621 WL_1_30 net132_7 0.00216297f
C8622 WL_1_30 net134_7 0.00216163f
C8623 WL_1_30 net135_7 0.00216426f
C8624 WL_1_30 net137_7 0.00215585f
C8625 WL_1_30 net139_7 0.00216868f
C8626 WL_1_30 net13_3 1.48566e-05f
C8627 WL_1_30 net141_7 0.00215694f
C8628 WL_1_30 net142_5 0.00215263f
C8629 WL_1_30 net14_8 1.68097e-05f
C8630 WL_1_30 net16_3 1.07975e-05f
C8631 WL_1_30 net17_8 1.33808e-05f
C8632 WL_1_30 net19_3 1.19619e-05f
C8633 WL_1_30 net20_8 1.6178e-05f
C8634 WL_1_30 net24_8 1.34534e-05f
C8635 WL_1_30 net27_6 1.01792e-05f
C8636 WL_1_30 net28_6 1.70806e-05f
C8637 WL_1_30 net3_8 2.28507e-05f
C8638 WL_1_30 net6_3 1.32845e-05f
C8639 WL_1_30 net76_2 0.00149518f
C8640 WL_1_30 net78 1.46807e-05f
C8641 WL_1_30 net79_2 0.00149673f
C8642 WL_1_30 net7_8 1.68391e-05f
C8643 WL_1_30 net80 1.17577e-05f
C8644 WL_1_30 net81_2 0.00148921f
C8645 WL_1_30 net83 1.91495e-05f
C8646 WL_1_30 net84_2 0.00148688f
C8647 WL_1_30 net85 1.17202e-05f
C8648 WL_1_30 net86_2 0.00149629f
C8649 WL_1_30 net87 1.68706e-05f
C8650 WL_1_30 net88_2 0.00149808f
C8651 WL_1_30 net90 1.09144e-05f
C8652 WL_1_30 net91_2 0.00148144f
C8653 WL_1_30 net93 2.04726e-05f
C8654 WL_1_30 net94_5 0.00148954f
C8655 WL_1_31 XB_1_0_2 0.000130005f
C8656 WL_1_31 XB_1_1_2 0.000116325f
C8657 WL_1_31 XB_1_2_2 0.000123938f
C8658 WL_1_31 XB_1_3_2 0.000117254f
C8659 WL_1_31 XB_1_4_2 0.000121293f
C8660 WL_1_31 XB_1_5_2 0.000117818f
C8661 WL_1_31 XB_1_6_2 0.000118266f
C8662 WL_1_31 XB_1_7 0.000111401f
C8663 WL_1_31 net11_8 1.16319e-05f
C8664 WL_1_31 net130_7 0.00215951f
C8665 WL_1_31 net132_7 0.00216297f
C8666 WL_1_31 net134_7 0.00216163f
C8667 WL_1_31 net135_7 0.00216426f
C8668 WL_1_31 net137_7 0.00215585f
C8669 WL_1_31 net139_7 0.00216868f
C8670 WL_1_31 net13_3 1.48566e-05f
C8671 WL_1_31 net141_7 0.00215694f
C8672 WL_1_31 net142_10 0.00215263f
C8673 WL_1_31 net14_8 1.68097e-05f
C8674 WL_1_31 net16_3 1.07975e-05f
C8675 WL_1_31 net17_8 1.33808e-05f
C8676 WL_1_31 net19_3 1.19619e-05f
C8677 WL_1_31 net20_8 1.6178e-05f
C8678 WL_1_31 net24_8 1.34534e-05f
C8679 WL_1_31 net27_3 1.01792e-05f
C8680 WL_1_31 net28_11 1.70806e-05f
C8681 WL_1_31 net3_8 2.28507e-05f
C8682 WL_1_31 net6_3 1.32845e-05f
C8683 WL_1_31 net76_2 0.00149518f
C8684 WL_1_31 net78 1.46807e-05f
C8685 WL_1_31 net79_2 0.00149673f
C8686 WL_1_31 net7_8 1.68391e-05f
C8687 WL_1_31 net80 1.17577e-05f
C8688 WL_1_31 net81_2 0.00148921f
C8689 WL_1_31 net83 1.91495e-05f
C8690 WL_1_31 net84_2 0.00148688f
C8691 WL_1_31 net85 1.17202e-05f
C8692 WL_1_31 net86_2 0.00149629f
C8693 WL_1_31 net87 1.68706e-05f
C8694 WL_1_31 net88_2 0.00149808f
C8695 WL_1_31 net90 1.09144e-05f
C8696 WL_1_31 net91_2 0.00148144f
C8697 WL_1_31 net93 2.04726e-05f
C8698 WL_1_31 net94_2 0.00148954f
C8699 WL_1_4 XB_0_6 1.2173e-05f
C8700 WL_1_4 XB_1_0_3 0.000170732f
C8701 WL_1_4 XB_1_1_3 0.000152766f
C8702 WL_1_4 XB_1_2_3 0.000162765f
C8703 WL_1_4 XB_1_3 0.000153987f
C8704 WL_1_4 XB_1_4 0.000159291f
C8705 WL_1_4 XB_1_5 0.000154728f
C8706 WL_1_4 XB_1_6 0.000155316f
C8707 WL_1_4 XB_1_7 0.0001463f
C8708 WL_1_4 net11_8 1.52759e-05f
C8709 WL_1_4 net130_8 0.00283603f
C8710 WL_1_4 net132_8 0.00284057f
C8711 WL_1_4 net134_8 0.00283881f
C8712 WL_1_4 net135 0.00284227f
C8713 WL_1_4 net137 0.00283122f
C8714 WL_1_4 net139 0.00284807f
C8715 WL_1_4 net13_3 1.95108e-05f
C8716 WL_1_4 net141 0.00283265f
C8717 WL_1_4 net142 0.00282699f
C8718 WL_1_4 net14_6 2.20757e-05f
C8719 WL_1_4 net16_6 1.41801e-05f
C8720 WL_1_4 net17_6 1.75727e-05f
C8721 WL_1_4 net19_6 1.57092e-05f
C8722 WL_1_4 net20_6 2.12461e-05f
C8723 WL_1_4 net24_6 1.7668e-05f
C8724 WL_1_4 net27_6 1.33681e-05f
C8725 WL_1_4 net28_6 2.24315e-05f
C8726 WL_1_4 net3_8 3.00092e-05f
C8727 WL_1_4 net6_3 1.74462e-05f
C8728 WL_1_4 net76 0.00196358f
C8729 WL_1_4 net78 1.92798e-05f
C8730 WL_1_4 net79 0.00196561f
C8731 WL_1_4 net7_8 2.21143e-05f
C8732 WL_1_4 net80 1.54411e-05f
C8733 WL_1_4 net81 0.00195574f
C8734 WL_1_4 net83 2.51486e-05f
C8735 WL_1_4 net84 0.00195268f
C8736 WL_1_4 net85 1.53919e-05f
C8737 WL_1_4 net86_4 0.00196504f
C8738 WL_1_4 net87 2.21558e-05f
C8739 WL_1_4 net88_4 0.00196739f
C8740 WL_1_4 net90 1.43336e-05f
C8741 WL_1_4 net91_4 0.00194553f
C8742 WL_1_4 net93 2.68861e-05f
C8743 WL_1_4 net94_4 0.00195617f
C8744 WL_1_5 XB_0_6_3 1.2173e-05f
C8745 WL_1_5 XB_1_0_3 0.000170732f
C8746 WL_1_5 XB_1_1_3 0.000152766f
C8747 WL_1_5 XB_1_2_3 0.000162765f
C8748 WL_1_5 XB_1_3_3 0.000153987f
C8749 WL_1_5 XB_1_4 0.000159291f
C8750 WL_1_5 XB_1_5 0.000154728f
C8751 WL_1_5 XB_1_6 0.000155316f
C8752 WL_1_5 XB_1_7 0.0001463f
C8753 WL_1_5 net11_8 1.52759e-05f
C8754 WL_1_5 net130_8 0.00283603f
C8755 WL_1_5 net132_8 0.00284057f
C8756 WL_1_5 net134_8 0.00283881f
C8757 WL_1_5 net135_8 0.00284227f
C8758 WL_1_5 net137 0.00283122f
C8759 WL_1_5 net139 0.00284807f
C8760 WL_1_5 net13_3 1.95108e-05f
C8761 WL_1_5 net141 0.00283265f
C8762 WL_1_5 net142 0.00282699f
C8763 WL_1_5 net14_8 2.20757e-05f
C8764 WL_1_5 net16_3 1.41801e-05f
C8765 WL_1_5 net17_6 1.75727e-05f
C8766 WL_1_5 net19_6 1.57092e-05f
C8767 WL_1_5 net20_6 2.12461e-05f
C8768 WL_1_5 net24_6 1.7668e-05f
C8769 WL_1_5 net27_6 1.33681e-05f
C8770 WL_1_5 net28_6 2.24315e-05f
C8771 WL_1_5 net3_8 3.00092e-05f
C8772 WL_1_5 net6_3 1.74462e-05f
C8773 WL_1_5 net76 0.00196358f
C8774 WL_1_5 net78 1.92798e-05f
C8775 WL_1_5 net79 0.00196561f
C8776 WL_1_5 net7_8 2.21143e-05f
C8777 WL_1_5 net80 1.54411e-05f
C8778 WL_1_5 net81 0.00195574f
C8779 WL_1_5 net83 2.51486e-05f
C8780 WL_1_5 net84 0.00195268f
C8781 WL_1_5 net85 1.53919e-05f
C8782 WL_1_5 net86 0.00196504f
C8783 WL_1_5 net87 2.21558e-05f
C8784 WL_1_5 net88_4 0.00196739f
C8785 WL_1_5 net90 1.43336e-05f
C8786 WL_1_5 net91_4 0.00194553f
C8787 WL_1_5 net93 2.68861e-05f
C8788 WL_1_5 net94_4 0.00195617f
C8789 WL_1_6 XB_0_6_3 1.2173e-05f
C8790 WL_1_6 XB_1_0_3 0.000170732f
C8791 WL_1_6 XB_1_1_3 0.000152766f
C8792 WL_1_6 XB_1_2_3 0.000162765f
C8793 WL_1_6 XB_1_3_3 0.000153987f
C8794 WL_1_6 XB_1_4_3 0.000159291f
C8795 WL_1_6 XB_1_5 0.000154728f
C8796 WL_1_6 XB_1_6 0.000155316f
C8797 WL_1_6 XB_1_7 0.0001463f
C8798 WL_1_6 net11_8 1.52759e-05f
C8799 WL_1_6 net130_8 0.00283603f
C8800 WL_1_6 net132_8 0.00284057f
C8801 WL_1_6 net134_8 0.00283881f
C8802 WL_1_6 net135_8 0.00284227f
C8803 WL_1_6 net137_8 0.00283122f
C8804 WL_1_6 net139 0.00284807f
C8805 WL_1_6 net13_3 1.95108e-05f
C8806 WL_1_6 net141 0.00283265f
C8807 WL_1_6 net142 0.00282699f
C8808 WL_1_6 net14_8 2.20757e-05f
C8809 WL_1_6 net16_3 1.41801e-05f
C8810 WL_1_6 net17_8 1.75727e-05f
C8811 WL_1_6 net19_3 1.57092e-05f
C8812 WL_1_6 net20_6 2.12461e-05f
C8813 WL_1_6 net24_6 1.7668e-05f
C8814 WL_1_6 net27_6 1.33681e-05f
C8815 WL_1_6 net28_6 2.24315e-05f
C8816 WL_1_6 net3_8 3.00092e-05f
C8817 WL_1_6 net6_3 1.74462e-05f
C8818 WL_1_6 net76 0.00196358f
C8819 WL_1_6 net78 1.92798e-05f
C8820 WL_1_6 net79 0.00196561f
C8821 WL_1_6 net7_8 2.21143e-05f
C8822 WL_1_6 net80 1.54411e-05f
C8823 WL_1_6 net81 0.00195574f
C8824 WL_1_6 net83 2.51486e-05f
C8825 WL_1_6 net84 0.00195268f
C8826 WL_1_6 net85 1.53919e-05f
C8827 WL_1_6 net86 0.00196504f
C8828 WL_1_6 net87 2.21558e-05f
C8829 WL_1_6 net88 0.00196739f
C8830 WL_1_6 net90 1.43336e-05f
C8831 WL_1_6 net91_4 0.00194553f
C8832 WL_1_6 net93 2.68861e-05f
C8833 WL_1_6 net94_4 0.00195617f
C8834 WL_1_7 XB_0_6_3 1.2173e-05f
C8835 WL_1_7 XB_1_0_3 0.000170732f
C8836 WL_1_7 XB_1_1_3 0.000152766f
C8837 WL_1_7 XB_1_2_3 0.000162765f
C8838 WL_1_7 XB_1_3_3 0.000153987f
C8839 WL_1_7 XB_1_4_3 0.000159291f
C8840 WL_1_7 XB_1_5_3 0.000154728f
C8841 WL_1_7 XB_1_6 0.000155316f
C8842 WL_1_7 XB_1_7 0.0001463f
C8843 WL_1_7 net11_8 1.52759e-05f
C8844 WL_1_7 net130_8 0.00283603f
C8845 WL_1_7 net132_8 0.00284057f
C8846 WL_1_7 net134_8 0.00283881f
C8847 WL_1_7 net135_8 0.00284227f
C8848 WL_1_7 net137_8 0.00283122f
C8849 WL_1_7 net139_8 0.00284807f
C8850 WL_1_7 net13_3 1.95108e-05f
C8851 WL_1_7 net141 0.00283265f
C8852 WL_1_7 net142 0.00282699f
C8853 WL_1_7 net14_8 2.20757e-05f
C8854 WL_1_7 net16_3 1.41801e-05f
C8855 WL_1_7 net17_8 1.75727e-05f
C8856 WL_1_7 net19_3 1.57092e-05f
C8857 WL_1_7 net20_8 2.12461e-05f
C8858 WL_1_7 net24_6 1.7668e-05f
C8859 WL_1_7 net27_6 1.33681e-05f
C8860 WL_1_7 net28_6 2.24315e-05f
C8861 WL_1_7 net3_8 3.00092e-05f
C8862 WL_1_7 net6_3 1.74462e-05f
C8863 WL_1_7 net76 0.00196358f
C8864 WL_1_7 net78 1.92798e-05f
C8865 WL_1_7 net79 0.00196561f
C8866 WL_1_7 net7_8 2.21143e-05f
C8867 WL_1_7 net80 1.54411e-05f
C8868 WL_1_7 net81 0.00195574f
C8869 WL_1_7 net83 2.51486e-05f
C8870 WL_1_7 net84 0.00195268f
C8871 WL_1_7 net85 1.53919e-05f
C8872 WL_1_7 net86 0.00196504f
C8873 WL_1_7 net87 2.21558e-05f
C8874 WL_1_7 net88 0.00196739f
C8875 WL_1_7 net90 1.43336e-05f
C8876 WL_1_7 net91 0.00194553f
C8877 WL_1_7 net93 2.68861e-05f
C8878 WL_1_7 net94_4 0.00195617f
C8879 WL_1_8 XB_0_6_3 1.2173e-05f
C8880 WL_1_8 XB_1_0_3 0.000170732f
C8881 WL_1_8 XB_1_1_3 0.000152766f
C8882 WL_1_8 XB_1_2_3 0.000162765f
C8883 WL_1_8 XB_1_3_3 0.000153987f
C8884 WL_1_8 XB_1_4_3 0.000159291f
C8885 WL_1_8 XB_1_5_3 0.000154728f
C8886 WL_1_8 XB_1_6_3 0.000155316f
C8887 WL_1_8 XB_1_7 0.0001463f
C8888 WL_1_8 net11_8 1.52759e-05f
C8889 WL_1_8 net130_8 0.00283603f
C8890 WL_1_8 net132_8 0.00284057f
C8891 WL_1_8 net134_8 0.00283881f
C8892 WL_1_8 net135_8 0.00284227f
C8893 WL_1_8 net137_8 0.00283122f
C8894 WL_1_8 net139_8 0.00284807f
C8895 WL_1_8 net13_3 1.95108e-05f
C8896 WL_1_8 net141_8 0.00283265f
C8897 WL_1_8 net142 0.00282699f
C8898 WL_1_8 net14_8 2.20757e-05f
C8899 WL_1_8 net16_3 1.41801e-05f
C8900 WL_1_8 net17_8 1.75727e-05f
C8901 WL_1_8 net19_3 1.57092e-05f
C8902 WL_1_8 net20_8 2.12461e-05f
C8903 WL_1_8 net24_8 1.7668e-05f
C8904 WL_1_8 net27_3 1.33681e-05f
C8905 WL_1_8 net28_6 2.24315e-05f
C8906 WL_1_8 net3_8 3.00092e-05f
C8907 WL_1_8 net6_3 1.74462e-05f
C8908 WL_1_8 net76 0.00196358f
C8909 WL_1_8 net78 1.92798e-05f
C8910 WL_1_8 net79 0.00196561f
C8911 WL_1_8 net7_8 2.21143e-05f
C8912 WL_1_8 net80 1.54411e-05f
C8913 WL_1_8 net81 0.00195574f
C8914 WL_1_8 net83 2.51486e-05f
C8915 WL_1_8 net84 0.00195268f
C8916 WL_1_8 net85 1.53919e-05f
C8917 WL_1_8 net86 0.00196504f
C8918 WL_1_8 net87 2.21558e-05f
C8919 WL_1_8 net88 0.00196739f
C8920 WL_1_8 net90 1.43336e-05f
C8921 WL_1_8 net91 0.00194553f
C8922 WL_1_8 net93 2.68861e-05f
C8923 WL_1_8 net94 0.00195617f
C8924 WL_1_9 XB_0_6 1.28304e-05f
C8925 WL_1_9 XB_1_0 0.000179952f
C8926 WL_1_9 XB_1_1 0.000161016f
C8927 WL_1_9 XB_1_2 0.000171554f
C8928 WL_1_9 XB_1_3 0.000162302f
C8929 WL_1_9 XB_1_4 0.000167893f
C8930 WL_1_9 XB_1_5 0.000163084f
C8931 WL_1_9 XB_1_6 0.000163703f
C8932 WL_1_9 XB_1_7 0.000154201f
C8933 WL_1_9 net11_6 1.61008e-05f
C8934 WL_1_9 net130 0.00298918f
C8935 WL_1_9 net132 0.00299397f
C8936 WL_1_9 net134 0.00299211f
C8937 WL_1_9 net135 0.00299576f
C8938 WL_1_9 net137 0.00298411f
C8939 WL_1_9 net139 0.00300187f
C8940 WL_1_9 net13_6 2.05644e-05f
C8941 WL_1_9 net141 0.00298562f
C8942 WL_1_9 net142 0.00297966f
C8943 WL_1_9 net14_6 2.32679e-05f
C8944 WL_1_9 net16_6 1.49458e-05f
C8945 WL_1_9 net17_6 1.85217e-05f
C8946 WL_1_9 net19_6 1.65575e-05f
C8947 WL_1_9 net20_6 2.23934e-05f
C8948 WL_1_9 net24_6 1.86221e-05f
C8949 WL_1_9 net27_6 1.409e-05f
C8950 WL_1_9 net28_6 2.36429e-05f
C8951 WL_1_9 net2_3 1.01732e-05f
C8952 WL_1_9 net3_6 3.16298e-05f
C8953 WL_1_9 net6_6 1.83883e-05f
C8954 WL_1_9 net73 1.00409e-05f
C8955 WL_1_9 net76 0.00206962f
C8956 WL_1_9 net78 2.0321e-05f
C8957 WL_1_9 net79_4 0.00207176f
C8958 WL_1_9 net7_6 2.33085e-05f
C8959 WL_1_9 net80 1.62749e-05f
C8960 WL_1_9 net81_4 0.00206136f
C8961 WL_1_9 net83 2.65066e-05f
C8962 WL_1_9 net84_4 0.00205813f
C8963 WL_1_9 net85 1.62231e-05f
C8964 WL_1_9 net86_4 0.00207115f
C8965 WL_1_9 net87 2.33522e-05f
C8966 WL_1_9 net88_4 0.00207363f
C8967 WL_1_9 net90 1.51077e-05f
C8968 WL_1_9 net91_5 0.00205059f
C8969 WL_1_9 net93 2.8338e-05f
C8970 WL_1_9 net94_5 0.00206181f
C8971 WL_1_9 net96 1.01679e-05f
C8972 XB_0_0 XB_1_0_3 0.000103768f
C8973 XB_0_0 net2_7 1.39303e-05f
C8974 XB_0_0 net3 0.0021635f
C8975 XB_0_0 net3_2 0.00187696f
C8976 XB_0_0 net3_3 0.00203746f
C8977 XB_0_0 net3_4 0.00205242f
C8978 XB_0_0 net3_5 0.000819698f
C8979 XB_0_0 net3_9 0.00197081f
C8980 XB_0_0 net67 0.00330935f
C8981 XB_0_0 net78 1.71726e-05f
C8982 XB_0_0_1 XB_0_1 1.56043e-05f
C8983 XB_0_0_1 XB_1_0_3 0.00043379f
C8984 XB_0_0_1 XB_1_4_3 1.01942e-05f
C8985 XB_0_0_1 net13_7 1.98152e-05f
C8986 XB_0_0_1 net6 1.33778e-05f
C8987 XB_0_0_1 net67 0.0138344f
C8988 XB_0_0_1 net68 2.1195e-05f
C8989 XB_0_0_1 net6_7 4.51067e-05f
C8990 XB_0_0_1 net7 0.000507361f
C8991 XB_0_0_1 net78 7.17881e-05f
C8992 XB_0_0_1 net7_2 0.000440166f
C8993 XB_0_0_1 net7_3 0.000477804f
C8994 XB_0_0_1 net7_4 0.000481312f
C8995 XB_0_0_2 XB_1_0_3 6.13112e-05f
C8996 XB_0_0_2 net13_4 1.30323e-05f
C8997 XB_0_0_2 net3_7 0.000409849f
C8998 XB_0_0_2 net67 0.00195533f
C8999 XB_0_0_2 net6_2 1.74258e-05f
C9000 XB_0_0_2 net6_4 2.96663e-05f
C9001 XB_0_0_2 net78 1.01464e-05f
C9002 XB_0_0_2 net7_5 0.000192227f
C9003 XB_0_0_2 net7_7 9.61136e-05f
C9004 XB_0_0_2 net7_9 0.000462175f
C9005 XB_0_0_3 XB_1_0_3 0.000122622f
C9006 XB_0_0_3 net130 4.94062e-05f
C9007 XB_0_0_3 net130_10 4.5006e-05f
C9008 XB_0_0_3 net130_2 4.28629e-05f
C9009 XB_0_0_3 net130_3 4.65279e-05f
C9010 XB_0_0_3 net130_4 4.68696e-05f
C9011 XB_0_0_3 net130_5 1.87188e-05f
C9012 XB_0_0_3 net130_6 1.87188e-05f
C9013 XB_0_0_3 net130_8 1.87188e-05f
C9014 XB_0_0_3 net130_9 2.89635e-05f
C9015 XB_0_0_3 net3_11 0.00126831f
C9016 XB_0_0_3 net3_6 0.000819698f
C9017 XB_0_0_3 net3_8 0.000819698f
C9018 XB_0_0_3 net67 0.00391065f
C9019 XB_0_0_3 net6_3 1.74258e-05f
C9020 XB_0_0_3 net6_6 1.26212e-05f
C9021 XB_0_0_3 net76_5 1.21502e-05f
C9022 XB_0_0_3 net76_7 1.8474e-05f
C9023 XB_0_0_3 net78 2.02928e-05f
C9024 XB_0_0_3 net7_11 0.000297431f
C9025 XB_0_0_3 net7_6 0.000192227f
C9026 XB_0_0_3 net7_8 0.000192227f
C9027 XB_0_1 XB_1_1_3 0.000108739f
C9028 XB_0_1 net68 0.00330396f
C9029 XB_0_1 net7 0.00212169f
C9030 XB_0_1 net7_2 0.00184069f
C9031 XB_0_1 net7_3 0.00199808f
C9032 XB_0_1 net7_4 0.00201276f
C9033 XB_0_1 net7_5 0.000803858f
C9034 XB_0_1 net7_9 0.00193273f
C9035 XB_0_1 net80 2.05947e-05f
C9036 XB_0_1_1 XB_0_2 1.35802e-05f
C9037 XB_0_1_1 XB_1_1_3 0.000454572f
C9038 XB_0_1_1 net10_7 2.20414e-05f
C9039 XB_0_1_1 net11 0.00050715f
C9040 XB_0_1_1 net11_2 0.000439984f
C9041 XB_0_1_1 net11_3 0.000477606f
C9042 XB_0_1_1 net11_4 0.000481113f
C9043 XB_0_1_1 net68 0.0138119f
C9044 XB_0_1_1 net80 8.6094e-05f
C9045 XB_0_1_2 XB_1_1_3 6.42484e-05f
C9046 XB_0_1_2 net10_4 1.44964e-05f
C9047 XB_0_1_2 net11_5 0.000192148f
C9048 XB_0_1_2 net11_7 9.60738e-05f
C9049 XB_0_1_2 net11_9 0.000461983f
C9050 XB_0_1_2 net68 0.00195214f
C9051 XB_0_1_2 net7_7 0.000401929f
C9052 XB_0_1_2 net80 1.21684e-05f
C9053 XB_0_1_3 XB_1_1_3 0.000128497f
C9054 XB_0_1_3 net11_11 0.000297308f
C9055 XB_0_1_3 net11_6 0.000192148f
C9056 XB_0_1_3 net11_8 0.000192148f
C9057 XB_0_1_3 net132 5.86578e-05f
C9058 XB_0_1_3 net132_10 5.34337e-05f
C9059 XB_0_1_3 net132_2 5.08892e-05f
C9060 XB_0_1_3 net132_3 5.52406e-05f
C9061 XB_0_1_3 net132_4 5.56463e-05f
C9062 XB_0_1_3 net132_5 2.22241e-05f
C9063 XB_0_1_3 net132_6 2.22241e-05f
C9064 XB_0_1_3 net132_7 1.1112e-05f
C9065 XB_0_1_3 net132_8 2.22241e-05f
C9066 XB_0_1_3 net132_9 3.43871e-05f
C9067 XB_0_1_3 net134 2.62821e-05f
C9068 XB_0_1_3 net134_10 2.39414e-05f
C9069 XB_0_1_3 net134_2 2.28013e-05f
C9070 XB_0_1_3 net134_3 2.4751e-05f
C9071 XB_0_1_3 net134_4 2.49328e-05f
C9072 XB_0_1_3 net134_9 1.54074e-05f
C9073 XB_0_1_3 net68 0.00390429f
C9074 XB_0_1_3 net79 1.30877e-05f
C9075 XB_0_1_3 net79_2 1.7048e-05f
C9076 XB_0_1_3 net79_3 1.7048e-05f
C9077 XB_0_1_3 net79_4 1.23475e-05f
C9078 XB_0_1_3 net79_5 2.90231e-05f
C9079 XB_0_1_3 net79_7 4.41287e-05f
C9080 XB_0_1_3 net7_11 0.0012438f
C9081 XB_0_1_3 net7_6 0.000803858f
C9082 XB_0_1_3 net7_8 0.000803858f
C9083 XB_0_1_3 net80 2.43368e-05f
C9084 XB_0_2 XB_1_2_3 9.1625e-05f
C9085 XB_0_2 net11 0.00211994f
C9086 XB_0_2 net11_2 0.00183918f
C9087 XB_0_2 net11_3 0.00199644f
C9088 XB_0_2 net11_4 0.0020111f
C9089 XB_0_2 net11_5 0.000803196f
C9090 XB_0_2 net11_9 0.00193113f
C9091 XB_0_2 net2_7 1.00025e-05f
C9092 XB_0_2 net69 0.00324909f
C9093 XB_0_2 net83 1.33389e-05f
C9094 XB_0_2_1 XB_0_3 1.63679e-05f
C9095 XB_0_2_1 XB_1_2_3 0.000383028f
C9096 XB_0_2_1 net14 0.000533725f
C9097 XB_0_2_1 net14_2 0.000463039f
C9098 XB_0_2_1 net14_3 0.000502632f
C9099 XB_0_2_1 net14_4 0.000506323f
C9100 XB_0_2_1 net19_7 1.2829e-05f
C9101 XB_0_2_1 net69 0.0135825f
C9102 XB_0_2_1 net70 2.11428e-05f
C9103 XB_0_2_1 net83 5.57618e-05f
C9104 XB_0_2_2 XB_1_2_3 5.41366e-05f
C9105 XB_0_2_2 net11_7 0.000401598f
C9106 XB_0_2_2 net14_5 0.000202216f
C9107 XB_0_2_2 net14_7 0.000101108f
C9108 XB_0_2_2 net14_9 0.00048619f
C9109 XB_0_2_2 net69 0.00191972f
C9110 XB_0_2_3 XB_1_2_3 0.000108273f
C9111 XB_0_2_3 net11_11 0.00124278f
C9112 XB_0_2_3 net11_6 0.000803196f
C9113 XB_0_2_3 net11_8 0.000803196f
C9114 XB_0_2_3 net14_11 0.000312887f
C9115 XB_0_2_3 net14_6 0.000202216f
C9116 XB_0_2_3 net14_8 0.000202216f
C9117 XB_0_2_3 net69 0.00383944f
C9118 XB_0_2_3 net83 1.57626e-05f
C9119 XB_0_3 XB_1_3_3 0.000108161f
C9120 XB_0_3 net14 0.00212615f
C9121 XB_0_3 net14_2 0.00184456f
C9122 XB_0_3 net14_3 0.00200228f
C9123 XB_0_3 net14_4 0.00201699f
C9124 XB_0_3 net14_5 0.000805547f
C9125 XB_0_3 net14_9 0.00193679f
C9126 XB_0_3 net70 0.00330781f
C9127 XB_0_3 net85 2.02236e-05f
C9128 XB_0_3_1 XB_0_4 2.18949e-05f
C9129 XB_0_3_1 XB_1_3_3 0.000452157f
C9130 XB_0_3_1 net17 0.000524741f
C9131 XB_0_3_1 net17_2 0.000455245f
C9132 XB_0_3_1 net17_3 0.000494172f
C9133 XB_0_3_1 net17_4 0.000497801f
C9134 XB_0_3_1 net70 0.0138279f
C9135 XB_0_3_1 net71 1.55124e-05f
C9136 XB_0_3_1 net85 8.45427e-05f
C9137 XB_0_3_2 XB_1_3_3 6.39071e-05f
C9138 XB_0_3_2 net14_7 0.000402774f
C9139 XB_0_3_2 net17_5 0.000198812f
C9140 XB_0_3_2 net17_7 9.94062e-05f
C9141 XB_0_3_2 net17_9 0.000478007f
C9142 XB_0_3_2 net70 0.00195442f
C9143 XB_0_3_2 net85 1.19491e-05f
C9144 XB_0_3_3 XB_1_3_3 0.000127814f
C9145 XB_0_3_3 net135 5.47558e-05f
C9146 XB_0_3_3 net135_10 4.98792e-05f
C9147 XB_0_3_3 net135_2 4.7504e-05f
C9148 XB_0_3_3 net135_3 5.15659e-05f
C9149 XB_0_3_3 net135_4 5.19446e-05f
C9150 XB_0_3_3 net135_5 2.07457e-05f
C9151 XB_0_3_3 net135_6 2.07457e-05f
C9152 XB_0_3_3 net135_7 1.03728e-05f
C9153 XB_0_3_3 net135_8 2.07457e-05f
C9154 XB_0_3_3 net135_9 3.20996e-05f
C9155 XB_0_3_3 net137 2.69588e-05f
C9156 XB_0_3_3 net137_10 2.45578e-05f
C9157 XB_0_3_3 net137_2 2.33884e-05f
C9158 XB_0_3_3 net137_3 2.53883e-05f
C9159 XB_0_3_3 net137_4 2.55747e-05f
C9160 XB_0_3_3 net137_5 1.02141e-05f
C9161 XB_0_3_3 net137_6 1.02141e-05f
C9162 XB_0_3_3 net137_8 1.02141e-05f
C9163 XB_0_3_3 net137_9 1.58041e-05f
C9164 XB_0_3_3 net14_11 0.00124642f
C9165 XB_0_3_3 net14_6 0.000805547f
C9166 XB_0_3_3 net14_8 0.000805547f
C9167 XB_0_3_3 net17_11 0.00030762f
C9168 XB_0_3_3 net17_6 0.000198812f
C9169 XB_0_3_3 net17_8 0.000198812f
C9170 XB_0_3_3 net70 0.00390884f
C9171 XB_0_3_3 net84_5 1.2328e-05f
C9172 XB_0_3_3 net84_7 1.87443e-05f
C9173 XB_0_3_3 net85 2.38982e-05f
C9174 XB_0_4 XB_1_4_3 9.43295e-05f
C9175 XB_0_4 net17 0.00214563f
C9176 XB_0_4 net17_2 0.00186146f
C9177 XB_0_4 net17_3 0.00202063f
C9178 XB_0_4 net17_4 0.00203547f
C9179 XB_0_4 net17_5 0.000812928f
C9180 XB_0_4 net17_9 0.00195453f
C9181 XB_0_4 net71 0.00329866f
C9182 XB_0_4 net87 1.49358e-05f
C9183 XB_0_4_1 XB_1_4_3 0.000394334f
C9184 XB_0_4_1 net20 0.00053249f
C9185 XB_0_4_1 net20_2 0.000461967f
C9186 XB_0_4_1 net20_3 0.000501469f
C9187 XB_0_4_1 net20_4 0.000505151f
C9188 XB_0_4_1 net27_7 2.03831e-05f
C9189 XB_0_4_1 net71 0.0137897f
C9190 XB_0_4_1 net72 2.01515e-05f
C9191 XB_0_4_1 net87 6.24376e-05f
C9192 XB_0_4_2 XB_1_4_3 5.57346e-05f
C9193 XB_0_4_2 net17_7 0.000406464f
C9194 XB_0_4_2 net20_5 0.000201748f
C9195 XB_0_4_2 net20_7 0.000100874f
C9196 XB_0_4_2 net20_9 0.000485066f
C9197 XB_0_4_2 net27_4 1.34058e-05f
C9198 XB_0_4_2 net71 0.00194901f
C9199 XB_0_4_3 XB_1_4_3 0.000111469f
C9200 XB_0_4_3 net137 4.09129e-05f
C9201 XB_0_4_3 net137_10 3.72691e-05f
C9202 XB_0_4_3 net137_2 3.54944e-05f
C9203 XB_0_4_3 net137_3 3.85294e-05f
C9204 XB_0_4_3 net137_4 3.88124e-05f
C9205 XB_0_4_3 net137_5 1.55009e-05f
C9206 XB_0_4_3 net137_6 1.55009e-05f
C9207 XB_0_4_3 net137_8 1.55009e-05f
C9208 XB_0_4_3 net137_9 2.39845e-05f
C9209 XB_0_4_3 net17_11 0.00125784f
C9210 XB_0_4_3 net17_6 0.000812928f
C9211 XB_0_4_3 net17_8 0.000812928f
C9212 XB_0_4_3 net20_11 0.000312163f
C9213 XB_0_4_3 net20_6 0.000201748f
C9214 XB_0_4_3 net20_8 0.000201748f
C9215 XB_0_4_3 net71 0.00389803f
C9216 XB_0_4_3 net87 1.76497e-05f
C9217 XB_0_5 XB_1_5_3 7.96082e-05f
C9218 XB_0_5 net20 0.00212564f
C9219 XB_0_5 net20_2 0.00184412f
C9220 XB_0_5 net20_3 0.00200181f
C9221 XB_0_5 net20_4 0.0020165f
C9222 XB_0_5 net20_5 0.000805355f
C9223 XB_0_5 net20_9 0.00193633f
C9224 XB_0_5 net72 0.00323155f
C9225 XB_0_5 net90 1.42385e-05f
C9226 XB_0_5_1 XB_0_6 3.89589e-05f
C9227 XB_0_5_1 XB_1_5_3 0.000332793f
C9228 XB_0_5_1 net24 0.00052928f
C9229 XB_0_5_1 net24_2 0.000459183f
C9230 XB_0_5_1 net24_3 0.000498446f
C9231 XB_0_5_1 net24_4 0.000502106f
C9232 XB_0_5_1 net72 0.0135092f
C9233 XB_0_5_1 net90 5.95224e-05f
C9234 XB_0_5_2 XB_1_5_3 4.70365e-05f
C9235 XB_0_5_2 net20_7 0.000402677f
C9236 XB_0_5_2 net24_5 0.000200532f
C9237 XB_0_5_2 net24_7 0.000100266f
C9238 XB_0_5_2 net24_9 0.000482142f
C9239 XB_0_5_2 net72 0.00190936f
C9240 XB_0_5_3 XB_0_6 1.10128e-05f
C9241 XB_0_5_3 XB_1_5_3 9.40729e-05f
C9242 XB_0_5_3 net139 5.22304e-05f
C9243 XB_0_5_3 net139_10 4.75787e-05f
C9244 XB_0_5_3 net139_2 4.53131e-05f
C9245 XB_0_5_3 net139_3 4.91877e-05f
C9246 XB_0_5_3 net139_4 4.95489e-05f
C9247 XB_0_5_3 net139_5 1.97889e-05f
C9248 XB_0_5_3 net139_6 1.97889e-05f
C9249 XB_0_5_3 net139_8 1.97889e-05f
C9250 XB_0_5_3 net139_9 3.06192e-05f
C9251 XB_0_5_3 net141 2.58396e-05f
C9252 XB_0_5_3 net141_10 2.35383e-05f
C9253 XB_0_5_3 net141_2 2.24174e-05f
C9254 XB_0_5_3 net141_3 2.43343e-05f
C9255 XB_0_5_3 net141_4 2.45129e-05f
C9256 XB_0_5_3 net141_9 1.5148e-05f
C9257 XB_0_5_3 net20_11 0.00124612f
C9258 XB_0_5_3 net20_6 0.000805355f
C9259 XB_0_5_3 net20_8 0.000805355f
C9260 XB_0_5_3 net24_11 0.000310281f
C9261 XB_0_5_3 net24_6 0.000200532f
C9262 XB_0_5_3 net24_8 0.000200532f
C9263 XB_0_5_3 net72 0.00381872f
C9264 XB_0_5_3 net88_5 1.10164e-05f
C9265 XB_0_5_3 net88_7 1.67501e-05f
C9266 XB_0_5_3 net90 1.68256e-05f
C9267 XB_0_6 XB_1_6_3 9.5276e-05f
C9268 XB_0_6 net16_7 1.27646e-05f
C9269 XB_0_6 net24 0.0020797f
C9270 XB_0_6 net24_2 0.00180426f
C9271 XB_0_6 net24_3 0.00195854f
C9272 XB_0_6 net24_4 0.00197292f
C9273 XB_0_6 net24_5 0.000787948f
C9274 XB_0_6 net24_9 0.00189448f
C9275 XB_0_6 net73 0.00331555f
C9276 XB_0_6 net93 2.32831e-05f
C9277 XB_0_6_1 XB_1_6_3 0.000398291f
C9278 XB_0_6_1 net28 0.000517443f
C9279 XB_0_6_1 net28_2 0.000448914f
C9280 XB_0_6_1 net28_3 0.000487299f
C9281 XB_0_6_1 net28_4 0.000490877f
C9282 XB_0_6_1 net73 0.0138603f
C9283 XB_0_6_1 net93 9.73325e-05f
C9284 XB_0_6_2 XB_1_6_3 5.62938e-05f
C9285 XB_0_6_2 net24_7 0.000393974f
C9286 XB_0_6_2 net28_5 0.000196047f
C9287 XB_0_6_2 net28_7 9.80236e-05f
C9288 XB_0_6_2 net28_9 0.000471359f
C9289 XB_0_6_2 net73 0.00195899f
C9290 XB_0_6_2 net93 1.37568e-05f
C9291 XB_0_6_3 XB_1_6_3 0.000112588f
C9292 XB_0_6_3 net141 2.77361e-05f
C9293 XB_0_6_3 net141_10 2.52659e-05f
C9294 XB_0_6_3 net141_2 2.40628e-05f
C9295 XB_0_6_3 net141_3 2.61203e-05f
C9296 XB_0_6_3 net141_4 2.63121e-05f
C9297 XB_0_6_3 net141_5 1.05086e-05f
C9298 XB_0_6_3 net141_6 1.05086e-05f
C9299 XB_0_6_3 net141_8 1.05086e-05f
C9300 XB_0_6_3 net141_9 1.62598e-05f
C9301 XB_0_6_3 net24_11 0.00121918f
C9302 XB_0_6_3 net24_6 0.000787948f
C9303 XB_0_6_3 net24_8 0.000787948f
C9304 XB_0_6_3 net28_11 0.000303342f
C9305 XB_0_6_3 net28_6 0.000196047f
C9306 XB_0_6_3 net28_8 0.000196047f
C9307 XB_0_6_3 net73 0.00391798f
C9308 XB_0_6_3 net93 2.75136e-05f
C9309 XB_0_7 XB_1_7_3 0.000134282f
C9310 XB_0_7 net23_7 1.04113e-05f
C9311 XB_0_7 net27_4 1.38166e-05f
C9312 XB_0_7 net27_7 2.10077e-05f
C9313 XB_0_7 net28 0.00214434f
C9314 XB_0_7 net28_2 0.00186035f
C9315 XB_0_7 net28_3 0.00201942f
C9316 XB_0_7 net28_4 0.00203425f
C9317 XB_0_7 net28_5 0.000812441f
C9318 XB_0_7 net28_9 0.00195336f
C9319 XB_0_7 net74 0.00325049f
C9320 XB_0_7_1 XB_1_7_3 0.000561353f
C9321 XB_0_7_1 net74 0.0135883f
C9322 XB_0_7_1 net96 4.12112e-05f
C9323 XB_0_7_2 XB_1_7_3 7.93407e-05f
C9324 XB_0_7_2 net28_7 0.000406221f
C9325 XB_0_7_2 net74 0.00192055f
C9326 XB_0_7_3 XB_1_7_3 0.000158681f
C9327 XB_0_7_3 net142 6.99842e-05f
C9328 XB_0_7_3 net142_10 6.37514e-05f
C9329 XB_0_7_3 net142_2 6.07156e-05f
C9330 XB_0_7_3 net142_3 6.59072e-05f
C9331 XB_0_7_3 net142_4 6.63912e-05f
C9332 XB_0_7_3 net142_5 2.65154e-05f
C9333 XB_0_7_3 net142_6 2.65154e-05f
C9334 XB_0_7_3 net142_7 1.32577e-05f
C9335 XB_0_7_3 net142_8 2.65154e-05f
C9336 XB_0_7_3 net142_9 4.1027e-05f
C9337 XB_0_7_3 net28_11 0.00125708f
C9338 XB_0_7_3 net28_6 0.000812441f
C9339 XB_0_7_3 net28_8 0.000812441f
C9340 XB_0_7_3 net74 0.00384111f
C9341 XB_0_7_3 net91_5 1.12413e-05f
C9342 XB_0_7_3 net91_7 1.7092e-05f
C9343 XB_0_7_3 net94 1.2899e-05f
C9344 XB_0_7_3 net94_2 1.68021e-05f
C9345 XB_0_7_3 net94_3 1.68021e-05f
C9346 XB_0_7_3 net94_4 1.21694e-05f
C9347 XB_0_7_3 net94_5 2.86044e-05f
C9348 XB_0_7_3 net94_7 4.34921e-05f
C9349 XB_0_7_3 net96 1.16494e-05f
C9350 XB_1_0 net130 0.00208796f
C9351 XB_1_0 net130_10 0.00190201f
C9352 XB_1_0 net130_2 0.00181143f
C9353 XB_1_0 net130_3 0.00196632f
C9354 XB_1_0 net130_4 0.00198076f
C9355 XB_1_0 net130_5 0.00079108f
C9356 XB_1_0 net67 2.31547e-05f
C9357 XB_1_0 net78 0.00326267f
C9358 XB_1_0_1 net132 0.000495406f
C9359 XB_1_0_1 net132_2 0.000429794f
C9360 XB_1_0_1 net132_3 0.000466545f
C9361 XB_1_0_1 net132_4 0.000469971f
C9362 XB_1_0_1 net67 9.67956e-05f
C9363 XB_1_0_1 net78 0.0136392f
C9364 XB_1_0_1 net84_7 1.8667e-05f
C9365 XB_1_0_2 net130_7 0.00039554f
C9366 XB_1_0_2 net132_10 0.000451284f
C9367 XB_1_0_2 net132_5 0.000187698f
C9368 XB_1_0_2 net132_7 9.38488e-05f
C9369 XB_1_0_2 net67 1.36809e-05f
C9370 XB_1_0_2 net78 0.00192775f
C9371 XB_1_0_2 net84_5 1.22772e-05f
C9372 XB_1_0_3 net130_6 0.00079108f
C9373 XB_1_0_3 net130_8 0.00079108f
C9374 XB_1_0_3 net130_9 0.00122403f
C9375 XB_1_0_3 net132_6 0.000187698f
C9376 XB_1_0_3 net132_8 0.000187698f
C9377 XB_1_0_3 net132_9 0.000290423f
C9378 XB_1_0_3 net3 2.41505e-05f
C9379 XB_1_0_3 net3_11 1.41578e-05f
C9380 XB_1_0_3 net3_2 2.0952e-05f
C9381 XB_1_0_3 net3_3 2.27436e-05f
C9382 XB_1_0_3 net3_4 2.29106e-05f
C9383 XB_1_0_3 net3_9 2.19996e-05f
C9384 XB_1_0_3 net67 2.73618e-05f
C9385 XB_1_0_3 net78 0.00385549f
C9386 XB_1_1 net132 0.00211266f
C9387 XB_1_1 net132_10 0.0019245f
C9388 XB_1_1 net132_2 0.00183286f
C9389 XB_1_1 net132_3 0.00198958f
C9390 XB_1_1 net132_4 0.00200419f
C9391 XB_1_1 net132_5 0.000800438f
C9392 XB_1_1 net68 2.12307e-05f
C9393 XB_1_1 net80 0.0032655f
C9394 XB_1_1_1 XB_1_2 2.04848e-05f
C9395 XB_1_1_1 net134 0.000519337f
C9396 XB_1_1_1 net134_2 0.000450557f
C9397 XB_1_1_1 net134_3 0.000489083f
C9398 XB_1_1_1 net134_4 0.000492674f
C9399 XB_1_1_1 net68 8.87527e-05f
C9400 XB_1_1_1 net80 0.0136511f
C9401 XB_1_1_1 net81_7 1.45593e-05f
C9402 XB_1_1_2 net132_7 0.000400219f
C9403 XB_1_1_2 net134_10 0.000473085f
C9404 XB_1_1_2 net134_5 0.000196765f
C9405 XB_1_1_2 net134_7 9.83824e-05f
C9406 XB_1_1_2 net68 1.25442e-05f
C9407 XB_1_1_2 net80 0.00192942f
C9408 XB_1_1_3 net11 2.45906e-05f
C9409 XB_1_1_3 net11_11 1.44158e-05f
C9410 XB_1_1_3 net11_2 2.13339e-05f
C9411 XB_1_1_3 net11_3 2.31581e-05f
C9412 XB_1_1_3 net11_4 2.33281e-05f
C9413 XB_1_1_3 net11_9 2.24005e-05f
C9414 XB_1_1_3 net132_6 0.000800438f
C9415 XB_1_1_3 net132_8 0.000800438f
C9416 XB_1_1_3 net132_9 0.00123851f
C9417 XB_1_1_3 net134_6 0.000196765f
C9418 XB_1_1_3 net134_8 0.000196765f
C9419 XB_1_1_3 net134_9 0.000304452f
C9420 XB_1_1_3 net68 2.50883e-05f
C9421 XB_1_1_3 net6_2 1.05869e-05f
C9422 XB_1_1_3 net6_3 1.05869e-05f
C9423 XB_1_1_3 net6_4 1.80235e-05f
C9424 XB_1_1_3 net6_7 2.74042e-05f
C9425 XB_1_1_3 net7 5.79287e-05f
C9426 XB_1_1_3 net7_11 3.39597e-05f
C9427 XB_1_1_3 net7_2 5.02567e-05f
C9428 XB_1_1_3 net7_3 5.4554e-05f
C9429 XB_1_1_3 net7_4 5.49546e-05f
C9430 XB_1_1_3 net7_5 2.19478e-05f
C9431 XB_1_1_3 net7_6 2.19478e-05f
C9432 XB_1_1_3 net7_7 1.09739e-05f
C9433 XB_1_1_3 net7_8 2.19478e-05f
C9434 XB_1_1_3 net7_9 5.27695e-05f
C9435 XB_1_1_3 net80 0.00385884f
C9436 XB_1_2 net134 0.00211853f
C9437 XB_1_2 net134_10 0.00192985f
C9438 XB_1_2 net134_2 0.00183796f
C9439 XB_1_2 net134_3 0.00199512f
C9440 XB_1_2 net134_4 0.00200977f
C9441 XB_1_2 net134_5 0.000802663f
C9442 XB_1_2 net69 2.29993e-05f
C9443 XB_1_2 net76_7 1.31865e-05f
C9444 XB_1_2 net83 0.00320113f
C9445 XB_1_2_1 net135 0.000516835f
C9446 XB_1_2_1 net135_2 0.000448386f
C9447 XB_1_2_1 net135_3 0.000486726f
C9448 XB_1_2_1 net135_4 0.0004903f
C9449 XB_1_2_1 net69 9.61459e-05f
C9450 XB_1_2_1 net83 0.013382f
C9451 XB_1_2_1 net88_7 1.14697e-05f
C9452 XB_1_2_2 net134_7 0.000401332f
C9453 XB_1_2_2 net135_10 0.000470805f
C9454 XB_1_2_2 net135_5 0.000195817f
C9455 XB_1_2_2 net135_7 9.79084e-05f
C9456 XB_1_2_2 net69 1.35891e-05f
C9457 XB_1_2_2 net83 0.00189139f
C9458 XB_1_2_3 net134_6 0.000802663f
C9459 XB_1_2_3 net134_8 0.000802663f
C9460 XB_1_2_3 net134_9 0.00124195f
C9461 XB_1_2_3 net135_6 0.000195817f
C9462 XB_1_2_3 net135_8 0.000195817f
C9463 XB_1_2_3 net135_9 0.000302985f
C9464 XB_1_2_3 net69 2.71782e-05f
C9465 XB_1_2_3 net83 0.00378277f
C9466 XB_1_3 net135 0.00213613f
C9467 XB_1_3 net135_10 0.00194588f
C9468 XB_1_3 net135_2 0.00185322f
C9469 XB_1_3 net135_3 0.00201169f
C9470 XB_1_3 net135_4 0.00202646f
C9471 XB_1_3 net135_5 0.00080933f
C9472 XB_1_3 net70 2.53017e-05f
C9473 XB_1_3 net84_7 1.28166e-05f
C9474 XB_1_3 net85 0.00326688f
C9475 XB_1_3_1 XB_1_4 1.38316e-05f
C9476 XB_1_3_1 net137 0.000540422f
C9477 XB_1_3_1 net137_2 0.000468849f
C9478 XB_1_3_1 net137_3 0.000508939f
C9479 XB_1_3_1 net137_4 0.000512677f
C9480 XB_1_3_1 net70 0.000105771f
C9481 XB_1_3_1 net85 0.0136568f
C9482 XB_1_3_1 net86_7 1.61026e-05f
C9483 XB_1_3_2 net135_7 0.000404665f
C9484 XB_1_3_2 net137_10 0.000492292f
C9485 XB_1_3_2 net137_5 0.000204754f
C9486 XB_1_3_2 net137_7 0.000102377f
C9487 XB_1_3_2 net70 1.49495e-05f
C9488 XB_1_3_2 net85 0.00193023f
C9489 XB_1_3_2 net86_5 1.05905e-05f
C9490 XB_1_3_3 net11 1.14519e-05f
C9491 XB_1_3_3 net11_3 1.07847e-05f
C9492 XB_1_3_3 net11_4 1.08639e-05f
C9493 XB_1_3_3 net11_9 1.0432e-05f
C9494 XB_1_3_3 net135_6 0.00080933f
C9495 XB_1_3_3 net135_8 0.00080933f
C9496 XB_1_3_3 net135_9 0.00125227f
C9497 XB_1_3_3 net137_6 0.000204754f
C9498 XB_1_3_3 net137_8 0.000204754f
C9499 XB_1_3_3 net137_9 0.000316813f
C9500 XB_1_3_3 net13_4 1.68346e-05f
C9501 XB_1_3_3 net13_7 2.55965e-05f
C9502 XB_1_3_3 net14 5.76234e-05f
C9503 XB_1_3_3 net14_11 3.37807e-05f
C9504 XB_1_3_3 net14_2 4.99918e-05f
C9505 XB_1_3_3 net14_3 5.42665e-05f
C9506 XB_1_3_3 net14_4 5.4665e-05f
C9507 XB_1_3_3 net14_5 2.18322e-05f
C9508 XB_1_3_3 net14_6 2.18322e-05f
C9509 XB_1_3_3 net14_7 1.09161e-05f
C9510 XB_1_3_3 net14_8 2.18322e-05f
C9511 XB_1_3_3 net14_9 5.24914e-05f
C9512 XB_1_3_3 net17 2.6924e-05f
C9513 XB_1_3_3 net17_11 1.57837e-05f
C9514 XB_1_3_3 net17_2 2.33582e-05f
C9515 XB_1_3_3 net17_3 2.53555e-05f
C9516 XB_1_3_3 net17_4 2.55417e-05f
C9517 XB_1_3_3 net17_5 1.02009e-05f
C9518 XB_1_3_3 net17_6 1.02009e-05f
C9519 XB_1_3_3 net17_8 1.02009e-05f
C9520 XB_1_3_3 net17_9 2.45262e-05f
C9521 XB_1_3_3 net70 2.9899e-05f
C9522 XB_1_3_3 net85 0.00386047f
C9523 XB_1_4 net137 0.00210795f
C9524 XB_1_4 net137_10 0.00192021f
C9525 XB_1_4 net137_2 0.00182878f
C9526 XB_1_4 net137_3 0.00198515f
C9527 XB_1_4 net137_4 0.00199973f
C9528 XB_1_4 net137_5 0.000798654f
C9529 XB_1_4 net71 2.36784e-05f
C9530 XB_1_4 net81_7 1.33079e-05f
C9531 XB_1_4 net87 0.00326837f
C9532 XB_1_4_1 net139 0.000507786f
C9533 XB_1_4_1 net139_2 0.000440536f
C9534 XB_1_4_1 net139_3 0.000478205f
C9535 XB_1_4_1 net139_4 0.000481716f
C9536 XB_1_4_1 net71 9.8985e-05f
C9537 XB_1_4_1 net87 0.013663f
C9538 XB_1_4_1 net94_7 1.99008e-05f
C9539 XB_1_4_2 net137_7 0.000399327f
C9540 XB_1_4_2 net139_10 0.000462562f
C9541 XB_1_4_2 net139_5 0.000192388f
C9542 XB_1_4_2 net139_7 9.61942e-05f
C9543 XB_1_4_2 net71 1.39904e-05f
C9544 XB_1_4_2 net87 0.00193111f
C9545 XB_1_4_2 net94_5 1.30886e-05f
C9546 XB_1_4_3 net137_6 0.000798654f
C9547 XB_1_4_3 net137_8 0.000798654f
C9548 XB_1_4_3 net137_9 0.00123575f
C9549 XB_1_4_3 net139_6 0.000192388f
C9550 XB_1_4_3 net139_8 0.000192388f
C9551 XB_1_4_3 net139_9 0.000297681f
C9552 XB_1_4_3 net17 2.31097e-05f
C9553 XB_1_4_3 net17_11 1.35476e-05f
C9554 XB_1_4_3 net17_2 2.00491e-05f
C9555 XB_1_4_3 net17_3 2.17634e-05f
C9556 XB_1_4_3 net17_4 2.19232e-05f
C9557 XB_1_4_3 net17_9 2.10515e-05f
C9558 XB_1_4_3 net71 2.79807e-05f
C9559 XB_1_4_3 net87 0.00386222f
C9560 XB_1_5 XB_1_6 1.78701e-05f
C9561 XB_1_5 net139 0.00217646f
C9562 XB_1_5 net139_10 0.00198262f
C9563 XB_1_5 net139_2 0.00188821f
C9564 XB_1_5 net139_3 0.00204966f
C9565 XB_1_5 net139_4 0.00206471f
C9566 XB_1_5 net139_5 0.000824609f
C9567 XB_1_5 net72 3.28461e-05f
C9568 XB_1_5 net90 0.00321929f
C9569 XB_1_5_1 XB_1_6 7.47042e-05f
C9570 XB_1_5_1 net141 0.000539269f
C9571 XB_1_5_1 net141_2 0.000467849f
C9572 XB_1_5_1 net141_3 0.000507853f
C9573 XB_1_5_1 net141_4 0.000511582f
C9574 XB_1_5_1 net72 0.00013731f
C9575 XB_1_5_1 net90 0.0134579f
C9576 XB_1_5_2 XB_1_6 1.05586e-05f
C9577 XB_1_5_2 net139_7 0.000412304f
C9578 XB_1_5_2 net141_10 0.000491241f
C9579 XB_1_5_2 net141_5 0.000204317f
C9580 XB_1_5_2 net141_7 0.000102158f
C9581 XB_1_5_2 net72 1.94071e-05f
C9582 XB_1_5_2 net90 0.00190211f
C9583 XB_1_5_3 XB_1_6 2.11171e-05f
C9584 XB_1_5_3 net139_6 0.000824609f
C9585 XB_1_5_3 net139_8 0.000824609f
C9586 XB_1_5_3 net139_9 0.00127591f
C9587 XB_1_5_3 net141_6 0.000204317f
C9588 XB_1_5_3 net141_8 0.000204317f
C9589 XB_1_5_3 net141_9 0.000316137f
C9590 XB_1_5_3 net19_4 1.02688e-05f
C9591 XB_1_5_3 net19_7 1.56134e-05f
C9592 XB_1_5_3 net20 5.33274e-05f
C9593 XB_1_5_3 net20_11 3.12622e-05f
C9594 XB_1_5_3 net20_2 4.62648e-05f
C9595 XB_1_5_3 net20_3 5.02207e-05f
C9596 XB_1_5_3 net20_4 5.05895e-05f
C9597 XB_1_5_3 net20_5 2.02045e-05f
C9598 XB_1_5_3 net20_6 2.02045e-05f
C9599 XB_1_5_3 net20_7 1.01023e-05f
C9600 XB_1_5_3 net20_8 2.02045e-05f
C9601 XB_1_5_3 net20_9 4.8578e-05f
C9602 XB_1_5_3 net23_4 1.3046e-05f
C9603 XB_1_5_3 net23_7 1.9836e-05f
C9604 XB_1_5_3 net24 1.09702e-05f
C9605 XB_1_5_3 net24_3 1.03311e-05f
C9606 XB_1_5_3 net24_4 1.0407e-05f
C9607 XB_1_5_3 net72 3.88142e-05f
C9608 XB_1_5_3 net90 0.00380423f
C9609 XB_1_6 net141 0.00209792f
C9610 XB_1_6 net141_10 0.00191108f
C9611 XB_1_6 net141_2 0.00182007f
C9612 XB_1_6 net141_3 0.0019757f
C9613 XB_1_6 net141_4 0.00199021f
C9614 XB_1_6 net141_5 0.000794854f
C9615 XB_1_6 net73 2.20269e-05f
C9616 XB_1_6 net86_7 1.23548e-05f
C9617 XB_1_6 net93 0.00329171f
C9618 XB_1_6_1 net142 0.000513178f
C9619 XB_1_6_1 net142_2 0.000445213f
C9620 XB_1_6_1 net142_3 0.000483282f
C9621 XB_1_6_1 net142_4 0.000486831f
C9622 XB_1_6_1 net73 9.20812e-05f
C9623 XB_1_6_1 net93 0.0137606f
C9624 XB_1_6_1 net94_7 1.5907e-05f
C9625 XB_1_6_2 net141_7 0.000397427f
C9626 XB_1_6_2 net142_10 0.000467474f
C9627 XB_1_6_2 net142_5 0.000194431f
C9628 XB_1_6_2 net142_7 9.72157e-05f
C9629 XB_1_6_2 net73 1.30146e-05f
C9630 XB_1_6_2 net93 0.0019449f
C9631 XB_1_6_2 net94_5 1.04619e-05f
C9632 XB_1_6_3 net141_6 0.000794854f
C9633 XB_1_6_3 net141_8 0.000794854f
C9634 XB_1_6_3 net141_9 0.00122987f
C9635 XB_1_6_3 net142_6 0.000194431f
C9636 XB_1_6_3 net142_8 0.000194431f
C9637 XB_1_6_3 net142_9 0.000300842f
C9638 XB_1_6_3 net24 2.87627e-05f
C9639 XB_1_6_3 net24_11 1.68616e-05f
C9640 XB_1_6_3 net24_2 2.49534e-05f
C9641 XB_1_6_3 net24_3 2.70871e-05f
C9642 XB_1_6_3 net24_4 2.7286e-05f
C9643 XB_1_6_3 net24_5 1.08975e-05f
C9644 XB_1_6_3 net24_6 1.08975e-05f
C9645 XB_1_6_3 net24_8 1.08975e-05f
C9646 XB_1_6_3 net24_9 2.6201e-05f
C9647 XB_1_6_3 net73 2.60292e-05f
C9648 XB_1_6_3 net93 0.00388981f
C9649 XB_1_7 net142 0.00218527f
C9650 XB_1_7 net142_10 0.00199065f
C9651 XB_1_7 net142_2 0.00189585f
C9652 XB_1_7 net142_3 0.00205796f
C9653 XB_1_7 net142_4 0.00207307f
C9654 XB_1_7 net142_5 0.000827948f
C9655 XB_1_7 net91 1.06906e-05f
C9656 XB_1_7 net91_2 1.39255e-05f
C9657 XB_1_7 net91_3 1.39255e-05f
C9658 XB_1_7 net91_4 1.0086e-05f
C9659 XB_1_7 net91_5 2.37073e-05f
C9660 XB_1_7 net91_7 3.60462e-05f
C9661 XB_1_7 net94 1.46247e-05f
C9662 XB_1_7 net94_2 1.90501e-05f
C9663 XB_1_7 net94_5 3.24315e-05f
C9664 XB_1_7 net94_7 4.9311e-05f
C9665 XB_1_7 net96 0.00323765f
C9666 XB_1_7_1 net74 2.18852e-05f
C9667 XB_1_7_1 net96 0.0135347f
C9668 XB_1_7_2 net142_7 0.000413974f
C9669 XB_1_7_2 net96 0.00191297f
C9670 XB_1_7_3 net142_6 0.000827948f
C9671 XB_1_7_3 net142_8 0.000827948f
C9672 XB_1_7_3 net142_9 0.00128108f
C9673 XB_1_7_3 net23_7 1.47519e-05f
C9674 XB_1_7_3 net27 1.76943e-05f
C9675 XB_1_7_3 net27_2 2.30485e-05f
C9676 XB_1_7_3 net27_3 2.30485e-05f
C9677 XB_1_7_3 net27_4 3.92385e-05f
C9678 XB_1_7_3 net27_6 1.66936e-05f
C9679 XB_1_7_3 net27_7 5.96608e-05f
C9680 XB_1_7_3 net28 4.99494e-05f
C9681 XB_1_7_3 net28_11 2.92819e-05f
C9682 XB_1_7_3 net28_2 4.33341e-05f
C9683 XB_1_7_3 net28_3 4.70395e-05f
C9684 XB_1_7_3 net28_4 4.73849e-05f
C9685 XB_1_7_3 net28_5 1.89247e-05f
C9686 XB_1_7_3 net28_6 1.89247e-05f
C9687 XB_1_7_3 net28_8 1.89247e-05f
C9688 XB_1_7_3 net28_9 4.55008e-05f
C9689 XB_1_7_3 net94_3 1.90501e-05f
C9690 XB_1_7_3 net94_4 1.37976e-05f
C9691 XB_1_7_3 net96 0.00382593f
C9692 net10 net11_2 0.0124671f
C9693 net10 net11_3 0.0135332f
C9694 net10 net11_4 0.0136326f
C9695 net10 net14 1.89572e-05f
C9696 net10 net14_2 1.64465e-05f
C9697 net10 net14_3 1.78528e-05f
C9698 net10 net14_4 1.79839e-05f
C9699 net10 net81_3 9.26423e-05f
C9700 net10_2 net11_7 0.00272229f
C9701 net10_2 net11_9 0.0130905f
C9702 net10_2 net14_9 1.72688e-05f
C9703 net10_2 net81_3 0.000120675f
C9704 net10_3 net11_11 0.00842436f
C9705 net10_3 net11_8 0.00544459f
C9706 net10_3 net14_11 1.11133e-05f
C9707 net10_3 net81_3 0.000120675f
C9708 net10_4 net11_5 0.00544459f
C9709 net10_4 net13_4 1.65889e-05f
C9710 net10_4 net6_2 1.27199e-05f
C9711 net10_4 net6_4 2.16549e-05f
C9712 net10_4 net6_7 3.29255e-05f
C9713 net10_4 net79_3 1.64514e-05f
C9714 net10_4 net81_4 0.000205442f
C9715 net10_4 net84_4 1.15514e-05f
C9716 net10_6 net11_6 0.00544459f
C9717 net10_6 net132 3.97032e-05f
C9718 net10_6 net132_10 3.61671e-05f
C9719 net10_6 net132_2 3.44449e-05f
C9720 net10_6 net132_3 3.73902e-05f
C9721 net10_6 net132_4 3.76647e-05f
C9722 net10_6 net132_5 1.50426e-05f
C9723 net10_6 net132_6 1.50426e-05f
C9724 net10_6 net132_8 1.50426e-05f
C9725 net10_6 net132_9 2.32753e-05f
C9726 net10_6 net6_3 1.27199e-05f
C9727 net10_6 net81_4 8.74028e-05f
C9728 net10_7 net11 0.0143703f
C9729 net10_7 net13_4 2.52229e-05f
C9730 net10_7 net79_3 2.50138e-05f
C9731 net10_7 net81_4 0.000312368f
C9732 net10_7 net84_4 1.75636e-05f
C9733 net11 net132_8 4.30712e-05f
C9734 net11 net134_6 0.000222201f
C9735 net11 net14 3.67839e-05f
C9736 net11 net69 0.0034037f
C9737 net11 net79_3 1.63579e-05f
C9738 net11 net83 1.52053e-05f
C9739 net11 net84_4 2.9787e-05f
C9740 net11_11 net132_8 2.52497e-05f
C9741 net11_11 net134_9 0.000130261f
C9742 net11_11 net14_6 2.15639e-05f
C9743 net11_11 net69 0.00199536f
C9744 net11_11 net84_4 1.74621e-05f
C9745 net11_2 net132_8 3.73668e-05f
C9746 net11_2 net134_8 0.000192773f
C9747 net11_2 net14 3.19123e-05f
C9748 net11_2 net69 0.00295292f
C9749 net11_2 net79_3 1.41915e-05f
C9750 net11_2 net83 1.31915e-05f
C9751 net11_2 net84_4 2.5842e-05f
C9752 net11_3 net132_8 4.0562e-05f
C9753 net11_3 net134_9 0.000209256f
C9754 net11_3 net14 3.4641e-05f
C9755 net11_3 net69 0.00320541f
C9756 net11_3 net79_3 1.54049e-05f
C9757 net11_3 net83 1.43195e-05f
C9758 net11_3 net84_4 2.80517e-05f
C9759 net11_4 net132_8 4.08598e-05f
C9760 net11_4 net134_9 0.000210793f
C9761 net11_4 net14 3.48954e-05f
C9762 net11_4 net69 0.00322895f
C9763 net11_4 net79_3 1.5518e-05f
C9764 net11_4 net83 1.44246e-05f
C9765 net11_4 net84_4 2.82577e-05f
C9766 net11_5 net132_8 1.63187e-05f
C9767 net11_5 net134_6 8.41868e-05f
C9768 net11_5 net14_5 1.39366e-05f
C9769 net11_5 net69 0.00128958f
C9770 net11_5 net84_4 1.12856e-05f
C9771 net11_6 net132_8 1.63187e-05f
C9772 net11_6 net134_6 8.41868e-05f
C9773 net11_6 net14_6 1.39366e-05f
C9774 net11_6 net69 0.00128958f
C9775 net11_6 net84_4 1.12856e-05f
C9776 net11_7 net134_8 4.20934e-05f
C9777 net11_7 net69 0.000644792f
C9778 net11_8 net132_8 1.63187e-05f
C9779 net11_8 net134_8 8.41868e-05f
C9780 net11_8 net14_6 1.39366e-05f
C9781 net11_8 net69 0.00128958f
C9782 net11_8 net84_4 1.12856e-05f
C9783 net11_9 net132_8 3.92352e-05f
C9784 net11_9 net134_9 0.000202412f
C9785 net11_9 net14_5 3.35079e-05f
C9786 net11_9 net69 0.00310056f
C9787 net11_9 net79_3 1.4901e-05f
C9788 net11_9 net83 1.38511e-05f
C9789 net11_9 net84_4 2.71341e-05f
C9790 net13 net14_2 0.012468f
C9791 net13 net14_3 0.0135341f
C9792 net13 net14_4 0.0136335f
C9793 net13 net84_3 7.51326e-05f
C9794 net130 net132 4.74953e-05f
C9795 net130 net135 1.57029e-05f
C9796 net130 net6_6 3.86794e-05f
C9797 net130 net76_7 0.0144017f
C9798 net130 net78 0.00338386f
C9799 net130_10 net132_5 4.32653e-05f
C9800 net130_10 net135_5 1.43044e-05f
C9801 net130_10 net6_6 3.52346e-05f
C9802 net130_10 net76_2 0.0131191f
C9803 net130_10 net78 0.00308249f
C9804 net130_2 net132 4.1205e-05f
C9805 net130_2 net135 1.36232e-05f
C9806 net130_2 net6_6 3.35567e-05f
C9807 net130_2 net76 0.0124944f
C9808 net130_2 net78 0.0029357f
C9809 net130_3 net132 4.47284e-05f
C9810 net130_3 net135 1.47881e-05f
C9811 net130_3 net6_6 3.64261e-05f
C9812 net130_3 net76 0.0135627f
C9813 net130_3 net78 0.00318673f
C9814 net130_4 net132 4.50568e-05f
C9815 net130_4 net135 1.48967e-05f
C9816 net130_4 net6_6 3.66936e-05f
C9817 net130_4 net76 0.0136623f
C9818 net130_4 net78 0.00321013f
C9819 net130_5 net132_5 1.79949e-05f
C9820 net130_5 net6_6 1.46547e-05f
C9821 net130_5 net76_5 0.00545648f
C9822 net130_5 net78 0.00128206f
C9823 net130_6 net132_6 1.79949e-05f
C9824 net130_6 net3 0.000231046f
C9825 net130_6 net3_5 8.75379e-05f
C9826 net130_6 net3_6 8.75379e-05f
C9827 net130_6 net6_6 1.46547e-05f
C9828 net130_6 net76_4 0.00545648f
C9829 net130_6 net78 0.00128206f
C9830 net130_7 net76_2 0.00272824f
C9831 net130_7 net78 0.000641032f
C9832 net130_8 net132_6 1.79949e-05f
C9833 net130_8 net14 1.21597e-05f
C9834 net130_8 net14_2 1.05493e-05f
C9835 net130_8 net14_3 1.14513e-05f
C9836 net130_8 net14_4 1.15354e-05f
C9837 net130_8 net14_9 1.10767e-05f
C9838 net130_8 net3_2 0.000200446f
C9839 net130_8 net3_7 4.3769e-05f
C9840 net130_8 net3_8 8.75379e-05f
C9841 net130_8 net6_6 1.46547e-05f
C9842 net130_8 net7 2.89206e-05f
C9843 net130_8 net76_3 0.00545648f
C9844 net130_8 net78 0.00128206f
C9845 net130_8 net7_11 1.69542e-05f
C9846 net130_8 net7_2 2.50904e-05f
C9847 net130_8 net7_3 2.72358e-05f
C9848 net130_8 net7_4 2.74358e-05f
C9849 net130_8 net7_5 1.09574e-05f
C9850 net130_8 net7_6 1.09574e-05f
C9851 net130_8 net7_8 1.09574e-05f
C9852 net130_8 net7_9 2.63449e-05f
C9853 net130_9 net132_6 2.78433e-05f
C9854 net130_9 net3_11 0.000135447f
C9855 net130_9 net3_3 0.000217586f
C9856 net130_9 net3_4 0.000219184f
C9857 net130_9 net3_9 0.000210469f
C9858 net130_9 net6_6 2.26751e-05f
C9859 net130_9 net76_3 0.00844276f
C9860 net130_9 net78 0.00198373f
C9861 net132 net134 3.55917e-05f
C9862 net132 net68 1.13816e-05f
C9863 net132 net76 1.71054e-05f
C9864 net132 net79_7 0.0143954f
C9865 net132 net80 0.00341248f
C9866 net132_10 net134_5 3.24219e-05f
C9867 net132_10 net68 1.03679e-05f
C9868 net132_10 net76_2 1.5582e-05f
C9869 net132_10 net79_2 0.0131133f
C9870 net132_10 net80 0.00310856f
C9871 net132_2 net134 3.0878e-05f
C9872 net132_2 net76 1.484e-05f
C9873 net132_2 net79 0.0124889f
C9874 net132_2 net80 0.00296053f
C9875 net132_3 net134 3.35183e-05f
C9876 net132_3 net68 1.07185e-05f
C9877 net132_3 net76 1.61089e-05f
C9878 net132_3 net79 0.0135567f
C9879 net132_3 net80 0.00321368f
C9880 net132_4 net134 3.37644e-05f
C9881 net132_4 net68 1.07973e-05f
C9882 net132_4 net76 1.62272e-05f
C9883 net132_4 net79 0.0136563f
C9884 net132_4 net80 0.00323728f
C9885 net132_5 net134_5 1.34849e-05f
C9886 net132_5 net79_5 0.00545407f
C9887 net132_5 net80 0.00129291f
C9888 net132_6 net134_6 1.34849e-05f
C9889 net132_6 net7 0.000233848f
C9890 net132_6 net79_4 0.00545407f
C9891 net132_6 net7_5 8.85995e-05f
C9892 net132_6 net7_6 8.85995e-05f
C9893 net132_6 net80 0.00129291f
C9894 net132_7 net79_2 0.00272704f
C9895 net132_7 net80 0.000646454f
C9896 net132_8 net134_6 1.34849e-05f
C9897 net132_8 net79_3 0.00545407f
C9898 net132_8 net7_2 0.000202877f
C9899 net132_8 net7_7 4.42998e-05f
C9900 net132_8 net7_8 8.85995e-05f
C9901 net132_8 net80 0.00129291f
C9902 net132_9 net134_6 2.0865e-05f
C9903 net132_9 net76_3 1.00277e-05f
C9904 net132_9 net79_3 0.00843903f
C9905 net132_9 net7_11 0.000137089f
C9906 net132_9 net7_3 0.000220225f
C9907 net132_9 net7_4 0.000221842f
C9908 net132_9 net7_9 0.000213021f
C9909 net132_9 net80 0.0020005f
C9910 net134 net135 3.96899e-05f
C9911 net134 net139 1.18995e-05f
C9912 net134 net13_6 1.61313e-05f
C9913 net134 net68 1.56722e-05f
C9914 net134 net6_3 1.34278e-05f
C9915 net134 net79 1.70464e-05f
C9916 net134 net81_7 0.0143975f
C9917 net134 net83 0.00338654f
C9918 net134_10 net135_5 3.6155e-05f
C9919 net134_10 net139_5 1.08398e-05f
C9920 net134_10 net13_6 1.46946e-05f
C9921 net134_10 net68 1.42765e-05f
C9922 net134_10 net6_3 1.22319e-05f
C9923 net134_10 net79_2 1.55283e-05f
C9924 net134_10 net81_2 0.0131153f
C9925 net134_10 net83 0.00308493f
C9926 net134_2 net135 3.44334e-05f
C9927 net134_2 net139 1.03236e-05f
C9928 net134_2 net13_6 1.39948e-05f
C9929 net134_2 net68 1.35966e-05f
C9930 net134_2 net6_3 1.16494e-05f
C9931 net134_2 net79 1.47888e-05f
C9932 net134_2 net81 0.0124907f
C9933 net134_2 net83 0.00293803f
C9934 net134_3 net135 3.73777e-05f
C9935 net134_3 net139 1.12063e-05f
C9936 net134_3 net13_6 1.51915e-05f
C9937 net134_3 net68 1.47592e-05f
C9938 net134_3 net6_3 1.26455e-05f
C9939 net134_3 net79 1.60534e-05f
C9940 net134_3 net81 0.0135588f
C9941 net134_3 net83 0.00318925f
C9942 net134_4 net135 3.76521e-05f
C9943 net134_4 net139 1.12886e-05f
C9944 net134_4 net13_6 1.53031e-05f
C9945 net134_4 net68 1.48676e-05f
C9946 net134_4 net6_3 1.27384e-05f
C9947 net134_4 net79 1.61712e-05f
C9948 net134_4 net81 0.0136584f
C9949 net134_4 net83 0.00321267f
C9950 net134_5 net135_5 1.50376e-05f
C9951 net134_5 net81_5 0.00545489f
C9952 net134_5 net83 0.00128308f
C9953 net134_6 net135_6 1.50376e-05f
C9954 net134_6 net7 2.86359e-05f
C9955 net134_6 net7_11 1.67873e-05f
C9956 net134_6 net7_2 2.48434e-05f
C9957 net134_6 net7_3 2.69676e-05f
C9958 net134_6 net7_4 2.71657e-05f
C9959 net134_6 net7_5 1.08495e-05f
C9960 net134_6 net7_6 1.08495e-05f
C9961 net134_6 net7_8 1.08495e-05f
C9962 net134_6 net7_9 2.60855e-05f
C9963 net134_6 net81_4 0.00545489f
C9964 net134_6 net83 0.00128308f
C9965 net134_7 net81_2 0.00272745f
C9966 net134_7 net83 0.00064154f
C9967 net134_8 net135_6 1.50376e-05f
C9968 net134_8 net14 2.43597e-05f
C9969 net134_8 net14_11 1.42804e-05f
C9970 net134_8 net14_2 2.11335e-05f
C9971 net134_8 net14_3 2.29406e-05f
C9972 net134_8 net14_4 2.3109e-05f
C9973 net134_8 net14_9 2.21902e-05f
C9974 net134_8 net81_3 0.00545489f
C9975 net134_8 net83 0.00128308f
C9976 net134_9 net135_6 2.32675e-05f
C9977 net134_9 net81_3 0.0084403f
C9978 net134_9 net83 0.0019853f
C9979 net135 net137 4.13385e-05f
C9980 net135 net16_6 3.45059e-05f
C9981 net135 net70 1.5883e-05f
C9982 net135 net81 1.79255e-05f
C9983 net135 net84_7 0.0144282f
C9984 net135 net85 0.00341506f
C9985 net135_10 net137_5 3.76568e-05f
C9986 net135_10 net16_6 3.14328e-05f
C9987 net135_10 net70 1.44684e-05f
C9988 net135_10 net81_2 1.63291e-05f
C9989 net135_10 net84_2 0.0131432f
C9990 net135_10 net85 0.00311091f
C9991 net135_2 net137 3.58637e-05f
C9992 net135_2 net16_6 2.9936e-05f
C9993 net135_2 net70 1.37795e-05f
C9994 net135_2 net81 1.55515e-05f
C9995 net135_2 net84 0.0125173f
C9996 net135_2 net85 0.00296277f
C9997 net135_3 net137 3.89303e-05f
C9998 net135_3 net16_6 3.24957e-05f
C9999 net135_3 net70 1.49577e-05f
C10000 net135_3 net81 1.68812e-05f
C10001 net135_3 net84 0.0135876f
C10002 net135_3 net85 0.00321611f
C10003 net135_4 net137 3.92161e-05f
C10004 net135_4 net16_6 3.27344e-05f
C10005 net135_4 net70 1.50675e-05f
C10006 net135_4 net81 1.70052e-05f
C10007 net135_4 net84 0.0136874f
C10008 net135_4 net85 0.00323973f
C10009 net135_5 net137_5 1.56622e-05f
C10010 net135_5 net16_6 1.30735e-05f
C10011 net135_5 net84_5 0.0054665f
C10012 net135_5 net85 0.00129389f
C10013 net135_6 net137_6 1.56622e-05f
C10014 net135_6 net14 0.000250887f
C10015 net135_6 net14_5 9.50554e-05f
C10016 net135_6 net14_6 9.50554e-05f
C10017 net135_6 net16_6 1.30735e-05f
C10018 net135_6 net84_4 0.0054665f
C10019 net135_6 net85 0.00129389f
C10020 net135_7 net84_2 0.00273325f
C10021 net135_7 net85 0.000646943f
C10022 net135_8 net137_6 1.56622e-05f
C10023 net135_8 net14_2 0.00021766f
C10024 net135_8 net14_7 4.75277e-05f
C10025 net135_8 net14_8 9.50554e-05f
C10026 net135_8 net16_6 1.30735e-05f
C10027 net135_8 net17 4.34641e-05f
C10028 net135_8 net17_11 2.548e-05f
C10029 net135_8 net17_2 3.77077e-05f
C10030 net135_8 net17_3 4.0932e-05f
C10031 net135_8 net17_4 4.12326e-05f
C10032 net135_8 net17_5 1.64675e-05f
C10033 net135_8 net17_6 1.64675e-05f
C10034 net135_8 net17_8 1.64675e-05f
C10035 net135_8 net17_9 3.95931e-05f
C10036 net135_8 net84_3 0.0054665f
C10037 net135_8 net85 0.00129389f
C10038 net135_9 net137_6 2.4234e-05f
C10039 net135_9 net14_11 0.000147078f
C10040 net135_9 net14_3 0.000236271f
C10041 net135_9 net14_4 0.000238006f
C10042 net135_9 net14_9 0.000228543f
C10043 net135_9 net16_6 2.02285e-05f
C10044 net135_9 net81_3 1.05085e-05f
C10045 net135_9 net84_3 0.00845826f
C10046 net135_9 net85 0.00200202f
C10047 net137 net139 3.38414e-05f
C10048 net137 net13_3 1.46459e-05f
C10049 net137 net142 1.77993e-05f
C10050 net137 net70 1.01461e-05f
C10051 net137 net86_7 0.0143997f
C10052 net137 net87 0.00340734f
C10053 net137_10 net139_5 3.08274e-05f
C10054 net137_10 net13_3 1.33415e-05f
C10055 net137_10 net142_5 1.6214e-05f
C10056 net137_10 net86_2 0.0131173f
C10057 net137_10 net87 0.00310388f
C10058 net137_2 net139 2.93595e-05f
C10059 net137_2 net13_3 1.27062e-05f
C10060 net137_2 net142 1.54419e-05f
C10061 net137_2 net86 0.0124926f
C10062 net137_2 net87 0.00295608f
C10063 net137_3 net139 3.18699e-05f
C10064 net137_3 net13_3 1.37926e-05f
C10065 net137_3 net142 1.67623e-05f
C10066 net137_3 net86 0.0135608f
C10067 net137_3 net87 0.00320884f
C10068 net137_4 net139 3.21039e-05f
C10069 net137_4 net13_3 1.38939e-05f
C10070 net137_4 net142 1.68854e-05f
C10071 net137_4 net86 0.0136604f
C10072 net137_4 net87 0.0032324f
C10073 net137_5 net139_5 1.28217e-05f
C10074 net137_5 net86_5 0.00545572f
C10075 net137_5 net87 0.00129096f
C10076 net137_6 net139_6 1.28217e-05f
C10077 net137_6 net14 3.74504e-05f
C10078 net137_6 net14_11 2.19547e-05f
C10079 net137_6 net14_2 3.24905e-05f
C10080 net137_6 net14_3 3.52687e-05f
C10081 net137_6 net14_4 3.55277e-05f
C10082 net137_6 net14_5 1.41891e-05f
C10083 net137_6 net14_6 1.41891e-05f
C10084 net137_6 net14_8 1.41891e-05f
C10085 net137_6 net14_9 3.41151e-05f
C10086 net137_6 net17 0.000253201f
C10087 net137_6 net17_5 9.59321e-05f
C10088 net137_6 net17_6 9.59321e-05f
C10089 net137_6 net86_4 0.00545572f
C10090 net137_6 net87 0.00129096f
C10091 net137_7 net86_2 0.00272786f
C10092 net137_7 net87 0.000645481f
C10093 net137_8 net139_6 1.28217e-05f
C10094 net137_8 net17_2 0.000219668f
C10095 net137_8 net17_7 4.79661e-05f
C10096 net137_8 net17_8 9.59321e-05f
C10097 net137_8 net20 2.38854e-05f
C10098 net137_8 net20_11 1.40024e-05f
C10099 net137_8 net20_2 2.0722e-05f
C10100 net137_8 net20_3 2.24939e-05f
C10101 net137_8 net20_4 2.26591e-05f
C10102 net137_8 net20_9 2.17581e-05f
C10103 net137_8 net86_3 0.00545572f
C10104 net137_8 net87 0.00129096f
C10105 net137_9 net139_6 1.98389e-05f
C10106 net137_9 net142_6 1.04345e-05f
C10107 net137_9 net17_11 0.000148435f
C10108 net137_9 net17_3 0.000238451f
C10109 net137_9 net17_4 0.000240202f
C10110 net137_9 net17_9 0.000230651f
C10111 net137_9 net86_3 0.00844158f
C10112 net137_9 net87 0.00199749f
C10113 net139 net141 3.30269e-05f
C10114 net139 net19_6 1.3592e-05f
C10115 net139 net23_6 3.9576e-05f
C10116 net139 net72 1.97334e-05f
C10117 net139 net88_7 0.0143889f
C10118 net139 net90 0.0034217f
C10119 net139 net91_5 1.40227e-05f
C10120 net139_10 net141_5 3.00855e-05f
C10121 net139_10 net19_3 1.23814e-05f
C10122 net139_10 net23_6 3.60514e-05f
C10123 net139_10 net72 1.79759e-05f
C10124 net139_10 net88_2 0.0131074f
C10125 net139_10 net90 0.00311696f
C10126 net139_10 net91_5 1.27739e-05f
C10127 net139_2 net141 2.86529e-05f
C10128 net139_2 net19_3 1.17918e-05f
C10129 net139_2 net23_6 3.43346e-05f
C10130 net139_2 net72 1.71199e-05f
C10131 net139_2 net88 0.0124833f
C10132 net139_2 net90 0.00296853f
C10133 net139_2 net91_7 1.21656e-05f
C10134 net139_3 net141 3.11029e-05f
C10135 net139_3 net19_3 1.28001e-05f
C10136 net139_3 net23_6 3.72705e-05f
C10137 net139_3 net72 1.85838e-05f
C10138 net139_3 net88 0.0135507f
C10139 net139_3 net90 0.00322236f
C10140 net139_3 net91_5 1.32058e-05f
C10141 net139_4 net141 3.13313e-05f
C10142 net139_4 net19_3 1.28941e-05f
C10143 net139_4 net23_6 3.75442e-05f
C10144 net139_4 net72 1.87203e-05f
C10145 net139_4 net88 0.0136502f
C10146 net139_4 net90 0.00324603f
C10147 net139_4 net91_5 1.33028e-05f
C10148 net139_5 net141_5 1.25131e-05f
C10149 net139_5 net23_6 1.49944e-05f
C10150 net139_5 net88_5 0.00545164f
C10151 net139_5 net90 0.0012964f
C10152 net139_6 net141_6 1.25131e-05f
C10153 net139_6 net20 0.000267138f
C10154 net139_6 net20_5 0.000101212f
C10155 net139_6 net20_6 0.000101212f
C10156 net139_6 net23_6 1.49944e-05f
C10157 net139_6 net88_4 0.00545164f
C10158 net139_6 net90 0.0012964f
C10159 net139_7 net88_2 0.00272582f
C10160 net139_7 net90 0.000648201f
C10161 net139_8 net141_6 1.25131e-05f
C10162 net139_8 net20_2 0.000231759f
C10163 net139_8 net20_7 5.06062e-05f
C10164 net139_8 net20_8 0.000101212f
C10165 net139_8 net23_6 1.49944e-05f
C10166 net139_8 net24 4.70293e-05f
C10167 net139_8 net24_11 2.75701e-05f
C10168 net139_8 net24_2 4.08008e-05f
C10169 net139_8 net24_3 4.42896e-05f
C10170 net139_8 net24_4 4.46148e-05f
C10171 net139_8 net24_5 1.78183e-05f
C10172 net139_8 net24_6 1.78183e-05f
C10173 net139_8 net24_8 1.78183e-05f
C10174 net139_8 net24_9 4.28408e-05f
C10175 net139_8 net88_3 0.00545164f
C10176 net139_8 net90 0.0012964f
C10177 net139_9 net141_6 1.93615e-05f
C10178 net139_9 net20_11 0.000156605f
C10179 net139_9 net20_3 0.000251576f
C10180 net139_9 net20_4 0.000253423f
C10181 net139_9 net20_9 0.000243346f
C10182 net139_9 net23_6 2.32008e-05f
C10183 net139_9 net72 1.15684e-05f
C10184 net139_9 net88_3 0.00843526f
C10185 net139_9 net90 0.00200591f
C10186 net13_2 net14_7 0.00272247f
C10187 net13_2 net14_9 0.0130914f
C10188 net13_2 net84_3 9.78673e-05f
C10189 net13_3 net14_11 0.00842492f
C10190 net13_3 net14_8 0.00544495f
C10191 net13_3 net84_3 9.78673e-05f
C10192 net13_4 net14_5 0.00544495f
C10193 net13_4 net70 1.11074e-05f
C10194 net13_4 net81_3 1.40744e-05f
C10195 net13_4 net84_4 0.000166613f
C10196 net13_4 net85 1.41566e-05f
C10197 net13_6 net14_6 0.00544495f
C10198 net13_6 net84_4 7.08834e-05f
C10199 net13_7 net14 0.0143713f
C10200 net13_7 net70 1.68884e-05f
C10201 net13_7 net81_3 2.13997e-05f
C10202 net13_7 net84_4 0.000253329f
C10203 net13_7 net85 2.15247e-05f
C10204 net13_7 net86_4 1.01331e-05f
C10205 net14 net17 2.56165e-05f
C10206 net14 net70 0.00342885f
C10207 net14 net81_3 1.07705e-05f
C10208 net14 net85 3.61122e-05f
C10209 net14 net86_4 3.16626e-05f
C10210 net141 net142 4.66906e-05f
C10211 net141 net19_3 1.96796e-05f
C10212 net141 net88 1.87467e-05f
C10213 net141 net91_7 0.0144151f
C10214 net141 net93 0.00337974f
C10215 net141_10 net142_5 4.25322e-05f
C10216 net141_10 net19_3 1.79269e-05f
C10217 net141_10 net88_2 1.70771e-05f
C10218 net141_10 net91_2 0.0131313f
C10219 net141_10 net93 0.00307874f
C10220 net141_2 net142 4.05069e-05f
C10221 net141_2 net19_3 1.70733e-05f
C10222 net141_2 net88 1.62639e-05f
C10223 net141_2 net91 0.012506f
C10224 net141_2 net93 0.00293213f
C10225 net141_3 net142 4.39705e-05f
C10226 net141_3 net19_3 1.85331e-05f
C10227 net141_3 net88 1.76546e-05f
C10228 net141_3 net91 0.0135753f
C10229 net141_3 net93 0.00318285f
C10230 net141_4 net142 4.42934e-05f
C10231 net141_4 net19_3 1.86692e-05f
C10232 net141_4 net88 1.77842e-05f
C10233 net141_4 net91 0.013675f
C10234 net141_4 net93 0.00320622f
C10235 net141_5 net142_5 1.769e-05f
C10236 net141_5 net91_5 0.00546154f
C10237 net141_5 net93 0.0012805f
C10238 net141_6 net142_6 1.769e-05f
C10239 net141_6 net20 3.07867e-05f
C10240 net141_6 net20_11 1.80482e-05f
C10241 net141_6 net20_2 2.67093e-05f
C10242 net141_6 net20_3 2.89932e-05f
C10243 net141_6 net20_4 2.92061e-05f
C10244 net141_6 net20_5 1.16644e-05f
C10245 net141_6 net20_6 1.16644e-05f
C10246 net141_6 net20_8 1.16644e-05f
C10247 net141_6 net20_9 2.80448e-05f
C10248 net141_6 net24 0.000206786f
C10249 net141_6 net24_5 7.83464e-05f
C10250 net141_6 net24_6 7.83464e-05f
C10251 net141_6 net91_4 0.00546154f
C10252 net141_6 net93 0.0012805f
C10253 net141_7 net91_2 0.00273077f
C10254 net141_7 net93 0.000640252f
C10255 net141_8 net142_6 1.769e-05f
C10256 net141_8 net24_2 0.000179399f
C10257 net141_8 net24_7 3.91732e-05f
C10258 net141_8 net24_8 7.83464e-05f
C10259 net141_8 net28 1.99468e-05f
C10260 net141_8 net28_11 1.16935e-05f
C10261 net141_8 net28_2 1.73051e-05f
C10262 net141_8 net28_3 1.87848e-05f
C10263 net141_8 net28_4 1.89227e-05f
C10264 net141_8 net28_9 1.81703e-05f
C10265 net141_8 net91_3 0.00546154f
C10266 net141_8 net93 0.0012805f
C10267 net141_9 net142_6 2.73715e-05f
C10268 net141_9 net19_3 1.15368e-05f
C10269 net141_9 net24_11 0.000121225f
C10270 net141_9 net24_3 0.000194739f
C10271 net141_9 net24_4 0.000196169f
C10272 net141_9 net24_9 0.000188369f
C10273 net141_9 net88_3 1.09899e-05f
C10274 net141_9 net91_3 0.00845059f
C10275 net141_9 net93 0.00198131f
C10276 net142 net27_6 3.38982e-05f
C10277 net142 net74 2.59499e-05f
C10278 net142 net91 2.3493e-05f
C10279 net142 net94_7 0.0144181f
C10280 net142 net96 0.0034063f
C10281 net142_10 net27_3 3.08792e-05f
C10282 net142_10 net74 2.36388e-05f
C10283 net142_10 net91_2 2.14007e-05f
C10284 net142_10 net94_2 0.013134f
C10285 net142_10 net96 0.00310293f
C10286 net142_2 net27_3 2.94088e-05f
C10287 net142_2 net74 2.25131e-05f
C10288 net142_2 net91 2.03816e-05f
C10289 net142_2 net94 0.0125086f
C10290 net142_2 net96 0.00295517f
C10291 net142_3 net27_3 3.19234e-05f
C10292 net142_3 net74 2.44381e-05f
C10293 net142_3 net91 2.21244e-05f
C10294 net142_3 net94 0.0135782f
C10295 net142_3 net96 0.00320786f
C10296 net142_4 net27_3 3.21578e-05f
C10297 net142_4 net74 2.46176e-05f
C10298 net142_4 net91 2.22869e-05f
C10299 net142_4 net94 0.0136779f
C10300 net142_4 net96 0.00323142f
C10301 net142_5 net27_6 1.28432e-05f
C10302 net142_5 net94_5 0.00546269f
C10303 net142_5 net96 0.00129057f
C10304 net142_6 net17 1.50293e-05f
C10305 net142_6 net17_2 1.30389e-05f
C10306 net142_6 net17_3 1.41538e-05f
C10307 net142_6 net17_4 1.42577e-05f
C10308 net142_6 net17_9 1.36908e-05f
C10309 net142_6 net27_6 1.28432e-05f
C10310 net142_6 net28 0.000297498f
C10311 net142_6 net28_5 0.000112715f
C10312 net142_6 net28_6 0.000112715f
C10313 net142_6 net94_4 0.00546269f
C10314 net142_6 net96 0.00129057f
C10315 net142_7 net94_2 0.00273135f
C10316 net142_7 net96 0.000645284f
C10317 net142_8 net27_3 1.28432e-05f
C10318 net142_8 net28_2 0.000258098f
C10319 net142_8 net28_7 5.63576e-05f
C10320 net142_8 net28_8 0.000112715f
C10321 net142_8 net94_3 0.00546269f
C10322 net142_8 net96 0.00129057f
C10323 net142_9 net27_3 1.98722e-05f
C10324 net142_9 net28_11 0.000174403f
C10325 net142_9 net28_3 0.000280167f
C10326 net142_9 net28_4 0.000282224f
C10327 net142_9 net28_9 0.000271003f
C10328 net142_9 net74 1.52127e-05f
C10329 net142_9 net91_3 1.37724e-05f
C10330 net142_9 net94_3 0.00845237f
C10331 net142_9 net96 0.00199688f
C10332 net14_11 net17_6 1.50172e-05f
C10333 net14_11 net70 0.0020101f
C10334 net14_11 net85 2.11701e-05f
C10335 net14_11 net86_4 1.85616e-05f
C10336 net14_2 net17 2.22239e-05f
C10337 net14_2 net70 0.00297473f
C10338 net14_2 net85 3.13295e-05f
C10339 net14_2 net86_4 2.74692e-05f
C10340 net14_3 net17 2.41242e-05f
C10341 net14_3 net70 0.0032291f
C10342 net14_3 net81_3 1.01431e-05f
C10343 net14_3 net85 3.40084e-05f
C10344 net14_3 net86_4 2.9818e-05f
C10345 net14_4 net17 2.43013e-05f
C10346 net14_4 net70 0.00325281f
C10347 net14_4 net81_3 1.02175e-05f
C10348 net14_4 net85 3.42581e-05f
C10349 net14_4 net86_4 3.0037e-05f
C10350 net14_5 net70 0.00129911f
C10351 net14_5 net85 1.36821e-05f
C10352 net14_5 net86_4 1.19962e-05f
C10353 net14_6 net70 0.00129911f
C10354 net14_6 net85 1.36821e-05f
C10355 net14_6 net86_4 1.19962e-05f
C10356 net14_7 net70 0.000649556f
C10357 net14_8 net70 0.00129911f
C10358 net14_8 net85 1.36821e-05f
C10359 net14_8 net86_4 1.19962e-05f
C10360 net14_9 net17_5 2.33351e-05f
C10361 net14_9 net70 0.00312347f
C10362 net14_9 net85 3.2896e-05f
C10363 net14_9 net86_4 2.88427e-05f
C10364 net16 net17_2 0.0124387f
C10365 net16 net17_3 0.0135023f
C10366 net16 net17_4 0.0136015f
C10367 net16 net20 1.34801e-05f
C10368 net16 net20_2 1.16948e-05f
C10369 net16 net20_3 1.26948e-05f
C10370 net16 net20_4 1.2788e-05f
C10371 net16 net86_3 7.60696e-05f
C10372 net16_2 net17_7 0.00271609f
C10373 net16_2 net17_9 0.0130607f
C10374 net16_2 net20_9 1.22796e-05f
C10375 net16_2 net86_3 9.90878e-05f
C10376 net16_3 net17_11 0.00840516f
C10377 net16_3 net17_8 0.00543218f
C10378 net16_3 net86_3 9.90878e-05f
C10379 net16_4 net17_5 0.00543218f
C10380 net16_4 net86_4 0.00016869f
C10381 net16_4 net88_4 1.2121e-05f
C10382 net16_6 net17_6 0.00543218f
C10383 net16_6 net86_4 7.17674e-05f
C10384 net16_7 net17 0.0143376f
C10385 net16_7 net19_4 1.16567e-05f
C10386 net16_7 net86_4 0.000256488f
C10387 net16_7 net88_4 1.84296e-05f
C10388 net17 net20 4.00965e-05f
C10389 net17 net71 0.00340793f
C10390 net17 net88_4 2.82435e-05f
C10391 net17_11 net20_6 2.35058e-05f
C10392 net17_11 net71 0.00199784f
C10393 net17_11 net88_4 1.65573e-05f
C10394 net17_2 net20 3.47861e-05f
C10395 net17_2 net71 0.00295658f
C10396 net17_2 net88_4 2.4503e-05f
C10397 net17_3 net20 3.77606e-05f
C10398 net17_3 net71 0.00320939f
C10399 net17_3 net88_4 2.65982e-05f
C10400 net17_4 net20 3.80379e-05f
C10401 net17_4 net71 0.00323296f
C10402 net17_4 net88_4 2.67935e-05f
C10403 net17_5 net20_5 1.51916e-05f
C10404 net17_5 net71 0.00129118f
C10405 net17_5 net88_4 1.07008e-05f
C10406 net17_6 net20_6 1.51916e-05f
C10407 net17_6 net71 0.00129118f
C10408 net17_6 net88_4 1.07008e-05f
C10409 net17_7 net71 0.000645592f
C10410 net17_8 net20_6 1.51916e-05f
C10411 net17_8 net71 0.00129118f
C10412 net17_8 net88_4 1.07008e-05f
C10413 net17_9 net20_5 3.65254e-05f
C10414 net17_9 net71 0.00310441f
C10415 net17_9 net88_4 2.57281e-05f
C10416 net19 net20_2 0.0124445f
C10417 net19 net20_3 0.0135086f
C10418 net19 net20_4 0.0136078f
C10419 net19 net24 1.61245e-05f
C10420 net19 net24_2 1.3989e-05f
C10421 net19 net24_3 1.51851e-05f
C10422 net19 net24_4 1.52966e-05f
C10423 net19 net88_3 6.58957e-05f
C10424 net19_2 net20_7 0.00271734f
C10425 net19_2 net20_9 0.0130667f
C10426 net19_2 net24_9 1.46884e-05f
C10427 net19_2 net88_3 8.58353e-05f
C10428 net19_3 net20_11 0.00840904f
C10429 net19_3 net20_8 0.00543469f
C10430 net19_3 net88_3 8.58353e-05f
C10431 net19_4 net20_5 0.00543469f
C10432 net19_4 net72 1.22715e-05f
C10433 net19_4 net88_4 0.000146129f
C10434 net19_4 net90 1.36019e-05f
C10435 net19_4 net91_4 1.44231e-05f
C10436 net19_6 net20_6 0.00543469f
C10437 net19_6 net88_4 6.21689e-05f
C10438 net19_7 net20 0.0143442f
C10439 net19_7 net23_4 1.0579e-05f
C10440 net19_7 net72 1.86584e-05f
C10441 net19_7 net88_4 0.000222184f
C10442 net19_7 net90 2.06812e-05f
C10443 net19_7 net91_4 2.19299e-05f
C10444 net2 net3_2 0.0124503f
C10445 net2 net3_3 0.0135149f
C10446 net2 net3_4 0.0136141f
C10447 net2 net6_4 1.45848e-05f
C10448 net2 net7 1.47338e-05f
C10449 net2 net76_3 6.56823e-05f
C10450 net2 net7_2 1.27825e-05f
C10451 net2 net7_3 1.38755e-05f
C10452 net2 net7_4 1.39774e-05f
C10453 net20 net24 1.88616e-05f
C10454 net20 net72 0.00342817f
C10455 net20 net90 2.898e-05f
C10456 net20 net91_4 3.8481e-05f
C10457 net20_11 net24_6 1.10573e-05f
C10458 net20_11 net72 0.00200971f
C10459 net20_11 net90 1.6989e-05f
C10460 net20_11 net91_4 2.25588e-05f
C10461 net20_2 net24 1.63636e-05f
C10462 net20_2 net72 0.00297415f
C10463 net20_2 net90 2.51419e-05f
C10464 net20_2 net91_4 3.33846e-05f
C10465 net20_3 net24 1.77628e-05f
C10466 net20_3 net72 0.00322846f
C10467 net20_3 net90 2.72918e-05f
C10468 net20_3 net91_4 3.62393e-05f
C10469 net20_4 net24 1.78932e-05f
C10470 net20_4 net72 0.00325217f
C10471 net20_4 net90 2.74922e-05f
C10472 net20_4 net91_4 3.65054e-05f
C10473 net20_5 net72 0.00129886f
C10474 net20_5 net90 1.09799e-05f
C10475 net20_5 net91_4 1.45796e-05f
C10476 net20_6 net72 0.00129886f
C10477 net20_6 net90 1.09799e-05f
C10478 net20_6 net91_4 1.45796e-05f
C10479 net20_7 net72 0.000649428f
C10480 net20_8 net72 0.00129886f
C10481 net20_8 net90 1.09799e-05f
C10482 net20_8 net91_4 1.45796e-05f
C10483 net20_9 net24_5 1.71818e-05f
C10484 net20_9 net72 0.00312286f
C10485 net20_9 net90 2.6399e-05f
C10486 net20_9 net91_4 3.50539e-05f
C10487 net23 net24_2 0.0124475f
C10488 net23 net24_3 0.0135119f
C10489 net23 net24_4 0.0136111f
C10490 net23 net28 2.00422e-05f
C10491 net23 net28_2 1.73878e-05f
C10492 net23 net28_3 1.88746e-05f
C10493 net23 net28_4 1.90132e-05f
C10494 net23 net91_3 8.65893e-05f
C10495 net23_2 net24_7 0.00271801f
C10496 net23_2 net24_9 0.0130699f
C10497 net23_2 net28_9 1.82572e-05f
C10498 net23_2 net88_3 1.12636e-05f
C10499 net23_2 net91_3 0.000112791f
C10500 net23_3 net24_11 0.0084111f
C10501 net23_3 net24_8 0.00543602f
C10502 net23_3 net28_11 1.17494e-05f
C10503 net23_3 net88_3 1.12636e-05f
C10504 net23_3 net91_3 0.000112791f
C10505 net23_4 net24_5 0.00543602f
C10506 net23_4 net72 1.23252e-05f
C10507 net23_4 net88_3 1.91755e-05f
C10508 net23_4 net91_4 0.000192019f
C10509 net23_6 net24_6 0.00543602f
C10510 net23_6 net91_4 8.16921e-05f
C10511 net23_7 net24 0.0143477f
C10512 net23_7 net72 1.874e-05f
C10513 net23_7 net88_3 2.91558e-05f
C10514 net23_7 net90 1.05072e-05f
C10515 net23_7 net91_4 0.000291958f
C10516 net23_7 net96 1.05796e-05f
C10517 net24 net28 4.00621e-05f
C10518 net24 net73 0.0034081f
C10519 net24 net88_3 1.44278e-05f
C10520 net24 net94_4 2.6657e-05f
C10521 net24_11 net28_6 2.34857e-05f
C10522 net24_11 net73 0.00199794f
C10523 net24_11 net94_4 1.56272e-05f
C10524 net24_2 net28 3.47563e-05f
C10525 net24_2 net73 0.00295673f
C10526 net24_2 net88_3 1.2517e-05f
C10527 net24_2 net94_4 2.31266e-05f
C10528 net24_3 net28 3.77283e-05f
C10529 net24_3 net73 0.00320956f
C10530 net24_3 net88_3 1.35873e-05f
C10531 net24_3 net94_4 2.5104e-05f
C10532 net24_4 net28 3.80053e-05f
C10533 net24_4 net73 0.00323312f
C10534 net24_4 net88_3 1.36871e-05f
C10535 net24_4 net94_4 2.52884e-05f
C10536 net24_5 net28_5 1.51786e-05f
C10537 net24_5 net73 0.00129125f
C10538 net24_5 net94_4 1.00997e-05f
C10539 net24_6 net28_6 1.51786e-05f
C10540 net24_6 net73 0.00129125f
C10541 net24_6 net94_4 1.00997e-05f
C10542 net24_7 net73 0.000645625f
C10543 net24_8 net28_6 1.51786e-05f
C10544 net24_8 net73 0.00129125f
C10545 net24_8 net94_4 1.00997e-05f
C10546 net24_9 net28_5 3.64941e-05f
C10547 net24_9 net73 0.00310457f
C10548 net24_9 net88_3 1.31429e-05f
C10549 net24_9 net94_4 2.42829e-05f
C10550 net27 net28_2 0.0125007f
C10551 net27 net28_3 0.0135696f
C10552 net27 net28_4 0.0136692f
C10553 net27 net94_3 8.12047e-05f
C10554 net27_2 net28_7 0.00272962f
C10555 net27_2 net28_9 0.0131257f
C10556 net27_2 net94_3 0.000105777f
C10557 net27_3 net28_11 0.00844703f
C10558 net27_3 net28_8 0.00545924f
C10559 net27_3 net94_3 0.000105777f
C10560 net27_4 net28_5 0.00545924f
C10561 net27_4 net74 1.11267e-05f
C10562 net27_4 net94_4 0.000180078f
C10563 net27_4 net96 1.37865e-05f
C10564 net27_6 net28_6 0.00545924f
C10565 net27_6 net94_4 7.66121e-05f
C10566 net27_7 net28 0.014409f
C10567 net27_7 net74 1.69178e-05f
C10568 net27_7 net94_4 0.000273803f
C10569 net27_7 net96 2.0962e-05f
C10570 net28 net74 0.00342524f
C10571 net28 net91_3 1.81063e-05f
C10572 net28 net96 3.56028e-05f
C10573 net28_11 net74 0.00200799f
C10574 net28_11 net91_3 1.06145e-05f
C10575 net28_11 net96 2.08715e-05f
C10576 net28_2 net74 0.0029716f
C10577 net28_2 net91_3 1.57083e-05f
C10578 net28_2 net96 3.08876e-05f
C10579 net28_3 net74 0.0032257f
C10580 net28_3 net91_3 1.70515e-05f
C10581 net28_3 net96 3.35287e-05f
C10582 net28_4 net74 0.00324938f
C10583 net28_4 net91_3 1.71767e-05f
C10584 net28_4 net96 3.37749e-05f
C10585 net28_5 net74 0.00129774f
C10586 net28_5 net96 1.34891e-05f
C10587 net28_6 net74 0.00129774f
C10588 net28_6 net96 1.34891e-05f
C10589 net28_7 net74 0.000648872f
C10590 net28_8 net74 0.00129774f
C10591 net28_8 net96 1.34891e-05f
C10592 net28_9 net74 0.00312018f
C10593 net28_9 net91_3 1.64937e-05f
C10594 net28_9 net96 3.24319e-05f
C10595 net2_2 net3_7 0.00271861f
C10596 net2_2 net3_9 0.0130728f
C10597 net2_2 net6_4 1.8998e-05f
C10598 net2_2 net76_3 8.55574e-05f
C10599 net2_2 net7_9 1.34216e-05f
C10600 net2_3 net3_11 0.00841296f
C10601 net2_3 net3_8 0.00543722f
C10602 net2_3 net6_6 1.8998e-05f
C10603 net2_3 net76_3 8.55574e-05f
C10604 net2_4 net3_5 0.00543722f
C10605 net2_4 net6_4 3.23429e-05f
C10606 net2_4 net76_4 0.000145656f
C10607 net2_4 net79_4 1.4039e-05f
C10608 net2_6 net3_6 0.00543722f
C10609 net2_6 net6_6 1.37599e-05f
C10610 net2_6 net76_4 6.19676e-05f
C10611 net2_7 net3 0.0143509f
C10612 net2_7 net6_4 4.91763e-05f
C10613 net2_7 net76_4 0.000221465f
C10614 net2_7 net79_4 2.13458e-05f
C10615 net3 net67 0.00341486f
C10616 net3 net7 4.4562e-05f
C10617 net3 net78 2.12407e-05f
C10618 net3 net79_4 3.12596e-05f
C10619 net3_11 net67 0.0020019f
C10620 net3_11 net78 1.2452e-05f
C10621 net3_11 net79_4 1.83254e-05f
C10622 net3_11 net7_6 2.61237e-05f
C10623 net3_2 net67 0.0029626f
C10624 net3_2 net7 3.86602e-05f
C10625 net3_2 net78 1.84276e-05f
C10626 net3_2 net79_4 2.71196e-05f
C10627 net3_3 net67 0.00321592f
C10628 net3_3 net7 4.1966e-05f
C10629 net3_3 net78 2.00033e-05f
C10630 net3_3 net79_4 2.94385e-05f
C10631 net3_4 net67 0.00323954f
C10632 net3_4 net7 4.22741e-05f
C10633 net3_4 net78 2.01502e-05f
C10634 net3_4 net79_4 2.96547e-05f
C10635 net3_5 net67 0.00129381f
C10636 net3_5 net79_4 1.18435e-05f
C10637 net3_5 net7_5 1.68835e-05f
C10638 net3_6 net67 0.00129381f
C10639 net3_6 net79_4 1.18435e-05f
C10640 net3_6 net7_6 1.68835e-05f
C10641 net3_7 net67 0.000646906f
C10642 net3_8 net67 0.00129381f
C10643 net3_8 net79_4 1.18435e-05f
C10644 net3_8 net7_6 1.68835e-05f
C10645 net3_9 net67 0.00311073f
C10646 net3_9 net78 1.9349e-05f
C10647 net3_9 net79_4 2.84755e-05f
C10648 net3_9 net7_5 4.05932e-05f
C10649 net6 net68 1.07397e-05f
C10650 net6 net79_3 9.36571e-05f
C10651 net6 net7_2 0.0125202f
C10652 net6 net7_3 0.0135908f
C10653 net6 net7_4 0.0136906f
C10654 net68 net6_2 1.39895e-05f
C10655 net68 net6_3 1.39895e-05f
C10656 net68 net6_4 2.38162e-05f
C10657 net68 net6_6 1.01323e-05f
C10658 net68 net6_7 3.62117e-05f
C10659 net68 net7 0.00342425f
C10660 net68 net79_5 1.09756e-05f
C10661 net68 net79_7 1.6688e-05f
C10662 net68 net7_11 0.00200741f
C10663 net68 net7_2 0.00297075f
C10664 net68 net7_3 0.00322477f
C10665 net68 net7_4 0.00324845f
C10666 net68 net7_5 0.00129737f
C10667 net68 net7_6 0.00129737f
C10668 net68 net7_7 0.000648685f
C10669 net68 net7_8 0.00129737f
C10670 net68 net7_9 0.00311928f
C10671 net68 net80 1.09892e-05f
C10672 net69 net83 1.07861e-05f
C10673 net6_2 net76_3 1.14697e-05f
C10674 net6_2 net79_3 0.000121997f
C10675 net6_2 net7_7 0.00273388f
C10676 net6_2 net7_9 0.0131462f
C10677 net6_3 net76_3 1.14697e-05f
C10678 net6_3 net79_3 0.000121997f
C10679 net6_3 net7_11 0.00846022f
C10680 net6_3 net7_8 0.00546777f
C10681 net6_4 net76_3 1.95265e-05f
C10682 net6_4 net79_4 0.000207692f
C10683 net6_4 net7_5 0.00546777f
C10684 net6_4 net80 1.1424e-05f
C10685 net6_4 net81_4 1.22266e-05f
C10686 net6_6 net79_4 8.83602e-05f
C10687 net6_6 net7_6 0.00546777f
C10688 net6_7 net7 0.0144315f
C10689 net6_7 net76_3 2.96893e-05f
C10690 net6_7 net79_4 0.000315789f
C10691 net6_7 net80 1.73699e-05f
C10692 net6_7 net81_4 1.85902e-05f
C10693 net7 net76_3 2.26523e-05f
C10694 net7 net80 2.43288e-05f
C10695 net7 net81_4 2.48197e-05f
C10696 net70 net84_5 1.07612e-05f
C10697 net70 net84_7 1.6362e-05f
C10698 net70 net85 2.20029e-05f
C10699 net71 net87 2.40266e-05f
C10700 net72 net88_5 1.05752e-05f
C10701 net72 net88_7 1.60793e-05f
C10702 net72 net91_7 1.201e-05f
C10703 net73 net93 5.48793e-05f
C10704 net74 net91_7 1.31026e-05f
C10705 net74 net94_5 1.169e-05f
C10706 net74 net94_7 1.77743e-05f
C10707 net74 net96 9.54641e-05f
C10708 net76_2 net79_5 1.08258e-05f
C10709 net76_3 net79_4 1.08258e-05f
C10710 net76_3 net7_11 1.32795e-05f
C10711 net76_3 net7_2 1.96523e-05f
C10712 net76_3 net7_3 2.13327e-05f
C10713 net76_3 net7_4 2.14893e-05f
C10714 net76_3 net7_9 2.06349e-05f
C10715 net76_5 net79_5 1.84303e-05f
C10716 net76_7 net79_5 2.80227e-05f
C10717 net79_2 net80 1.27937e-05f
C10718 net79_3 net80 1.27937e-05f
C10719 net79_5 net80 2.17804e-05f
C10720 net79_7 net80 3.31164e-05f
C10721 net79_7 net81_5 1.40001e-05f
C10722 net7_11 net80 1.42623e-05f
C10723 net7_11 net81_4 1.45501e-05f
C10724 net7_2 net80 2.11067e-05f
C10725 net7_2 net81_4 2.15326e-05f
C10726 net7_3 net80 2.29115e-05f
C10727 net7_3 net81_4 2.33738e-05f
C10728 net7_4 net80 2.30797e-05f
C10729 net7_4 net81_4 2.35454e-05f
C10730 net7_9 net80 2.2162e-05f
C10731 net7_9 net81_4 2.26092e-05f
C10732 net81_2 net84_5 1.19205e-05f
C10733 net81_3 net84_4 1.19205e-05f
C10734 net81_5 net84_5 2.02939e-05f
C10735 net81_7 net84_5 3.08562e-05f
C10736 net84_5 net85 1.04509e-05f
C10737 net84_5 net86_5 1.12867e-05f
C10738 net84_7 net85 1.58903e-05f
C10739 net84_7 net86_5 1.7161e-05f
C10740 net86_5 net88_5 1.21017e-05f
C10741 net86_7 net88_5 1.84003e-05f
C10742 net88_5 net91_5 1.29302e-05f
C10743 net88_7 net91_5 1.96599e-05f
C10744 net90 net91_5 1.5139e-05f
C10745 net90 net91_7 2.30183e-05f
C10746 net91_5 net96 1.15081e-05f
C10747 net91_7 net94_5 1.44846e-05f
C10748 net91_7 net96 1.74977e-05f
C10749 net94_7 net96 1.4938e-05f
.ends
