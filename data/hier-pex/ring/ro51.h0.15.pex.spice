* RO51 - parasitic extraction by OpenLayout (openlayout pex, mode rc)
* layout: /tmp/xs/ro51.gds
* C: FasterCap 3D field solver (k = 4.6 front end, 3.23 above z = 0.074 um); R: KLayout RNetExtractor, reference sheet / via resistances
* 102 transistors, 357 resistors, 1538 capacitors
* total capacitance per net (fF): S0 0.3920, S1 0.3665, S10 0.3675, S11 0.3675, S12 0.3675, S13 0.3675, S14 0.3675, S15 0.3675, S16 0.3675, S17 0.3675, S18 0.3675, S19 0.3675, S2 0.3673, S20 0.3675, S21 0.3675, S22 0.3675, S23 0.3676, S24 0.3666, S25 0.3651, S26 0.4040, S27 0.3649, S28 0.3657, S29 0.3657, S3 0.3675, S30 0.3657, S31 0.3657, S32 0.3657, S33 0.3657, S34 0.3657, S35 0.3657, S36 0.3657, S37 0.3657, S38 0.3657, S39 0.3657, S4 0.3675, S40 0.3657, S41 0.3657, S42 0.3657, S43 0.3657, S44 0.3657, S45 0.3657, S46 0.3657, S47 0.3657, S48 0.3657, S49 0.3654, S5 0.3675, S50 0.3642, S6 0.3675, S7 0.3675, S8 0.3675, S9 0.3675, VDD 4.7539, VSS_0 7.0827, VSS_1 2.6060

.subckt RO51 S0 S1 S10 S11 S12 S13 S14 S15 S16 S17 S18 S19 S2 S20 S21 S22 S23 S24 S25 S26 S27 S28 S29 S3 S30 S31 S32 S33 S34 S35 S36 S37 S38 S39 S4 S40 S41 S42 S43 S44 S45 S46 S47 S48 S49 S5 S50 S6 S7 S8 S9 VDD VSS_0 VSS_1
N1 S1_6 S0_4 VSS_0 VSS_0 nmos_rvt l=20n nfin=3
N2 S2_6 S1_4 VSS_0 VSS_0 nmos_rvt l=20n nfin=3
N3 S3_6 S2_4 VSS_0 VSS_0 nmos_rvt l=20n nfin=3
N4 S4_6 S3_4 VSS_0 VSS_0 nmos_rvt l=20n nfin=3
N5 S5_6 S4_4 VSS_0 VSS_0 nmos_rvt l=20n nfin=3
N6 S6_6 S5_4 VSS_0 VSS_0 nmos_rvt l=20n nfin=3
N7 S7_6 S6_4 VSS_0 VSS_0 nmos_rvt l=20n nfin=3
N8 S8_6 S7_4 VSS_0 VSS_0 nmos_rvt l=20n nfin=3
N9 S9_6 S8_4 VSS_0 VSS_0 nmos_rvt l=20n nfin=3
N10 S10_6 S9_4 VSS_0 VSS_0 nmos_rvt l=20n nfin=3
N11 S11_6 S10_4 VSS_0 VSS_0 nmos_rvt l=20n nfin=3
N12 S12_6 S11_4 VSS_0 VSS_0 nmos_rvt l=20n nfin=3
N13 S13_6 S12_4 VSS_0 VSS_0 nmos_rvt l=20n nfin=3
N14 S14_6 S13_4 VSS_0 VSS_0 nmos_rvt l=20n nfin=3
N15 S15_6 S14_4 VSS_0 VSS_0 nmos_rvt l=20n nfin=3
N16 S16_6 S15_4 VSS_0 VSS_0 nmos_rvt l=20n nfin=3
N17 S17_6 S16_4 VSS_0 VSS_0 nmos_rvt l=20n nfin=3
N18 S18_6 S17_4 VSS_0 VSS_0 nmos_rvt l=20n nfin=3
N19 S19_6 S18_4 VSS_0 VSS_0 nmos_rvt l=20n nfin=3
N20 S20_6 S19_4 VSS_0 VSS_0 nmos_rvt l=20n nfin=3
N21 S21_6 S20_4 VSS_0 VSS_0 nmos_rvt l=20n nfin=3
N22 S22_6 S21_4 VSS_0 VSS_0 nmos_rvt l=20n nfin=3
N23 S23_6 S22_4 VSS_0 VSS_0 nmos_rvt l=20n nfin=3
N24 S24_6 S23_4 VSS_0 VSS_0 nmos_rvt l=20n nfin=3
N25 S25_6 S24_4 VSS_0 VSS_0 nmos_rvt l=20n nfin=3
N26 S26_6 S25_4 VSS_0 VSS_0 nmos_rvt l=20n nfin=3
N27 VSS_1 S50_4 S0_7 VSS_0 nmos_rvt l=20n nfin=3
N28 VSS_1 S49_4 S50_7 VSS_0 nmos_rvt l=20n nfin=3
N29 VSS_1 S48_4 S49_7 VSS_0 nmos_rvt l=20n nfin=3
N30 VSS_1 S47_4 S48_7 VSS_0 nmos_rvt l=20n nfin=3
N31 VSS_1 S46_4 S47_7 VSS_0 nmos_rvt l=20n nfin=3
N32 VSS_1 S45_4 S46_7 VSS_0 nmos_rvt l=20n nfin=3
N33 VSS_1 S44_4 S45_7 VSS_0 nmos_rvt l=20n nfin=3
N34 VSS_1 S43_4 S44_7 VSS_0 nmos_rvt l=20n nfin=3
N35 VSS_1 S42_4 S43_7 VSS_0 nmos_rvt l=20n nfin=3
N36 VSS_1 S41_4 S42_7 VSS_0 nmos_rvt l=20n nfin=3
N37 VSS_1 S40_4 S41_7 VSS_0 nmos_rvt l=20n nfin=3
N38 VSS_1 S39_4 S40_7 VSS_0 nmos_rvt l=20n nfin=3
N39 VSS_1 S38_4 S39_7 VSS_0 nmos_rvt l=20n nfin=3
N40 VSS_1 S37_4 S38_7 VSS_0 nmos_rvt l=20n nfin=3
N41 VSS_1 S36_4 S37_7 VSS_0 nmos_rvt l=20n nfin=3
N42 VSS_1 S35_4 S36_7 VSS_0 nmos_rvt l=20n nfin=3
N43 VSS_1 S34_4 S35_7 VSS_0 nmos_rvt l=20n nfin=3
N44 VSS_1 S33_4 S34_7 VSS_0 nmos_rvt l=20n nfin=3
N45 VSS_1 S32_4 S33_7 VSS_0 nmos_rvt l=20n nfin=3
N46 VSS_1 S31_4 S32_7 VSS_0 nmos_rvt l=20n nfin=3
N47 VSS_1 S30_4 S31_7 VSS_0 nmos_rvt l=20n nfin=3
N48 VSS_1 S29_4 S30_7 VSS_0 nmos_rvt l=20n nfin=3
N49 VSS_1 S28_4 S29_7 VSS_0 nmos_rvt l=20n nfin=3
N50 VSS_1 S27_4 S28_7 VSS_0 nmos_rvt l=20n nfin=3
N51 VSS_1 S26_4 S27_7 VSS_0 nmos_rvt l=20n nfin=3
N52 S1_7 S0_5 VDD VDD pmos_rvt l=20n nfin=3
N53 S2_7 S1_5 VDD VDD pmos_rvt l=20n nfin=3
N54 S3_7 S2_5 VDD VDD pmos_rvt l=20n nfin=3
N55 S4_7 S3_5 VDD VDD pmos_rvt l=20n nfin=3
N56 S5_7 S4_5 VDD VDD pmos_rvt l=20n nfin=3
N57 S6_7 S5_5 VDD VDD pmos_rvt l=20n nfin=3
N58 S7_7 S6_5 VDD VDD pmos_rvt l=20n nfin=3
N59 S8_7 S7_5 VDD VDD pmos_rvt l=20n nfin=3
N60 S9_7 S8_5 VDD VDD pmos_rvt l=20n nfin=3
N61 S10_7 S9_5 VDD VDD pmos_rvt l=20n nfin=3
N62 S11_7 S10_5 VDD VDD pmos_rvt l=20n nfin=3
N63 S12_7 S11_5 VDD VDD pmos_rvt l=20n nfin=3
N64 S13_7 S12_5 VDD VDD pmos_rvt l=20n nfin=3
N65 S14_7 S13_5 VDD VDD pmos_rvt l=20n nfin=3
N66 S15_7 S14_5 VDD VDD pmos_rvt l=20n nfin=3
N67 S16_7 S15_5 VDD VDD pmos_rvt l=20n nfin=3
N68 S17_7 S16_5 VDD VDD pmos_rvt l=20n nfin=3
N69 S18_7 S17_5 VDD VDD pmos_rvt l=20n nfin=3
N70 S19_7 S18_5 VDD VDD pmos_rvt l=20n nfin=3
N71 S20_7 S19_5 VDD VDD pmos_rvt l=20n nfin=3
N72 S21_7 S20_5 VDD VDD pmos_rvt l=20n nfin=3
N73 S22_7 S21_5 VDD VDD pmos_rvt l=20n nfin=3
N74 S23_7 S22_5 VDD VDD pmos_rvt l=20n nfin=3
N75 S24_7 S23_5 VDD VDD pmos_rvt l=20n nfin=3
N76 S25_7 S24_5 VDD VDD pmos_rvt l=20n nfin=3
N77 S26_7 S25_5 VDD VDD pmos_rvt l=20n nfin=3
N78 VDD S50_5 S0_6 VDD pmos_rvt l=20n nfin=3
N79 VDD S49_5 S50_6 VDD pmos_rvt l=20n nfin=3
N80 VDD S48_5 S49_6 VDD pmos_rvt l=20n nfin=3
N81 VDD S47_5 S48_6 VDD pmos_rvt l=20n nfin=3
N82 VDD S46_5 S47_6 VDD pmos_rvt l=20n nfin=3
N83 VDD S45_5 S46_6 VDD pmos_rvt l=20n nfin=3
N84 VDD S44_5 S45_6 VDD pmos_rvt l=20n nfin=3
N85 VDD S43_5 S44_6 VDD pmos_rvt l=20n nfin=3
N86 VDD S42_5 S43_6 VDD pmos_rvt l=20n nfin=3
N87 VDD S41_5 S42_6 VDD pmos_rvt l=20n nfin=3
N88 VDD S40_5 S41_6 VDD pmos_rvt l=20n nfin=3
N89 VDD S39_5 S40_6 VDD pmos_rvt l=20n nfin=3
N90 VDD S38_5 S39_6 VDD pmos_rvt l=20n nfin=3
N91 VDD S37_5 S38_6 VDD pmos_rvt l=20n nfin=3
N92 VDD S36_5 S37_6 VDD pmos_rvt l=20n nfin=3
N93 VDD S35_5 S36_6 VDD pmos_rvt l=20n nfin=3
N94 VDD S34_5 S35_6 VDD pmos_rvt l=20n nfin=3
N95 VDD S33_5 S34_6 VDD pmos_rvt l=20n nfin=3
N96 VDD S32_5 S33_6 VDD pmos_rvt l=20n nfin=3
N97 VDD S31_5 S32_6 VDD pmos_rvt l=20n nfin=3
N98 VDD S30_5 S31_6 VDD pmos_rvt l=20n nfin=3
N99 VDD S29_5 S30_6 VDD pmos_rvt l=20n nfin=3
N100 VDD S28_5 S29_6 VDD pmos_rvt l=20n nfin=3
N101 VDD S27_5 S28_6 VDD pmos_rvt l=20n nfin=3
N102 VDD S26_5 S27_6 VDD pmos_rvt l=20n nfin=3
R1 S1_5 S1_1 22.9598
R2 S1_1 S1_4 22.9598
R3 S1 S1_3 15.1551
R4 S1_6 S1_2 63.5313
R5 S1_7 S1_2 63.5313
R6 S1_1 S1_3 40.8794
R7 S1_3 S1_2 51.6604
R8 S2_5 S2_1 22.9598
R9 S2_1 S2_4 22.9598
R10 S2 S2_3 15.1551
R11 S2_6 S2_2 63.5313
R12 S2_7 S2_2 63.5313
R13 S2_1 S2_3 40.8794
R14 S2_3 S2_2 51.6604
R15 S3_5 S3_1 22.9598
R16 S3_1 S3_4 22.9598
R17 S3 S3_3 15.1551
R18 S3_6 S3_2 63.5313
R19 S3_7 S3_2 63.5313
R20 S3_1 S3_3 40.8794
R21 S3_3 S3_2 51.6604
R22 S4_5 S4_1 22.9598
R23 S4_1 S4_4 22.9598
R24 S4 S4_3 15.1551
R25 S4_6 S4_2 63.5313
R26 S4_7 S4_2 63.5313
R27 S4_1 S4_3 40.8794
R28 S4_3 S4_2 51.6604
R29 S5_5 S5_1 22.9598
R30 S5_1 S5_4 22.9598
R31 S5 S5_3 15.1551
R32 S5_6 S5_2 63.5313
R33 S5_7 S5_2 63.5313
R34 S5_1 S5_3 40.8794
R35 S5_3 S5_2 51.6604
R36 S6_5 S6_1 22.9598
R37 S6_1 S6_4 22.9598
R38 S6 S6_3 15.1551
R39 S6_6 S6_2 63.5313
R40 S6_7 S6_2 63.5313
R41 S6_1 S6_3 40.8794
R42 S6_3 S6_2 51.6604
R43 S7_5 S7_1 22.9598
R44 S7_1 S7_4 22.9598
R45 S7 S7_3 15.1551
R46 S7_6 S7_2 63.5313
R47 S7_7 S7_2 63.5313
R48 S7_1 S7_3 40.8794
R49 S7_3 S7_2 51.6604
R50 S8_5 S8_1 22.9598
R51 S8_1 S8_4 22.9598
R52 S8 S8_3 15.1551
R53 S8_6 S8_2 63.5313
R54 S8_7 S8_2 63.5313
R55 S8_1 S8_3 40.8794
R56 S8_3 S8_2 51.6604
R57 S9_5 S9_1 22.9598
R58 S9_1 S9_4 22.9598
R59 S9 S9_3 15.1551
R60 S9_6 S9_2 63.5313
R61 S9_7 S9_2 63.5313
R62 S9_1 S9_3 40.8794
R63 S9_3 S9_2 51.6604
R64 S10_5 S10_1 22.9598
R65 S10_1 S10_4 22.9598
R66 S10 S10_3 15.1551
R67 S10_6 S10_2 63.5313
R68 S10_7 S10_2 63.5313
R69 S10_1 S10_3 40.8794
R70 S10_3 S10_2 51.6604
R71 S11_5 S11_1 22.9598
R72 S11_1 S11_4 22.9598
R73 S11 S11_3 15.1551
R74 S11_6 S11_2 63.5313
R75 S11_7 S11_2 63.5313
R76 S11_1 S11_3 40.8794
R77 S11_3 S11_2 51.6604
R78 S12_5 S12_1 22.9598
R79 S12_1 S12_4 22.9598
R80 S12 S12_3 15.1551
R81 S12_6 S12_2 63.5313
R82 S12_7 S12_2 63.5313
R83 S12_1 S12_3 40.8794
R84 S12_3 S12_2 51.6604
R85 S13_5 S13_1 22.9598
R86 S13_1 S13_4 22.9598
R87 S13 S13_3 15.1551
R88 S13_6 S13_2 63.5313
R89 S13_7 S13_2 63.5313
R90 S13_1 S13_3 40.8794
R91 S13_3 S13_2 51.6604
R92 S14_5 S14_1 22.9598
R93 S14_1 S14_4 22.9598
R94 S14 S14_3 15.1551
R95 S14_6 S14_2 63.5313
R96 S14_7 S14_2 63.5313
R97 S14_1 S14_3 40.8794
R98 S14_3 S14_2 51.6604
R99 S15_5 S15_1 22.9598
R100 S15_1 S15_4 22.9598
R101 S15 S15_3 15.1551
R102 S15_6 S15_2 63.5313
R103 S15_7 S15_2 63.5313
R104 S15_1 S15_3 40.8794
R105 S15_3 S15_2 51.6604
R106 S16_5 S16_1 22.9598
R107 S16_1 S16_4 22.9598
R108 S16 S16_3 15.1551
R109 S16_6 S16_2 63.5313
R110 S16_7 S16_2 63.5313
R111 S16_1 S16_3 40.8794
R112 S16_3 S16_2 51.6604
R113 S17_5 S17_1 22.9598
R114 S17_1 S17_4 22.9598
R115 S17 S17_3 15.1551
R116 S17_6 S17_2 63.5313
R117 S17_7 S17_2 63.5313
R118 S17_1 S17_3 40.8794
R119 S17_3 S17_2 51.6604
R120 S18_5 S18_1 22.9598
R121 S18_1 S18_4 22.9598
R122 S18 S18_3 15.1551
R123 S18_6 S18_2 63.5313
R124 S18_7 S18_2 63.5313
R125 S18_1 S18_3 40.8794
R126 S18_3 S18_2 51.6604
R127 S19_5 S19_1 22.9598
R128 S19_1 S19_4 22.9598
R129 S19 S19_3 15.1551
R130 S19_6 S19_2 63.5313
R131 S19_7 S19_2 63.5313
R132 S19_1 S19_3 40.8794
R133 S19_3 S19_2 51.6604
R134 S20_5 S20_1 22.9598
R135 S20_1 S20_4 22.9598
R136 S20 S20_3 15.1551
R137 S20_6 S20_2 63.5313
R138 S20_7 S20_2 63.5313
R139 S20_1 S20_3 40.8794
R140 S20_3 S20_2 51.6604
R141 S21_5 S21_1 22.9598
R142 S21_1 S21_4 22.9598
R143 S21 S21_3 15.1551
R144 S21_6 S21_2 63.5313
R145 S21_7 S21_2 63.5313
R146 S21_1 S21_3 40.8794
R147 S21_3 S21_2 51.6604
R148 S22_5 S22_1 22.9598
R149 S22_1 S22_4 22.9598
R150 S22 S22_3 15.1551
R151 S22_6 S22_2 63.5313
R152 S22_7 S22_2 63.5313
R153 S22_1 S22_3 40.8794
R154 S22_3 S22_2 51.6604
R155 S23_5 S23_1 22.9598
R156 S23_1 S23_4 22.9598
R157 S23 S23_3 15.1551
R158 S23_6 S23_2 63.5313
R159 S23_7 S23_2 63.5313
R160 S23_1 S23_3 40.8794
R161 S23_3 S23_2 51.6604
R162 S24_5 S24_1 22.9598
R163 S24_1 S24_4 22.9598
R164 S24 S24_3 15.1551
R165 S24_6 S24_2 63.5313
R166 S24_7 S24_2 63.5313
R167 S24_1 S24_3 40.8794
R168 S24_3 S24_2 51.6604
R169 S25_5 S25_1 22.9598
R170 S25_1 S25_4 22.9598
R171 S25 S25_3 15.1551
R172 S25_6 S25_2 63.5313
R173 S25_7 S25_2 63.5313
R174 S25_1 S25_3 40.8794
R175 S25_3 S25_2 51.6604
R176 S26_4 S26_1 22.9598
R177 S26_1 S26_5 22.9598
R178 S26_3 S26 15.1551
R179 S26_6 S26_2 63.5313
R180 S26_7 S26_2 63.5313
R181 S26_1 S26_3 40.8794
R182 S26_2 S26_3 219.432
R183 S0_5 S0_1 22.9598
R184 S0_1 S0_4 22.9598
R185 S0 S0_2 15.1551
R186 S0_6 S0_3 63.5313
R187 S0_7 S0_3 63.5313
R188 S0_1 S0_2 40.8794
R189 S0_2 S0_3 181.661
R190 S50_4 S50_1 22.9598
R191 S50_1 S50_5 22.9598
R192 S50_2 S50 15.1551
R193 S50_6 S50_3 63.5313
R194 S50_7 S50_3 63.5313
R195 S50_1 S50_2 40.8794
R196 S50_3 S50_2 51.6604
R197 S49_4 S49_1 22.9598
R198 S49_1 S49_5 22.9598
R199 S49_2 S49 15.1551
R200 S49_6 S49_3 63.5313
R201 S49_7 S49_3 63.5313
R202 S49_1 S49_2 40.8794
R203 S49_3 S49_2 51.6604
R204 S48_4 S48_1 22.9598
R205 S48_1 S48_5 22.9598
R206 S48_2 S48 15.1551
R207 S48_6 S48_3 63.5313
R208 S48_7 S48_3 63.5313
R209 S48_1 S48_2 40.8794
R210 S48_3 S48_2 51.6604
R211 S47_4 S47_1 22.9598
R212 S47_1 S47_5 22.9598
R213 S47_2 S47 15.1551
R214 S47_6 S47_3 63.5313
R215 S47_7 S47_3 63.5313
R216 S47_1 S47_2 40.8794
R217 S47_3 S47_2 51.6604
R218 S46_4 S46_1 22.9598
R219 S46_1 S46_5 22.9598
R220 S46_2 S46 15.1551
R221 S46_6 S46_3 63.5313
R222 S46_7 S46_3 63.5313
R223 S46_1 S46_2 40.8794
R224 S46_3 S46_2 51.6604
R225 S45_4 S45_1 22.9598
R226 S45_1 S45_5 22.9598
R227 S45_2 S45 15.1551
R228 S45_6 S45_3 63.5313
R229 S45_7 S45_3 63.5313
R230 S45_1 S45_2 40.8794
R231 S45_3 S45_2 51.6604
R232 S44_4 S44_1 22.9598
R233 S44_1 S44_5 22.9598
R234 S44_2 S44 15.1551
R235 S44_6 S44_3 63.5313
R236 S44_7 S44_3 63.5313
R237 S44_1 S44_2 40.8794
R238 S44_3 S44_2 51.6604
R239 S43_4 S43_1 22.9598
R240 S43_1 S43_5 22.9598
R241 S43_2 S43 15.1551
R242 S43_6 S43_3 63.5313
R243 S43_7 S43_3 63.5313
R244 S43_1 S43_2 40.8794
R245 S43_3 S43_2 51.6604
R246 S42_4 S42_1 22.9598
R247 S42_1 S42_5 22.9598
R248 S42_2 S42 15.1551
R249 S42_6 S42_3 63.5313
R250 S42_7 S42_3 63.5313
R251 S42_1 S42_2 40.8794
R252 S42_3 S42_2 51.6604
R253 S41_4 S41_1 22.9598
R254 S41_1 S41_5 22.9598
R255 S41_2 S41 15.1551
R256 S41_6 S41_3 63.5313
R257 S41_7 S41_3 63.5313
R258 S41_1 S41_2 40.8794
R259 S41_3 S41_2 51.6604
R260 S40_4 S40_1 22.9598
R261 S40_1 S40_5 22.9598
R262 S40_2 S40 15.1551
R263 S40_6 S40_3 63.5313
R264 S40_7 S40_3 63.5313
R265 S40_1 S40_2 40.8794
R266 S40_3 S40_2 51.6604
R267 S39_4 S39_1 22.9598
R268 S39_1 S39_5 22.9598
R269 S39_2 S39 15.1551
R270 S39_6 S39_3 63.5313
R271 S39_7 S39_3 63.5313
R272 S39_1 S39_2 40.8794
R273 S39_3 S39_2 51.6604
R274 S38_4 S38_1 22.9598
R275 S38_1 S38_5 22.9598
R276 S38_2 S38 15.1551
R277 S38_6 S38_3 63.5313
R278 S38_7 S38_3 63.5313
R279 S38_1 S38_2 40.8794
R280 S38_3 S38_2 51.6604
R281 S37_4 S37_1 22.9598
R282 S37_1 S37_5 22.9598
R283 S37_2 S37 15.1551
R284 S37_6 S37_3 63.5313
R285 S37_7 S37_3 63.5313
R286 S37_1 S37_2 40.8794
R287 S37_3 S37_2 51.6604
R288 S36_4 S36_1 22.9598
R289 S36_1 S36_5 22.9598
R290 S36_2 S36 15.1551
R291 S36_6 S36_3 63.5313
R292 S36_7 S36_3 63.5313
R293 S36_1 S36_2 40.8794
R294 S36_3 S36_2 51.6604
R295 S35_4 S35_1 22.9598
R296 S35_1 S35_5 22.9598
R297 S35_2 S35 15.1551
R298 S35_6 S35_3 63.5313
R299 S35_7 S35_3 63.5313
R300 S35_1 S35_2 40.8794
R301 S35_3 S35_2 51.6604
R302 S34_4 S34_1 22.9598
R303 S34_1 S34_5 22.9598
R304 S34_2 S34 15.1551
R305 S34_6 S34_3 63.5313
R306 S34_7 S34_3 63.5313
R307 S34_1 S34_2 40.8794
R308 S34_3 S34_2 51.6604
R309 S33_4 S33_1 22.9598
R310 S33_1 S33_5 22.9598
R311 S33_2 S33 15.1551
R312 S33_6 S33_3 63.5313
R313 S33_7 S33_3 63.5313
R314 S33_1 S33_2 40.8794
R315 S33_3 S33_2 51.6604
R316 S32_4 S32_1 22.9598
R317 S32_1 S32_5 22.9598
R318 S32_2 S32 15.1551
R319 S32_6 S32_3 63.5313
R320 S32_7 S32_3 63.5313
R321 S32_1 S32_2 40.8794
R322 S32_3 S32_2 51.6604
R323 S31_4 S31_1 22.9598
R324 S31_1 S31_5 22.9598
R325 S31_2 S31 15.1551
R326 S31_6 S31_3 63.5313
R327 S31_7 S31_3 63.5313
R328 S31_1 S31_2 40.8794
R329 S31_3 S31_2 51.6604
R330 S30_4 S30_1 22.9598
R331 S30_1 S30_5 22.9598
R332 S30_2 S30 15.1551
R333 S30_6 S30_3 63.5313
R334 S30_7 S30_3 63.5313
R335 S30_1 S30_2 40.8794
R336 S30_3 S30_2 51.6604
R337 S29_4 S29_1 22.9598
R338 S29_1 S29_5 22.9598
R339 S29_2 S29 15.1551
R340 S29_6 S29_3 63.5313
R341 S29_7 S29_3 63.5313
R342 S29_1 S29_2 40.8794
R343 S29_3 S29_2 51.6604
R344 S28_4 S28_1 22.9598
R345 S28_1 S28_5 22.9598
R346 S28_2 S28 15.1551
R347 S28_6 S28_3 63.5313
R348 S28_7 S28_3 63.5313
R349 S28_1 S28_2 40.8794
R350 S28_3 S28_2 51.6604
R351 S27_4 S27_1 22.9598
R352 S27_1 S27_5 22.9598
R353 S27_2 S27 15.1551
R354 S27_6 S27_3 63.5313
R355 S27_7 S27_3 63.5313
R356 S27_1 S27_2 40.8794
R357 S27_3 S27_2 51.6604
C1 S0 S1_7 0.0145202f
C2 S0 S50_5 0.000115118f
C3 S0 VDD 0.00834367f
C4 S0 VSS_0 0.0214567f
C5 S0_1 S1 6.54064e-05f
C6 S0_1 S1_1 3.71163e-05f
C7 S0_1 S1_2 0.0081923f
C8 S0_1 S1_3 9.64982e-05f
C9 S0_1 S1_4 3.80853e-05f
C10 S0_1 S1_5 3.80853e-05f
C11 S0_1 S50_5 6.49497e-05f
C12 S0_1 VDD 0.00470751f
C13 S0_1 VSS_0 0.0124243f
C14 S0_2 S1_6 0.0310908f
C15 S0_2 S50_5 0.000246492f
C16 S0_2 VDD 0.0178656f
C17 S0_2 VSS_0 0.0459433f
C18 S0_3 S1_7 0.00014782f
C19 S0_3 S50_1 0.00931445f
C20 S0_3 VDD 0.0111058f
C21 S0_3 VSS_0 0.0325501f
C22 S0_3 VSS_1 0.00912759f
C23 S0_4 S1_6 0.00840618f
C24 S0_4 S50_5 6.66453e-05f
C25 S0_4 VDD 0.00483041f
C26 S0_4 VSS_0 0.0124219f
C27 S0_5 S1_7 0.00840618f
C28 S0_5 S50_5 6.66453e-05f
C29 S0_5 VDD 0.00483041f
C30 S0_5 VSS_0 0.0124219f
C31 S0_6 S1_7 8.18234e-05f
C32 S0_6 S50 0.0164139f
C33 S0_6 S50_2 0.0242165f
C34 S0_6 S50_5 0.00955762f
C35 S0_6 VDD 0.00614747f
C36 S0_6 VSS_0 0.0186693f
C37 S0_6 VSS_1 0.00505244f
C38 S0_7 S1_7 6.70721e-05f
C39 S0_7 S50_4 0.00955762f
C40 S0_7 VDD 0.00503919f
C41 S0_7 VSS_0 0.0147693f
C42 S0_7 VSS_1 0.00414157f
C43 S1 S2_7 0.0165118f
C44 S1 VDD 0.00968934f
C45 S1 VSS_0 0.0222204f
C46 S10 S11_7 0.0165468f
C47 S10 S9_1 6.99956e-05f
C48 S10 VDD 0.00967979f
C49 S10 VSS_0 0.0222327f
C50 S10_1 S11 6.99956e-05f
C51 S10_1 S11_1 3.97205e-05f
C52 S10_1 S11_2 0.00938983f
C53 S10_1 S11_3 0.000103269f
C54 S10_1 S11_4 4.07575e-05f
C55 S10_1 S11_5 4.07575e-05f
C56 S10_1 S9_1 3.97205e-05f
C57 S10_1 VDD 0.00549301f
C58 S10_1 VSS_0 0.0129779f
C59 S10_2 S9_1 0.00938983f
C60 S10_2 VDD 0.00417817f
C61 S10_2 VSS_0 0.0239823f
C62 S10_3 S11_6 0.0244125f
C63 S10_3 S9_1 0.000103269f
C64 S10_3 VDD 0.0142812f
C65 S10_3 VSS_0 0.0328013f
C66 S10_4 S11_6 0.00963497f
C67 S10_4 S9_1 4.07575e-05f
C68 S10_4 VDD 0.00563641f
C69 S10_4 VSS_0 0.0129458f
C70 S10_5 S11_7 0.00963497f
C71 S10_5 S9_1 4.07575e-05f
C72 S10_5 VDD 0.00935869f
C73 S10_5 VSS_0 0.0138227f
C74 S10_6 S9_3 0.0244125f
C75 S10_6 S9_4 0.00963497f
C76 S10_6 VDD 0.00412618f
C77 S10_6 VSS_0 0.0243207f
C78 S10_7 S9 0.0165468f
C79 S10_7 S9_5 0.00963497f
C80 S10_7 VDD 0.010512f
C81 S10_7 VSS_0 0.0243058f
C82 S11 S12_7 0.0165468f
C83 S11 VDD 0.00967979f
C84 S11 VSS_0 0.0222327f
C85 S11_1 S12 6.99956e-05f
C86 S11_1 S12_1 3.97205e-05f
C87 S11_1 S12_2 0.00938983f
C88 S11_1 S12_3 0.000103269f
C89 S11_1 S12_4 4.07575e-05f
C90 S11_1 S12_5 4.07575e-05f
C91 S11_1 VDD 0.00549301f
C92 S11_1 VSS_0 0.0129779f
C93 S11_2 VDD 0.00417817f
C94 S11_2 VSS_0 0.0239823f
C95 S11_3 S12_6 0.0244125f
C96 S11_3 VDD 0.0142812f
C97 S11_3 VSS_0 0.0328013f
C98 S11_4 S12_6 0.00963497f
C99 S11_4 VDD 0.00563641f
C100 S11_4 VSS_0 0.0129458f
C101 S11_5 S12_7 0.00963497f
C102 S11_5 VDD 0.00935869f
C103 S11_5 VSS_0 0.0138227f
C104 S11_6 VDD 0.00412618f
C105 S11_6 VSS_0 0.0243207f
C106 S11_7 VDD 0.010512f
C107 S11_7 VSS_0 0.0243058f
C108 S12 S13_7 0.0165468f
C109 S12 VDD 0.00967979f
C110 S12 VSS_0 0.0222327f
C111 S12_1 S13 6.99956e-05f
C112 S12_1 S13_1 3.97205e-05f
C113 S12_1 S13_2 0.00938983f
C114 S12_1 S13_3 0.000103269f
C115 S12_1 S13_4 4.07575e-05f
C116 S12_1 S13_5 4.07575e-05f
C117 S12_1 VDD 0.00549301f
C118 S12_1 VSS_0 0.0129779f
C119 S12_2 VDD 0.00417817f
C120 S12_2 VSS_0 0.0239823f
C121 S12_3 S13_6 0.0244125f
C122 S12_3 VDD 0.0142812f
C123 S12_3 VSS_0 0.0328013f
C124 S12_4 S13_6 0.00963497f
C125 S12_4 VDD 0.00563641f
C126 S12_4 VSS_0 0.0129458f
C127 S12_5 S13_7 0.00963497f
C128 S12_5 VDD 0.00935869f
C129 S12_5 VSS_0 0.0138227f
C130 S12_6 VDD 0.00412618f
C131 S12_6 VSS_0 0.0243207f
C132 S12_7 VDD 0.010512f
C133 S12_7 VSS_0 0.0243058f
C134 S13 S14_7 0.0165468f
C135 S13 VDD 0.00967979f
C136 S13 VSS_0 0.0222327f
C137 S13_1 S14 6.99956e-05f
C138 S13_1 S14_1 3.97205e-05f
C139 S13_1 S14_2 0.00938983f
C140 S13_1 S14_3 0.000103269f
C141 S13_1 S14_4 4.07575e-05f
C142 S13_1 S14_5 4.07575e-05f
C143 S13_1 VDD 0.00549301f
C144 S13_1 VSS_0 0.0129779f
C145 S13_2 VDD 0.00417817f
C146 S13_2 VSS_0 0.0239823f
C147 S13_3 S14_6 0.0244125f
C148 S13_3 VDD 0.0142812f
C149 S13_3 VSS_0 0.0328013f
C150 S13_4 S14_6 0.00963497f
C151 S13_4 VDD 0.00563641f
C152 S13_4 VSS_0 0.0129458f
C153 S13_5 S14_7 0.00963497f
C154 S13_5 VDD 0.00935869f
C155 S13_5 VSS_0 0.0138227f
C156 S13_6 VDD 0.00412618f
C157 S13_6 VSS_0 0.0243207f
C158 S13_7 VDD 0.010512f
C159 S13_7 VSS_0 0.0243058f
C160 S14 S15_7 0.0165468f
C161 S14 VDD 0.00967979f
C162 S14 VSS_0 0.0222327f
C163 S14_1 S15 6.99956e-05f
C164 S14_1 S15_1 3.97205e-05f
C165 S14_1 S15_2 0.00938983f
C166 S14_1 S15_3 0.000103269f
C167 S14_1 S15_4 4.07575e-05f
C168 S14_1 S15_5 4.07575e-05f
C169 S14_1 VDD 0.00549301f
C170 S14_1 VSS_0 0.0129779f
C171 S14_2 VDD 0.00417817f
C172 S14_2 VSS_0 0.0239823f
C173 S14_3 S15_6 0.0244125f
C174 S14_3 VDD 0.0142812f
C175 S14_3 VSS_0 0.0328013f
C176 S14_4 S15_6 0.00963497f
C177 S14_4 VDD 0.00563641f
C178 S14_4 VSS_0 0.0129458f
C179 S14_5 S15_7 0.00963497f
C180 S14_5 VDD 0.00935869f
C181 S14_5 VSS_0 0.0138227f
C182 S14_6 VDD 0.00412618f
C183 S14_6 VSS_0 0.0243207f
C184 S14_7 VDD 0.010512f
C185 S14_7 VSS_0 0.0243058f
C186 S15 S16_7 0.0165468f
C187 S15 VDD 0.00967979f
C188 S15 VSS_0 0.0222327f
C189 S15_1 S16 6.99956e-05f
C190 S15_1 S16_1 3.97205e-05f
C191 S15_1 S16_2 0.00938983f
C192 S15_1 S16_3 0.000103269f
C193 S15_1 S16_4 4.07575e-05f
C194 S15_1 S16_5 4.07575e-05f
C195 S15_1 VDD 0.00549301f
C196 S15_1 VSS_0 0.0129779f
C197 S15_2 VDD 0.00417817f
C198 S15_2 VSS_0 0.0239823f
C199 S15_3 S16_6 0.0244125f
C200 S15_3 VDD 0.0142812f
C201 S15_3 VSS_0 0.0328013f
C202 S15_4 S16_6 0.00963497f
C203 S15_4 VDD 0.00563641f
C204 S15_4 VSS_0 0.0129458f
C205 S15_5 S16_7 0.00963497f
C206 S15_5 VDD 0.00935869f
C207 S15_5 VSS_0 0.0138227f
C208 S15_6 VDD 0.00412618f
C209 S15_6 VSS_0 0.0243207f
C210 S15_7 VDD 0.010512f
C211 S15_7 VSS_0 0.0243058f
C212 S16 S17_7 0.0165468f
C213 S16 VDD 0.00967979f
C214 S16 VSS_0 0.0222327f
C215 S16_1 S17 6.99956e-05f
C216 S16_1 S17_1 3.97205e-05f
C217 S16_1 S17_2 0.00938983f
C218 S16_1 S17_3 0.000103269f
C219 S16_1 S17_4 4.07575e-05f
C220 S16_1 S17_5 4.07575e-05f
C221 S16_1 VDD 0.00549301f
C222 S16_1 VSS_0 0.0129779f
C223 S16_2 VDD 0.00417817f
C224 S16_2 VSS_0 0.0239823f
C225 S16_3 S17_6 0.0244125f
C226 S16_3 VDD 0.0142812f
C227 S16_3 VSS_0 0.0328013f
C228 S16_4 S17_6 0.00963497f
C229 S16_4 VDD 0.00563641f
C230 S16_4 VSS_0 0.0129458f
C231 S16_5 S17_7 0.00963497f
C232 S16_5 VDD 0.00935869f
C233 S16_5 VSS_0 0.0138227f
C234 S16_6 VDD 0.00412618f
C235 S16_6 VSS_0 0.0243207f
C236 S16_7 VDD 0.010512f
C237 S16_7 VSS_0 0.0243058f
C238 S17 S18_7 0.0165468f
C239 S17 VDD 0.00967979f
C240 S17 VSS_0 0.0222327f
C241 S17_1 S18 6.99956e-05f
C242 S17_1 S18_1 3.97205e-05f
C243 S17_1 S18_2 0.00938983f
C244 S17_1 S18_3 0.000103269f
C245 S17_1 S18_4 4.07575e-05f
C246 S17_1 S18_5 4.07575e-05f
C247 S17_1 VDD 0.00549301f
C248 S17_1 VSS_0 0.0129779f
C249 S17_2 VDD 0.00417817f
C250 S17_2 VSS_0 0.0239823f
C251 S17_3 S18_6 0.0244125f
C252 S17_3 VDD 0.0142812f
C253 S17_3 VSS_0 0.0328013f
C254 S17_4 S18_6 0.00963497f
C255 S17_4 VDD 0.00563641f
C256 S17_4 VSS_0 0.0129458f
C257 S17_5 S18_7 0.00963497f
C258 S17_5 VDD 0.00935869f
C259 S17_5 VSS_0 0.0138227f
C260 S17_6 VDD 0.00412618f
C261 S17_6 VSS_0 0.0243207f
C262 S17_7 VDD 0.010512f
C263 S17_7 VSS_0 0.0243058f
C264 S18 S19_7 0.0165468f
C265 S18 VDD 0.00967979f
C266 S18 VSS_0 0.0222327f
C267 S18_1 S19 6.99956e-05f
C268 S18_1 S19_1 3.97205e-05f
C269 S18_1 S19_2 0.00938983f
C270 S18_1 S19_3 0.000103269f
C271 S18_1 S19_4 4.07575e-05f
C272 S18_1 S19_5 4.07575e-05f
C273 S18_1 VDD 0.00549301f
C274 S18_1 VSS_0 0.0129779f
C275 S18_2 VDD 0.00417817f
C276 S18_2 VSS_0 0.0239823f
C277 S18_3 S19_6 0.0244125f
C278 S18_3 VDD 0.0142812f
C279 S18_3 VSS_0 0.0328013f
C280 S18_4 S19_6 0.00963497f
C281 S18_4 VDD 0.00563641f
C282 S18_4 VSS_0 0.0129458f
C283 S18_5 S19_7 0.00963497f
C284 S18_5 VDD 0.00935869f
C285 S18_5 VSS_0 0.0138227f
C286 S18_6 VDD 0.00412618f
C287 S18_6 VSS_0 0.0243207f
C288 S18_7 VDD 0.010512f
C289 S18_7 VSS_0 0.0243058f
C290 S19 S20_7 0.0165468f
C291 S19 VDD 0.00967979f
C292 S19 VSS_0 0.0222327f
C293 S19_1 S20 6.99956e-05f
C294 S19_1 S20_1 3.97205e-05f
C295 S19_1 S20_2 0.00938983f
C296 S19_1 S20_3 0.000103269f
C297 S19_1 S20_4 4.07575e-05f
C298 S19_1 S20_5 4.07575e-05f
C299 S19_1 VDD 0.00549301f
C300 S19_1 VSS_0 0.0129779f
C301 S19_2 VDD 0.00417817f
C302 S19_2 VSS_0 0.0239823f
C303 S19_3 S20_6 0.0244125f
C304 S19_3 VDD 0.0142812f
C305 S19_3 VSS_0 0.0328013f
C306 S19_4 S20_6 0.00963497f
C307 S19_4 VDD 0.00563641f
C308 S19_4 VSS_0 0.0129458f
C309 S19_5 S20_7 0.00963497f
C310 S19_5 VDD 0.00935869f
C311 S19_5 VSS_0 0.0138227f
C312 S19_6 VDD 0.00412618f
C313 S19_6 VSS_0 0.0243207f
C314 S19_7 VDD 0.010512f
C315 S19_7 VSS_0 0.0243058f
C316 S1_1 S2 6.99956e-05f
C317 S1_1 S2_1 3.97205e-05f
C318 S1_1 S2_2 0.00936998f
C319 S1_1 S2_3 0.000103269f
C320 S1_1 S2_4 4.07575e-05f
C321 S1_1 S2_5 4.07575e-05f
C322 S1_1 VDD 0.00549843f
C323 S1_1 VSS_0 0.0129709f
C324 S1_2 VDD 0.00412622f
C325 S1_2 VSS_0 0.0235095f
C326 S1_3 S2_6 0.0243609f
C327 S1_3 VDD 0.0142953f
C328 S1_3 VSS_0 0.0327832f
C329 S1_4 S2_6 0.0096146f
C330 S1_4 VDD 0.00564197f
C331 S1_4 VSS_0 0.0129387f
C332 S1_5 S2_7 0.0096146f
C333 S1_5 VDD 0.00933434f
C334 S1_5 VSS_0 0.0138573f
C335 S1_6 VDD 0.00407487f
C336 S1_6 VSS_0 0.0232169f
C337 S1_7 VDD 0.0101625f
C338 S1_7 VSS_0 0.0234734f
C339 S2 S3_7 0.0165468f
C340 S2 VDD 0.00967979f
C341 S2 VSS_0 0.0222327f
C342 S20 S21_7 0.0165468f
C343 S20 VDD 0.00967979f
C344 S20 VSS_0 0.0222327f
C345 S20_1 S21 6.99956e-05f
C346 S20_1 S21_1 3.97205e-05f
C347 S20_1 S21_2 0.00938983f
C348 S20_1 S21_3 0.000103269f
C349 S20_1 S21_4 4.07575e-05f
C350 S20_1 S21_5 4.07575e-05f
C351 S20_1 VDD 0.00549301f
C352 S20_1 VSS_0 0.0129779f
C353 S20_2 VDD 0.00417817f
C354 S20_2 VSS_0 0.0239823f
C355 S20_3 S21_6 0.0244125f
C356 S20_3 VDD 0.0142812f
C357 S20_3 VSS_0 0.0328013f
C358 S20_4 S21_6 0.00963497f
C359 S20_4 VDD 0.00563641f
C360 S20_4 VSS_0 0.0129458f
C361 S20_5 S21_7 0.00963497f
C362 S20_5 VDD 0.00935869f
C363 S20_5 VSS_0 0.0138227f
C364 S20_6 VDD 0.00412618f
C365 S20_6 VSS_0 0.0243207f
C366 S20_7 VDD 0.010512f
C367 S20_7 VSS_0 0.0243058f
C368 S21 S22_7 0.0165468f
C369 S21 VDD 0.00967979f
C370 S21 VSS_0 0.0222327f
C371 S21_1 S22 6.99956e-05f
C372 S21_1 S22_1 3.97205e-05f
C373 S21_1 S22_2 0.00938983f
C374 S21_1 S22_3 0.000103269f
C375 S21_1 S22_4 4.07575e-05f
C376 S21_1 S22_5 4.07575e-05f
C377 S21_1 VDD 0.00549301f
C378 S21_1 VSS_0 0.0129779f
C379 S21_2 VDD 0.00417817f
C380 S21_2 VSS_0 0.0239823f
C381 S21_3 S22_6 0.0244125f
C382 S21_3 VDD 0.0142812f
C383 S21_3 VSS_0 0.0328013f
C384 S21_4 S22_6 0.00963497f
C385 S21_4 VDD 0.00563641f
C386 S21_4 VSS_0 0.0129458f
C387 S21_5 S22_7 0.00963497f
C388 S21_5 VDD 0.00935869f
C389 S21_5 VSS_0 0.0138227f
C390 S21_6 VDD 0.00412618f
C391 S21_6 VSS_0 0.0243207f
C392 S21_7 VDD 0.010512f
C393 S21_7 VSS_0 0.0243058f
C394 S22 S23_7 0.0165468f
C395 S22 VDD 0.00967979f
C396 S22 VSS_0 0.0222327f
C397 S22_1 S23 6.99956e-05f
C398 S22_1 S23_1 3.97205e-05f
C399 S22_1 S23_2 0.00938983f
C400 S22_1 S23_3 0.000103269f
C401 S22_1 S23_4 4.07575e-05f
C402 S22_1 S23_5 4.07575e-05f
C403 S22_1 VDD 0.00549301f
C404 S22_1 VSS_0 0.0129779f
C405 S22_2 VDD 0.00417817f
C406 S22_2 VSS_0 0.0239823f
C407 S22_3 S23_6 0.0244125f
C408 S22_3 VDD 0.0142812f
C409 S22_3 VSS_0 0.0328013f
C410 S22_4 S23_6 0.00963497f
C411 S22_4 VDD 0.00563641f
C412 S22_4 VSS_0 0.0129458f
C413 S22_5 S23_7 0.00963497f
C414 S22_5 VDD 0.00935869f
C415 S22_5 VSS_0 0.0138213f
C416 S22_6 VDD 0.00412618f
C417 S22_6 VSS_0 0.0243207f
C418 S22_7 VDD 0.010512f
C419 S22_7 VSS_0 0.0243058f
C420 S23 S24_7 0.0165468f
C421 S23 VDD 0.00967979f
C422 S23 VSS_0 0.0222327f
C423 S23_1 S24 7.40027e-05f
C424 S23_1 S24_1 4.19944e-05f
C425 S23_1 S24_2 0.00938983f
C426 S23_1 S24_3 0.000109181f
C427 S23_1 S24_4 4.30908e-05f
C428 S23_1 S24_5 4.30908e-05f
C429 S23_1 VDD 0.00549836f
C430 S23_1 VSS_0 0.0129557f
C431 S23_2 VDD 0.00417817f
C432 S23_2 VSS_0 0.0239823f
C433 S23_3 S24_6 0.0244125f
C434 S23_3 VDD 0.0142812f
C435 S23_3 VSS_0 0.0328013f
C436 S23_4 S24_6 0.00963497f
C437 S23_4 VDD 0.00563641f
C438 S23_4 VSS_0 0.0129458f
C439 S23_5 S24_7 0.00963497f
C440 S23_5 VDD 0.00935863f
C441 S23_5 VSS_0 0.0138143f
C442 S23_6 VDD 0.00412618f
C443 S23_6 VSS_0 0.0243207f
C444 S23_7 VDD 0.010512f
C445 S23_7 VSS_0 0.0243058f
C446 S24 S25_7 0.0165106f
C447 S24 VDD 0.00968666f
C448 S24 VSS_0 0.0220144f
C449 S24_1 S25 4.42506e-05f
C450 S24_1 S25_1 2.5111e-05f
C451 S24_1 S25_2 0.00936932f
C452 S24_1 S25_3 6.52857e-05f
C453 S24_1 S25_4 2.57666e-05f
C454 S24_1 S25_5 2.57666e-05f
C455 S24_1 VDD 0.00593212f
C456 S24_1 VSS_0 0.0131683f
C457 S24_2 VDD 0.00417817f
C458 S24_2 VSS_0 0.0239823f
C459 S24_3 S25_6 0.0243592f
C460 S24_3 VDD 0.0142913f
C461 S24_3 VSS_0 0.0324793f
C462 S24_4 S25_6 0.00961392f
C463 S24_4 VDD 0.00564041f
C464 S24_4 VSS_0 0.0128187f
C465 S24_5 S25_7 0.00961392f
C466 S24_5 VDD 0.00928102f
C467 S24_5 VSS_0 0.0137652f
C468 S24_6 VDD 0.00412618f
C469 S24_6 VSS_0 0.0243207f
C470 S24_7 VDD 0.0105119f
C471 S24_7 VSS_0 0.0243054f
C472 S25 S26_7 0.0164037f
C473 S25 VDD 0.00958498f
C474 S25 VSS_0 0.0221298f
C475 S25_1 S26_2 0.00930866f
C476 S25_1 VDD 0.00543921f
C477 S25_1 VSS_0 0.012558f
C478 S25_2 S26_6 1.42028e-05f
C479 S25_2 VDD 0.00413682f
C480 S25_2 VSS_0 0.0238415f
C481 S25_3 S26_6 0.0242015f
C482 S25_3 VDD 0.0141413f
C483 S25_3 VSS_0 0.0326495f
C484 S25_4 S26_6 0.00955168f
C485 S25_4 VDD 0.0055812f
C486 S25_4 VSS_0 0.0128859f
C487 S25_5 S26_3 0.000396315f
C488 S25_5 S26_7 0.00955168f
C489 S25_5 VDD 0.00931289f
C490 S25_5 VSS_0 0.0128859f
C491 S25_6 S26_6 1.4026e-05f
C492 S25_6 VDD 0.00408534f
C493 S25_6 VSS_0 0.0241817f
C494 S25_7 S26 1.91395e-05f
C495 S25_7 S26_1 2.41748e-05f
C496 S25_7 S26_3 0.00010891f
C497 S25_7 S26_4 2.48059e-05f
C498 S25_7 S26_5 2.48059e-05f
C499 S25_7 S26_6 1.4026e-05f
C500 S25_7 VDD 0.0105274f
C501 S25_7 VSS_0 0.0240168f
C502 S26 S27_6 0.00656946f
C503 S26 VDD 0.00432664f
C504 S26 VSS_0 0.00475245f
C505 S26 VSS_1 0.00436446f
C506 S26_1 S27 0.000159319f
C507 S26_1 S27_1 9.04091e-05f
C508 S26_1 S27_2 0.000235053f
C509 S26_1 S27_3 0.00829777f
C510 S26_1 S27_4 9.27693e-05f
C511 S26_1 S27_5 9.27693e-05f
C512 S26_1 VDD 0.00549048f
C513 S26_1 VSS_0 0.00600273f
C514 S26_1 VSS_1 0.00567183f
C515 S26_2 S27_6 3.41222e-05f
C516 S26_2 VDD 0.00504793f
C517 S26_2 VSS_0 0.0348066f
C518 S26_3 S27_6 0.0376868f
C519 S26_3 VDD 0.0352042f
C520 S26_3 VSS_0 0.0417928f
C521 S26_3 VSS_1 0.0253718f
C522 S26_4 S27_7 0.0085144f
C523 S26_4 VDD 0.00560757f
C524 S26_4 VSS_0 0.00615944f
C525 S26_4 VSS_1 0.00565659f
C526 S26_5 S27_6 0.0085144f
C527 S26_5 VDD 0.00560757f
C528 S26_5 VSS_0 0.00638592f
C529 S26_5 VSS_1 0.00565659f
C530 S26_6 S27_6 1.54827e-05f
C531 S26_6 VDD 0.00229046f
C532 S26_6 VSS_0 0.0164945f
C533 S26_7 S27_6 3.22601e-05f
C534 S26_7 VDD 0.00477244f
C535 S26_7 VSS_0 0.0329071f
C536 S27 S28_6 0.0163858f
C537 S27 VDD 0.0107609f
C538 S27 VSS_0 0.0113615f
C539 S27 VSS_1 0.0109507f
C540 S27_1 S28 0.000159724f
C541 S27_1 S28_1 9.0639e-05f
C542 S27_1 S28_2 0.000235651f
C543 S27_1 S28_3 0.00929846f
C544 S27_1 S28_4 9.30053e-05f
C545 S27_1 S28_5 9.30053e-05f
C546 S27_1 VDD 0.0061323f
C547 S27_1 VSS_0 0.00644731f
C548 S27_1 VSS_1 0.00635058f
C549 S27_2 S28_6 0.0241749f
C550 S27_2 VDD 0.0158762f
C551 S27_2 VSS_0 0.0167623f
C552 S27_2 VSS_1 0.0161562f
C553 S27_3 VDD 0.005842f
C554 S27_3 VSS_0 0.0176616f
C555 S27_3 VSS_1 0.00589029f
C556 S27_4 S28_7 0.00954121f
C557 S27_4 VDD 0.00626591f
C558 S27_4 VSS_0 0.00661563f
C559 S27_4 VSS_1 0.00637643f
C560 S27_5 S28_6 0.00954121f
C561 S27_5 VDD 0.00626591f
C562 S27_5 VSS_0 0.00759891f
C563 S27_5 VSS_1 0.00637643f
C564 S27_6 VDD 0.00585089f
C565 S27_6 VSS_0 0.0179286f
C566 S27_6 VSS_1 0.005817f
C567 S27_7 VDD 0.00576931f
C568 S27_7 VSS_0 0.0174418f
C569 S27_7 VSS_1 0.005817f
C570 S28 S29_6 0.0163862f
C571 S28 VDD 0.0107623f
C572 S28 VSS_0 0.0113624f
C573 S28 VSS_1 0.0109481f
C574 S28_1 S29 0.000159724f
C575 S28_1 S29_1 9.0639e-05f
C576 S28_1 S29_2 0.000235651f
C577 S28_1 S29_3 0.0092987f
C578 S28_1 S29_4 9.30053e-05f
C579 S28_1 S29_5 9.30053e-05f
C580 S28_1 VDD 0.00613313f
C581 S28_1 VSS_0 0.00644785f
C582 S28_1 VSS_1 0.00634913f
C583 S28_2 S29_6 0.0241756f
C584 S28_2 VDD 0.0158783f
C585 S28_2 VSS_0 0.0167637f
C586 S28_2 VSS_1 0.0161524f
C587 S28_3 VDD 0.00585147f
C588 S28_3 VSS_0 0.01794f
C589 S28_3 VSS_1 0.00588458f
C590 S28_4 S29_7 0.00954145f
C591 S28_4 VDD 0.00626676f
C592 S28_4 VSS_0 0.00661618f
C593 S28_4 VSS_1 0.00637494f
C594 S28_5 S29_6 0.00954145f
C595 S28_5 VDD 0.00626676f
C596 S28_5 VSS_0 0.00759946f
C597 S28_5 VSS_1 0.00637494f
C598 S28_6 VDD 0.00578779f
C599 S28_6 VSS_0 0.0189495f
C600 S28_6 VSS_1 0.00581135f
C601 S28_7 VDD 0.00577866f
C602 S28_7 VSS_0 0.0177168f
C603 S28_7 VSS_1 0.00581135f
C604 S29 S30_6 0.0163862f
C605 S29 VDD 0.0107623f
C606 S29 VSS_0 0.0113624f
C607 S29 VSS_1 0.0109481f
C608 S29_1 S30 0.000159724f
C609 S29_1 S30_1 9.0639e-05f
C610 S29_1 S30_2 0.000235651f
C611 S29_1 S30_3 0.0092987f
C612 S29_1 S30_4 9.30053e-05f
C613 S29_1 S30_5 9.30053e-05f
C614 S29_1 VDD 0.00613313f
C615 S29_1 VSS_0 0.00644785f
C616 S29_1 VSS_1 0.00634913f
C617 S29_2 S30_6 0.0241756f
C618 S29_2 VDD 0.0158783f
C619 S29_2 VSS_0 0.0167637f
C620 S29_2 VSS_1 0.0161524f
C621 S29_3 VDD 0.00585192f
C622 S29_3 VSS_0 0.0179406f
C623 S29_3 VSS_1 0.00589714f
C624 S29_4 S30_7 0.00954145f
C625 S29_4 VDD 0.00626676f
C626 S29_4 VSS_0 0.00661618f
C627 S29_4 VSS_1 0.00637494f
C628 S29_5 S30_6 0.00954145f
C629 S29_5 VDD 0.00626676f
C630 S29_5 VSS_0 0.00759946f
C631 S29_5 VSS_1 0.00637494f
C632 S29_6 VDD 0.0057791f
C633 S29_6 VSS_0 0.0189825f
C634 S29_6 VSS_1 0.00582376f
C635 S29_7 VDD 0.0057791f
C636 S29_7 VSS_0 0.0177173f
C637 S29_7 VSS_1 0.00582376f
C638 S2_1 S3 6.99956e-05f
C639 S2_1 S3_1 3.97205e-05f
C640 S2_1 S3_2 0.00938983f
C641 S2_1 S3_3 0.000103269f
C642 S2_1 S3_4 4.07575e-05f
C643 S2_1 S3_5 4.07575e-05f
C644 S2_1 VDD 0.00549301f
C645 S2_1 VSS_0 0.0129779f
C646 S2_2 VDD 0.00419113f
C647 S2_2 VSS_0 0.0239689f
C648 S2_3 S3_6 0.0244125f
C649 S2_3 VDD 0.0142812f
C650 S2_3 VSS_0 0.0328013f
C651 S2_4 S3_6 0.00963497f
C652 S2_4 VDD 0.00563641f
C653 S2_4 VSS_0 0.0129458f
C654 S2_5 S3_7 0.00963497f
C655 S2_5 VDD 0.00935869f
C656 S2_5 VSS_0 0.0138227f
C657 S2_6 VDD 0.00413898f
C658 S2_6 VSS_0 0.0243749f
C659 S2_7 VDD 0.0104702f
C660 S2_7 VSS_0 0.0242586f
C661 S3 S4_7 0.0165468f
C662 S3 VDD 0.00967979f
C663 S3 VSS_0 0.0222327f
C664 S30 S31_6 0.0163862f
C665 S30 VDD 0.0107623f
C666 S30 VSS_0 0.0113624f
C667 S30 VSS_1 0.0109481f
C668 S30_1 S31 0.000159724f
C669 S30_1 S31_1 9.0639e-05f
C670 S30_1 S31_2 0.000235651f
C671 S30_1 S31_3 0.0092987f
C672 S30_1 S31_4 9.30053e-05f
C673 S30_1 S31_5 9.30053e-05f
C674 S30_1 VDD 0.00613313f
C675 S30_1 VSS_0 0.00644785f
C676 S30_1 VSS_1 0.00634913f
C677 S30_2 S31_6 0.0241756f
C678 S30_2 VDD 0.0158783f
C679 S30_2 VSS_0 0.0167637f
C680 S30_2 VSS_1 0.0161524f
C681 S30_3 VDD 0.00585192f
C682 S30_3 VSS_0 0.0179406f
C683 S30_3 VSS_1 0.00589714f
C684 S30_4 S31_7 0.00954145f
C685 S30_4 VDD 0.00626676f
C686 S30_4 VSS_0 0.00661618f
C687 S30_4 VSS_1 0.00637494f
C688 S30_5 S31_6 0.00954145f
C689 S30_5 VDD 0.00626676f
C690 S30_5 VSS_0 0.00759946f
C691 S30_5 VSS_1 0.00637494f
C692 S30_6 VDD 0.0057791f
C693 S30_6 VSS_0 0.0189825f
C694 S30_6 VSS_1 0.00582376f
C695 S30_7 VDD 0.0057791f
C696 S30_7 VSS_0 0.0177173f
C697 S30_7 VSS_1 0.00582376f
C698 S31 S32_6 0.0163862f
C699 S31 VDD 0.0107623f
C700 S31 VSS_0 0.0113624f
C701 S31 VSS_1 0.0109481f
C702 S31_1 S32 0.000159724f
C703 S31_1 S32_1 9.0639e-05f
C704 S31_1 S32_2 0.000235651f
C705 S31_1 S32_3 0.0092987f
C706 S31_1 S32_4 9.30053e-05f
C707 S31_1 S32_5 9.30053e-05f
C708 S31_1 VDD 0.00613313f
C709 S31_1 VSS_0 0.00644785f
C710 S31_1 VSS_1 0.00634913f
C711 S31_2 S32_6 0.0241756f
C712 S31_2 VDD 0.0158783f
C713 S31_2 VSS_0 0.0167637f
C714 S31_2 VSS_1 0.0161524f
C715 S31_3 VDD 0.00585192f
C716 S31_3 VSS_0 0.0179406f
C717 S31_3 VSS_1 0.00589714f
C718 S31_4 S32_7 0.00954145f
C719 S31_4 VDD 0.00626676f
C720 S31_4 VSS_0 0.00661618f
C721 S31_4 VSS_1 0.00637494f
C722 S31_5 S32_6 0.00954145f
C723 S31_5 VDD 0.00626676f
C724 S31_5 VSS_0 0.00759946f
C725 S31_5 VSS_1 0.00637494f
C726 S31_6 VDD 0.0057791f
C727 S31_6 VSS_0 0.0189825f
C728 S31_6 VSS_1 0.00582376f
C729 S31_7 VDD 0.0057791f
C730 S31_7 VSS_0 0.0177173f
C731 S31_7 VSS_1 0.00582376f
C732 S32 S33_6 0.0163862f
C733 S32 VDD 0.0107623f
C734 S32 VSS_0 0.0113624f
C735 S32 VSS_1 0.0109481f
C736 S32_1 S33 0.000159724f
C737 S32_1 S33_1 9.0639e-05f
C738 S32_1 S33_2 0.000235651f
C739 S32_1 S33_3 0.0092987f
C740 S32_1 S33_4 9.30053e-05f
C741 S32_1 S33_5 9.30053e-05f
C742 S32_1 VDD 0.00613313f
C743 S32_1 VSS_0 0.00644785f
C744 S32_1 VSS_1 0.00634913f
C745 S32_2 S33_6 0.0241756f
C746 S32_2 VDD 0.0158783f
C747 S32_2 VSS_0 0.0167637f
C748 S32_2 VSS_1 0.0161524f
C749 S32_3 VDD 0.00585192f
C750 S32_3 VSS_0 0.0179406f
C751 S32_3 VSS_1 0.00589714f
C752 S32_4 S33_7 0.00954145f
C753 S32_4 VDD 0.00626676f
C754 S32_4 VSS_0 0.00661618f
C755 S32_4 VSS_1 0.00637494f
C756 S32_5 S33_6 0.00954145f
C757 S32_5 VDD 0.00626676f
C758 S32_5 VSS_0 0.00759946f
C759 S32_5 VSS_1 0.00637494f
C760 S32_6 VDD 0.0057791f
C761 S32_6 VSS_0 0.0189825f
C762 S32_6 VSS_1 0.00582376f
C763 S32_7 VDD 0.0057791f
C764 S32_7 VSS_0 0.0177173f
C765 S32_7 VSS_1 0.00582376f
C766 S33 S34_6 0.0163862f
C767 S33 VDD 0.0107623f
C768 S33 VSS_0 0.0113624f
C769 S33 VSS_1 0.0109481f
C770 S33_1 S34 0.000159724f
C771 S33_1 S34_1 9.0639e-05f
C772 S33_1 S34_2 0.000235651f
C773 S33_1 S34_3 0.0092987f
C774 S33_1 S34_4 9.30053e-05f
C775 S33_1 S34_5 9.30053e-05f
C776 S33_1 VDD 0.00613313f
C777 S33_1 VSS_0 0.00644785f
C778 S33_1 VSS_1 0.00634913f
C779 S33_2 S34_6 0.0241756f
C780 S33_2 VDD 0.0158783f
C781 S33_2 VSS_0 0.0167637f
C782 S33_2 VSS_1 0.0161524f
C783 S33_3 VDD 0.00585192f
C784 S33_3 VSS_0 0.0179406f
C785 S33_3 VSS_1 0.00589714f
C786 S33_4 S34_7 0.00954145f
C787 S33_4 VDD 0.00626676f
C788 S33_4 VSS_0 0.00661618f
C789 S33_4 VSS_1 0.00637494f
C790 S33_5 S34_6 0.00954145f
C791 S33_5 VDD 0.00626676f
C792 S33_5 VSS_0 0.00759946f
C793 S33_5 VSS_1 0.00637494f
C794 S33_6 VDD 0.0057791f
C795 S33_6 VSS_0 0.0189825f
C796 S33_6 VSS_1 0.00582376f
C797 S33_7 VDD 0.0057791f
C798 S33_7 VSS_0 0.0177173f
C799 S33_7 VSS_1 0.00582376f
C800 S34 S35_6 0.0163862f
C801 S34 VDD 0.0107623f
C802 S34 VSS_0 0.0113624f
C803 S34 VSS_1 0.0109481f
C804 S34_1 S35 0.000159724f
C805 S34_1 S35_1 9.0639e-05f
C806 S34_1 S35_2 0.000235651f
C807 S34_1 S35_3 0.0092987f
C808 S34_1 S35_4 9.30053e-05f
C809 S34_1 S35_5 9.30053e-05f
C810 S34_1 VDD 0.00613313f
C811 S34_1 VSS_0 0.00644785f
C812 S34_1 VSS_1 0.00634913f
C813 S34_2 S35_6 0.0241756f
C814 S34_2 VDD 0.0158783f
C815 S34_2 VSS_0 0.0167637f
C816 S34_2 VSS_1 0.0161524f
C817 S34_3 VDD 0.00585192f
C818 S34_3 VSS_0 0.0179406f
C819 S34_3 VSS_1 0.00589714f
C820 S34_4 S35_7 0.00954145f
C821 S34_4 VDD 0.00626676f
C822 S34_4 VSS_0 0.00661618f
C823 S34_4 VSS_1 0.00637494f
C824 S34_5 S35_6 0.00954145f
C825 S34_5 VDD 0.00626676f
C826 S34_5 VSS_0 0.00759946f
C827 S34_5 VSS_1 0.00637494f
C828 S34_6 VDD 0.0057791f
C829 S34_6 VSS_0 0.0189825f
C830 S34_6 VSS_1 0.00582376f
C831 S34_7 VDD 0.0057791f
C832 S34_7 VSS_0 0.0177173f
C833 S34_7 VSS_1 0.00582376f
C834 S35 S36_6 0.0163862f
C835 S35 VDD 0.0107623f
C836 S35 VSS_0 0.0113624f
C837 S35 VSS_1 0.0109481f
C838 S35_1 S36 0.000159724f
C839 S35_1 S36_1 9.0639e-05f
C840 S35_1 S36_2 0.000235651f
C841 S35_1 S36_3 0.0092987f
C842 S35_1 S36_4 9.30053e-05f
C843 S35_1 S36_5 9.30053e-05f
C844 S35_1 VDD 0.00613313f
C845 S35_1 VSS_0 0.00644785f
C846 S35_1 VSS_1 0.00634913f
C847 S35_2 S36_6 0.0241756f
C848 S35_2 VDD 0.0158783f
C849 S35_2 VSS_0 0.0167637f
C850 S35_2 VSS_1 0.0161524f
C851 S35_3 VDD 0.00585192f
C852 S35_3 VSS_0 0.0179406f
C853 S35_3 VSS_1 0.00589714f
C854 S35_4 S36_7 0.00954145f
C855 S35_4 VDD 0.00626676f
C856 S35_4 VSS_0 0.00661618f
C857 S35_4 VSS_1 0.00637494f
C858 S35_5 S36_6 0.00954145f
C859 S35_5 VDD 0.00626676f
C860 S35_5 VSS_0 0.00759946f
C861 S35_5 VSS_1 0.00637494f
C862 S35_6 VDD 0.0057791f
C863 S35_6 VSS_0 0.0189825f
C864 S35_6 VSS_1 0.00582376f
C865 S35_7 VDD 0.0057791f
C866 S35_7 VSS_0 0.0177173f
C867 S35_7 VSS_1 0.00582376f
C868 S36 S37_6 0.0163862f
C869 S36 VDD 0.0107623f
C870 S36 VSS_0 0.0113624f
C871 S36 VSS_1 0.0109481f
C872 S36_1 S37 0.000159724f
C873 S36_1 S37_1 9.0639e-05f
C874 S36_1 S37_2 0.000235651f
C875 S36_1 S37_3 0.0092987f
C876 S36_1 S37_4 9.30053e-05f
C877 S36_1 S37_5 9.30053e-05f
C878 S36_1 VDD 0.00613313f
C879 S36_1 VSS_0 0.00644785f
C880 S36_1 VSS_1 0.00634913f
C881 S36_2 S37_6 0.0241756f
C882 S36_2 VDD 0.0158783f
C883 S36_2 VSS_0 0.0167637f
C884 S36_2 VSS_1 0.0161524f
C885 S36_3 VDD 0.00585192f
C886 S36_3 VSS_0 0.0179406f
C887 S36_3 VSS_1 0.00589714f
C888 S36_4 S37_7 0.00954145f
C889 S36_4 VDD 0.00626676f
C890 S36_4 VSS_0 0.00661618f
C891 S36_4 VSS_1 0.00637494f
C892 S36_5 S37_6 0.00954145f
C893 S36_5 VDD 0.00626676f
C894 S36_5 VSS_0 0.00759946f
C895 S36_5 VSS_1 0.00637494f
C896 S36_6 VDD 0.0057791f
C897 S36_6 VSS_0 0.0189825f
C898 S36_6 VSS_1 0.00582376f
C899 S36_7 VDD 0.0057791f
C900 S36_7 VSS_0 0.0177173f
C901 S36_7 VSS_1 0.00582376f
C902 S37 S38_6 0.0163862f
C903 S37 VDD 0.0107623f
C904 S37 VSS_0 0.0113624f
C905 S37 VSS_1 0.0109481f
C906 S37_1 S38 0.000159724f
C907 S37_1 S38_1 9.0639e-05f
C908 S37_1 S38_2 0.000235651f
C909 S37_1 S38_3 0.0092987f
C910 S37_1 S38_4 9.30053e-05f
C911 S37_1 S38_5 9.30053e-05f
C912 S37_1 VDD 0.00613313f
C913 S37_1 VSS_0 0.00644785f
C914 S37_1 VSS_1 0.00634913f
C915 S37_2 S38_6 0.0241756f
C916 S37_2 VDD 0.0158783f
C917 S37_2 VSS_0 0.0167637f
C918 S37_2 VSS_1 0.0161524f
C919 S37_3 VDD 0.00585192f
C920 S37_3 VSS_0 0.0179406f
C921 S37_3 VSS_1 0.00589714f
C922 S37_4 S38_7 0.00954145f
C923 S37_4 VDD 0.00626676f
C924 S37_4 VSS_0 0.00661618f
C925 S37_4 VSS_1 0.00637494f
C926 S37_5 S38_6 0.00954145f
C927 S37_5 VDD 0.00626676f
C928 S37_5 VSS_0 0.00759946f
C929 S37_5 VSS_1 0.00637494f
C930 S37_6 VDD 0.0057791f
C931 S37_6 VSS_0 0.0189825f
C932 S37_6 VSS_1 0.00582376f
C933 S37_7 VDD 0.0057791f
C934 S37_7 VSS_0 0.0177173f
C935 S37_7 VSS_1 0.00582376f
C936 S38 S39_6 0.0163862f
C937 S38 VDD 0.0107623f
C938 S38 VSS_0 0.0113624f
C939 S38 VSS_1 0.0109481f
C940 S38_1 S39 0.000159724f
C941 S38_1 S39_1 9.0639e-05f
C942 S38_1 S39_2 0.000235651f
C943 S38_1 S39_3 0.0092987f
C944 S38_1 S39_4 9.30053e-05f
C945 S38_1 S39_5 9.30053e-05f
C946 S38_1 VDD 0.00613313f
C947 S38_1 VSS_0 0.00644785f
C948 S38_1 VSS_1 0.00634913f
C949 S38_2 S39_6 0.0241756f
C950 S38_2 VDD 0.0158783f
C951 S38_2 VSS_0 0.0167637f
C952 S38_2 VSS_1 0.0161524f
C953 S38_3 VDD 0.00585192f
C954 S38_3 VSS_0 0.0179406f
C955 S38_3 VSS_1 0.00589714f
C956 S38_4 S39_7 0.00954145f
C957 S38_4 VDD 0.00626676f
C958 S38_4 VSS_0 0.00661618f
C959 S38_4 VSS_1 0.00637494f
C960 S38_5 S39_6 0.00954145f
C961 S38_5 VDD 0.00626676f
C962 S38_5 VSS_0 0.00759946f
C963 S38_5 VSS_1 0.00637494f
C964 S38_6 VDD 0.0057791f
C965 S38_6 VSS_0 0.0189825f
C966 S38_6 VSS_1 0.00582376f
C967 S38_7 VDD 0.0057791f
C968 S38_7 VSS_0 0.0177173f
C969 S38_7 VSS_1 0.00582376f
C970 S39 S40_6 0.0163862f
C971 S39 VDD 0.0107623f
C972 S39 VSS_0 0.0113624f
C973 S39 VSS_1 0.0109481f
C974 S39_1 S40 0.000159724f
C975 S39_1 S40_1 9.0639e-05f
C976 S39_1 S40_2 0.000235651f
C977 S39_1 S40_3 0.0092987f
C978 S39_1 S40_4 9.30053e-05f
C979 S39_1 S40_5 9.30053e-05f
C980 S39_1 VDD 0.00613313f
C981 S39_1 VSS_0 0.00644785f
C982 S39_1 VSS_1 0.00634913f
C983 S39_2 S40_6 0.0241756f
C984 S39_2 VDD 0.0158783f
C985 S39_2 VSS_0 0.0167637f
C986 S39_2 VSS_1 0.0161524f
C987 S39_3 VDD 0.00585192f
C988 S39_3 VSS_0 0.0179406f
C989 S39_3 VSS_1 0.00589714f
C990 S39_4 S40_7 0.00954145f
C991 S39_4 VDD 0.00626676f
C992 S39_4 VSS_0 0.00661618f
C993 S39_4 VSS_1 0.00637494f
C994 S39_5 S40_6 0.00954145f
C995 S39_5 VDD 0.00626676f
C996 S39_5 VSS_0 0.00759946f
C997 S39_5 VSS_1 0.00637494f
C998 S39_6 VDD 0.0057791f
C999 S39_6 VSS_0 0.0189825f
C1000 S39_6 VSS_1 0.00582376f
C1001 S39_7 VDD 0.0057791f
C1002 S39_7 VSS_0 0.0177173f
C1003 S39_7 VSS_1 0.00582376f
C1004 S3_1 S4 6.99956e-05f
C1005 S3_1 S4_1 3.97205e-05f
C1006 S3_1 S4_2 0.00938983f
C1007 S3_1 S4_3 0.000103269f
C1008 S3_1 S4_4 4.07575e-05f
C1009 S3_1 S4_5 4.07575e-05f
C1010 S3_1 VDD 0.00549301f
C1011 S3_1 VSS_0 0.0129779f
C1012 S3_2 VDD 0.00417817f
C1013 S3_2 VSS_0 0.0239823f
C1014 S3_3 S4_6 0.0244125f
C1015 S3_3 VDD 0.0142812f
C1016 S3_3 VSS_0 0.0328013f
C1017 S3_4 S4_6 0.00963497f
C1018 S3_4 VDD 0.00563641f
C1019 S3_4 VSS_0 0.0129458f
C1020 S3_5 S4_7 0.00963497f
C1021 S3_5 VDD 0.00935869f
C1022 S3_5 VSS_0 0.0138227f
C1023 S3_6 VDD 0.00412618f
C1024 S3_6 VSS_0 0.0243208f
C1025 S3_7 VDD 0.010512f
C1026 S3_7 VSS_0 0.0243193f
C1027 S4 S5_7 0.0165468f
C1028 S4 VDD 0.00967979f
C1029 S4 VSS_0 0.0222327f
C1030 S40 S41_6 0.0163862f
C1031 S40 VDD 0.0107623f
C1032 S40 VSS_0 0.0113624f
C1033 S40 VSS_1 0.0109481f
C1034 S40_1 S41 0.000159724f
C1035 S40_1 S41_1 9.0639e-05f
C1036 S40_1 S41_2 0.000235651f
C1037 S40_1 S41_3 0.0092987f
C1038 S40_1 S41_4 9.30053e-05f
C1039 S40_1 S41_5 9.30053e-05f
C1040 S40_1 VDD 0.00613313f
C1041 S40_1 VSS_0 0.00644785f
C1042 S40_1 VSS_1 0.00634913f
C1043 S40_2 S41_6 0.0241756f
C1044 S40_2 VDD 0.0158783f
C1045 S40_2 VSS_0 0.0167637f
C1046 S40_2 VSS_1 0.0161524f
C1047 S40_3 VDD 0.00585192f
C1048 S40_3 VSS_0 0.0179406f
C1049 S40_3 VSS_1 0.00589714f
C1050 S40_4 S41_7 0.00954145f
C1051 S40_4 VDD 0.00626676f
C1052 S40_4 VSS_0 0.00661618f
C1053 S40_4 VSS_1 0.00637494f
C1054 S40_5 S41_6 0.00954145f
C1055 S40_5 VDD 0.00626676f
C1056 S40_5 VSS_0 0.00759946f
C1057 S40_5 VSS_1 0.00637494f
C1058 S40_6 VDD 0.0057791f
C1059 S40_6 VSS_0 0.0189825f
C1060 S40_6 VSS_1 0.00582376f
C1061 S40_7 VDD 0.0057791f
C1062 S40_7 VSS_0 0.0177173f
C1063 S40_7 VSS_1 0.00582376f
C1064 S41 S42_6 0.0163862f
C1065 S41 VDD 0.0107623f
C1066 S41 VSS_0 0.0113624f
C1067 S41 VSS_1 0.0109481f
C1068 S41_1 S42 0.000159724f
C1069 S41_1 S42_1 9.0639e-05f
C1070 S41_1 S42_2 0.000235651f
C1071 S41_1 S42_3 0.0092987f
C1072 S41_1 S42_4 9.30053e-05f
C1073 S41_1 S42_5 9.30053e-05f
C1074 S41_1 VDD 0.00613313f
C1075 S41_1 VSS_0 0.00644785f
C1076 S41_1 VSS_1 0.00634913f
C1077 S41_2 S42_6 0.0241756f
C1078 S41_2 VDD 0.0158783f
C1079 S41_2 VSS_0 0.0167637f
C1080 S41_2 VSS_1 0.0161524f
C1081 S41_3 VDD 0.00585192f
C1082 S41_3 VSS_0 0.0179406f
C1083 S41_3 VSS_1 0.00589714f
C1084 S41_4 S42_7 0.00954145f
C1085 S41_4 VDD 0.00626676f
C1086 S41_4 VSS_0 0.00661618f
C1087 S41_4 VSS_1 0.00637494f
C1088 S41_5 S42_6 0.00954145f
C1089 S41_5 VDD 0.00626676f
C1090 S41_5 VSS_0 0.00759946f
C1091 S41_5 VSS_1 0.00637494f
C1092 S41_6 VDD 0.0057791f
C1093 S41_6 VSS_0 0.0189825f
C1094 S41_6 VSS_1 0.00582376f
C1095 S41_7 VDD 0.0057791f
C1096 S41_7 VSS_0 0.0177173f
C1097 S41_7 VSS_1 0.00582376f
C1098 S42 S43_6 0.0163862f
C1099 S42 VDD 0.0107623f
C1100 S42 VSS_0 0.0113624f
C1101 S42 VSS_1 0.0109481f
C1102 S42_1 S43 0.000159724f
C1103 S42_1 S43_1 9.0639e-05f
C1104 S42_1 S43_2 0.000235651f
C1105 S42_1 S43_3 0.0092987f
C1106 S42_1 S43_4 9.30053e-05f
C1107 S42_1 S43_5 9.30053e-05f
C1108 S42_1 VDD 0.00613313f
C1109 S42_1 VSS_0 0.00644785f
C1110 S42_1 VSS_1 0.00634913f
C1111 S42_2 S43_6 0.0241756f
C1112 S42_2 VDD 0.0158783f
C1113 S42_2 VSS_0 0.0167637f
C1114 S42_2 VSS_1 0.0161524f
C1115 S42_3 VDD 0.00585192f
C1116 S42_3 VSS_0 0.0179406f
C1117 S42_3 VSS_1 0.00589714f
C1118 S42_4 S43_7 0.00954145f
C1119 S42_4 VDD 0.00626676f
C1120 S42_4 VSS_0 0.00661618f
C1121 S42_4 VSS_1 0.00637494f
C1122 S42_5 S43_6 0.00954145f
C1123 S42_5 VDD 0.00626676f
C1124 S42_5 VSS_0 0.00759946f
C1125 S42_5 VSS_1 0.00637494f
C1126 S42_6 VDD 0.0057791f
C1127 S42_6 VSS_0 0.0189825f
C1128 S42_6 VSS_1 0.00582376f
C1129 S42_7 VDD 0.0057791f
C1130 S42_7 VSS_0 0.0177173f
C1131 S42_7 VSS_1 0.00582376f
C1132 S43 S44_6 0.0163862f
C1133 S43 VDD 0.0107623f
C1134 S43 VSS_0 0.0113624f
C1135 S43 VSS_1 0.0109481f
C1136 S43_1 S44 0.000159724f
C1137 S43_1 S44_1 9.0639e-05f
C1138 S43_1 S44_2 0.000235651f
C1139 S43_1 S44_3 0.0092987f
C1140 S43_1 S44_4 9.30053e-05f
C1141 S43_1 S44_5 9.30053e-05f
C1142 S43_1 VDD 0.00613313f
C1143 S43_1 VSS_0 0.00644785f
C1144 S43_1 VSS_1 0.00634913f
C1145 S43_2 S44_6 0.0241756f
C1146 S43_2 VDD 0.0158783f
C1147 S43_2 VSS_0 0.0167637f
C1148 S43_2 VSS_1 0.0161524f
C1149 S43_3 VDD 0.00585192f
C1150 S43_3 VSS_0 0.0179406f
C1151 S43_3 VSS_1 0.00589714f
C1152 S43_4 S44_7 0.00954145f
C1153 S43_4 VDD 0.00626676f
C1154 S43_4 VSS_0 0.00661618f
C1155 S43_4 VSS_1 0.00637494f
C1156 S43_5 S44_6 0.00954145f
C1157 S43_5 VDD 0.00626676f
C1158 S43_5 VSS_0 0.00759946f
C1159 S43_5 VSS_1 0.00637494f
C1160 S43_6 VDD 0.0057791f
C1161 S43_6 VSS_0 0.0189825f
C1162 S43_6 VSS_1 0.00582376f
C1163 S43_7 VDD 0.0057791f
C1164 S43_7 VSS_0 0.0177173f
C1165 S43_7 VSS_1 0.00582376f
C1166 S44 S45_6 0.0163862f
C1167 S44 VDD 0.0107623f
C1168 S44 VSS_0 0.0113624f
C1169 S44 VSS_1 0.0109481f
C1170 S44_1 S45 0.000159724f
C1171 S44_1 S45_1 9.0639e-05f
C1172 S44_1 S45_2 0.000235651f
C1173 S44_1 S45_3 0.0092987f
C1174 S44_1 S45_4 9.30053e-05f
C1175 S44_1 S45_5 9.30053e-05f
C1176 S44_1 VDD 0.00613313f
C1177 S44_1 VSS_0 0.00644785f
C1178 S44_1 VSS_1 0.00634913f
C1179 S44_2 S45_6 0.0241756f
C1180 S44_2 VDD 0.0158783f
C1181 S44_2 VSS_0 0.0167637f
C1182 S44_2 VSS_1 0.0161524f
C1183 S44_3 VDD 0.00585192f
C1184 S44_3 VSS_0 0.0179406f
C1185 S44_3 VSS_1 0.00589714f
C1186 S44_4 S45_7 0.00954145f
C1187 S44_4 VDD 0.00626676f
C1188 S44_4 VSS_0 0.00661618f
C1189 S44_4 VSS_1 0.00637494f
C1190 S44_5 S45_6 0.00954145f
C1191 S44_5 VDD 0.00626676f
C1192 S44_5 VSS_0 0.00759946f
C1193 S44_5 VSS_1 0.00637494f
C1194 S44_6 VDD 0.0057791f
C1195 S44_6 VSS_0 0.0189825f
C1196 S44_6 VSS_1 0.00582376f
C1197 S44_7 VDD 0.0057791f
C1198 S44_7 VSS_0 0.0177173f
C1199 S44_7 VSS_1 0.00582376f
C1200 S45 S46_6 0.0163862f
C1201 S45 VDD 0.0107623f
C1202 S45 VSS_0 0.0113624f
C1203 S45 VSS_1 0.0109481f
C1204 S45_1 S46 0.000159724f
C1205 S45_1 S46_1 9.0639e-05f
C1206 S45_1 S46_2 0.000235651f
C1207 S45_1 S46_3 0.0092987f
C1208 S45_1 S46_4 9.30053e-05f
C1209 S45_1 S46_5 9.30053e-05f
C1210 S45_1 VDD 0.00613313f
C1211 S45_1 VSS_0 0.00644785f
C1212 S45_1 VSS_1 0.00634913f
C1213 S45_2 S46_6 0.0241756f
C1214 S45_2 VDD 0.0158783f
C1215 S45_2 VSS_0 0.0167637f
C1216 S45_2 VSS_1 0.0161524f
C1217 S45_3 VDD 0.00585192f
C1218 S45_3 VSS_0 0.0179406f
C1219 S45_3 VSS_1 0.00589714f
C1220 S45_4 S46_7 0.00954145f
C1221 S45_4 VDD 0.00626676f
C1222 S45_4 VSS_0 0.00661618f
C1223 S45_4 VSS_1 0.00637494f
C1224 S45_5 S46_6 0.00954145f
C1225 S45_5 VDD 0.00626676f
C1226 S45_5 VSS_0 0.00759946f
C1227 S45_5 VSS_1 0.00637494f
C1228 S45_6 VDD 0.0057791f
C1229 S45_6 VSS_0 0.0189825f
C1230 S45_6 VSS_1 0.00582376f
C1231 S45_7 VDD 0.0057791f
C1232 S45_7 VSS_0 0.0177173f
C1233 S45_7 VSS_1 0.00582376f
C1234 S46 S47_6 0.0163862f
C1235 S46 VDD 0.0107623f
C1236 S46 VSS_0 0.0113624f
C1237 S46 VSS_1 0.0109481f
C1238 S46_1 S47 0.000159724f
C1239 S46_1 S47_1 9.0639e-05f
C1240 S46_1 S47_2 0.000235651f
C1241 S46_1 S47_3 0.0092987f
C1242 S46_1 S47_4 9.30053e-05f
C1243 S46_1 S47_5 9.30053e-05f
C1244 S46_1 VDD 0.00613313f
C1245 S46_1 VSS_0 0.00644785f
C1246 S46_1 VSS_1 0.00634913f
C1247 S46_2 S47_6 0.0241756f
C1248 S46_2 VDD 0.0158783f
C1249 S46_2 VSS_0 0.0167637f
C1250 S46_2 VSS_1 0.0161524f
C1251 S46_3 VDD 0.00585192f
C1252 S46_3 VSS_0 0.0179406f
C1253 S46_3 VSS_1 0.00589714f
C1254 S46_4 S47_7 0.00954145f
C1255 S46_4 VDD 0.00626676f
C1256 S46_4 VSS_0 0.00661618f
C1257 S46_4 VSS_1 0.00637494f
C1258 S46_5 S47_6 0.00954145f
C1259 S46_5 VDD 0.00626676f
C1260 S46_5 VSS_0 0.00759946f
C1261 S46_5 VSS_1 0.00637494f
C1262 S46_6 VDD 0.0057791f
C1263 S46_6 VSS_0 0.0189825f
C1264 S46_6 VSS_1 0.00582376f
C1265 S46_7 VDD 0.0057791f
C1266 S46_7 VSS_0 0.0177173f
C1267 S46_7 VSS_1 0.00582376f
C1268 S47 S48_6 0.0163862f
C1269 S47 VDD 0.0107623f
C1270 S47 VSS_0 0.0113624f
C1271 S47 VSS_1 0.0109481f
C1272 S47_1 S48 0.000159724f
C1273 S47_1 S48_1 9.0639e-05f
C1274 S47_1 S48_2 0.000235651f
C1275 S47_1 S48_3 0.0092987f
C1276 S47_1 S48_4 9.30053e-05f
C1277 S47_1 S48_5 9.30053e-05f
C1278 S47_1 VDD 0.00613313f
C1279 S47_1 VSS_0 0.00644785f
C1280 S47_1 VSS_1 0.00634913f
C1281 S47_2 S48_6 0.0241756f
C1282 S47_2 VDD 0.0158783f
C1283 S47_2 VSS_0 0.0167637f
C1284 S47_2 VSS_1 0.0161524f
C1285 S47_3 VDD 0.00585192f
C1286 S47_3 VSS_0 0.0179406f
C1287 S47_3 VSS_1 0.00589714f
C1288 S47_4 S48_7 0.00954145f
C1289 S47_4 VDD 0.00626676f
C1290 S47_4 VSS_0 0.00661618f
C1291 S47_4 VSS_1 0.00637494f
C1292 S47_5 S48_6 0.00954145f
C1293 S47_5 VDD 0.00626676f
C1294 S47_5 VSS_0 0.00759946f
C1295 S47_5 VSS_1 0.00637494f
C1296 S47_6 VDD 0.0057791f
C1297 S47_6 VSS_0 0.0189825f
C1298 S47_6 VSS_1 0.00582376f
C1299 S47_7 VDD 0.0057791f
C1300 S47_7 VSS_0 0.0177173f
C1301 S47_7 VSS_1 0.00582376f
C1302 S48 S49_6 0.0163862f
C1303 S48 VDD 0.0107623f
C1304 S48 VSS_0 0.0113624f
C1305 S48 VSS_1 0.0109481f
C1306 S48_1 S49 0.000166834f
C1307 S48_1 S49_1 9.46738e-05f
C1308 S48_1 S49_2 0.000246141f
C1309 S48_1 S49_3 0.0092987f
C1310 S48_1 S49_4 9.71454e-05f
C1311 S48_1 S49_5 9.71454e-05f
C1312 S48_1 VDD 0.00610732f
C1313 S48_1 VSS_0 0.00644785f
C1314 S48_1 VSS_1 0.00634249f
C1315 S48_2 S49_6 0.0241756f
C1316 S48_2 VDD 0.0158783f
C1317 S48_2 VSS_0 0.0167637f
C1318 S48_2 VSS_1 0.0161524f
C1319 S48_3 VDD 0.00585192f
C1320 S48_3 VSS_0 0.0179406f
C1321 S48_3 VSS_1 0.00589714f
C1322 S48_4 S49_7 0.00954145f
C1323 S48_4 VDD 0.00626676f
C1324 S48_4 VSS_0 0.00661618f
C1325 S48_4 VSS_1 0.00637494f
C1326 S48_5 S49_6 0.00954145f
C1327 S48_5 VDD 0.00626676f
C1328 S48_5 VSS_0 0.00759997f
C1329 S48_5 VSS_1 0.00637494f
C1330 S48_6 VDD 0.0057791f
C1331 S48_6 VSS_0 0.0189825f
C1332 S48_6 VSS_1 0.00582376f
C1333 S48_7 VDD 0.0057791f
C1334 S48_7 VSS_0 0.0177173f
C1335 S48_7 VSS_1 0.00582376f
C1336 S49 S50_6 0.0164377f
C1337 S49 VDD 0.0107329f
C1338 S49 VSS_0 0.011316f
C1339 S49 VSS_1 0.0109904f
C1340 S49_1 S50 0.000102665f
C1341 S49_1 S50_1 5.82597e-05f
C1342 S49_1 S50_2 0.000151469f
C1343 S49_1 S50_3 0.00932796f
C1344 S49_1 S50_4 5.97807e-05f
C1345 S49_1 S50_5 5.97807e-05f
C1346 S49_1 VDD 0.00612489f
C1347 S49_1 VSS_0 0.00643194f
C1348 S49_1 VSS_1 0.00623675f
C1349 S49_2 S50_6 0.0242516f
C1350 S49_2 VDD 0.0158349f
C1351 S49_2 VSS_0 0.0166951f
C1352 S49_2 VSS_1 0.0162148f
C1353 S49_3 VDD 0.00585192f
C1354 S49_3 VSS_0 0.0179374f
C1355 S49_3 VSS_1 0.00589714f
C1356 S49_4 S50_7 0.00957148f
C1357 S49_4 VDD 0.00624962f
C1358 S49_4 VSS_0 0.00658913f
C1359 S49_4 VSS_1 0.00639957f
C1360 S49_5 S50_6 0.00957148f
C1361 S49_5 VDD 0.00624962f
C1362 S49_5 VSS_0 0.00756999f
C1363 S49_5 VSS_1 0.00639957f
C1364 S49_6 VDD 0.0057791f
C1365 S49_6 VSS_0 0.0189757f
C1366 S49_6 VSS_1 0.00582376f
C1367 S49_7 VDD 0.0057791f
C1368 S49_7 VSS_0 0.0177142f
C1369 S49_7 VSS_1 0.00582376f
C1370 S4_1 S5 6.99956e-05f
C1371 S4_1 S5_1 3.97205e-05f
C1372 S4_1 S5_2 0.00938983f
C1373 S4_1 S5_3 0.000103269f
C1374 S4_1 S5_4 4.07575e-05f
C1375 S4_1 S5_5 4.07575e-05f
C1376 S4_1 VDD 0.00549301f
C1377 S4_1 VSS_0 0.0129779f
C1378 S4_2 VDD 0.00417817f
C1379 S4_2 VSS_0 0.0239823f
C1380 S4_3 S5_6 0.0244125f
C1381 S4_3 VDD 0.0142812f
C1382 S4_3 VSS_0 0.0328013f
C1383 S4_4 S5_6 0.00963497f
C1384 S4_4 VDD 0.00563641f
C1385 S4_4 VSS_0 0.0129458f
C1386 S4_5 S5_7 0.00963497f
C1387 S4_5 VDD 0.00935869f
C1388 S4_5 VSS_0 0.0138227f
C1389 S4_6 VDD 0.00412618f
C1390 S4_6 VSS_0 0.0243207f
C1391 S4_7 VDD 0.010512f
C1392 S4_7 VSS_0 0.0243058f
C1393 S5 S6_7 0.0165468f
C1394 S5 VDD 0.00967979f
C1395 S5 VSS_0 0.0222327f
C1396 S50 VDD 0.0105746f
C1397 S50 VSS_0 0.0111323f
C1398 S50 VSS_1 0.0109668f
C1399 S50_1 VDD 0.00600077f
C1400 S50_1 VSS_0 0.00631729f
C1401 S50_1 VSS_1 0.00622333f
C1402 S50_2 VDD 0.0156013f
C1403 S50_2 VSS_0 0.0164242f
C1404 S50_2 VSS_1 0.0161799f
C1405 S50_3 VDD 0.00591273f
C1406 S50_3 VSS_0 0.0179486f
C1407 S50_3 VSS_1 0.00588963f
C1408 S50_4 VDD 0.00615743f
C1409 S50_4 VSS_0 0.00648221f
C1410 S50_4 VSS_1 0.0063858f
C1411 S50_5 VDD 0.00615743f
C1412 S50_5 VSS_0 0.00689587f
C1413 S50_5 VSS_1 0.0063858f
C1414 S50_6 VDD 0.00583915f
C1415 S50_6 VSS_0 0.0189867f
C1416 S50_6 VSS_1 0.00581634f
C1417 S50_7 VDD 0.00583915f
C1418 S50_7 VSS_0 0.0177252f
C1419 S50_7 VSS_1 0.00581634f
C1420 S5_1 S6 6.99956e-05f
C1421 S5_1 S6_1 3.97205e-05f
C1422 S5_1 S6_2 0.00938983f
C1423 S5_1 S6_3 0.000103269f
C1424 S5_1 S6_4 4.07575e-05f
C1425 S5_1 S6_5 4.07575e-05f
C1426 S5_1 VDD 0.00549301f
C1427 S5_1 VSS_0 0.0129779f
C1428 S5_2 VDD 0.00417817f
C1429 S5_2 VSS_0 0.0239823f
C1430 S5_3 S6_6 0.0244125f
C1431 S5_3 VDD 0.0142812f
C1432 S5_3 VSS_0 0.0328013f
C1433 S5_4 S6_6 0.00963497f
C1434 S5_4 VDD 0.00563641f
C1435 S5_4 VSS_0 0.0129458f
C1436 S5_5 S6_7 0.00963497f
C1437 S5_5 VDD 0.00935869f
C1438 S5_5 VSS_0 0.0138227f
C1439 S5_6 VDD 0.00412618f
C1440 S5_6 VSS_0 0.0243207f
C1441 S5_7 VDD 0.010512f
C1442 S5_7 VSS_0 0.0243058f
C1443 S6 S7_7 0.0165468f
C1444 S6 VDD 0.00967979f
C1445 S6 VSS_0 0.0222327f
C1446 S6_1 S7 6.99956e-05f
C1447 S6_1 S7_1 3.97205e-05f
C1448 S6_1 S7_2 0.00938983f
C1449 S6_1 S7_3 0.000103269f
C1450 S6_1 S7_4 4.07575e-05f
C1451 S6_1 S7_5 4.07575e-05f
C1452 S6_1 VDD 0.00549301f
C1453 S6_1 VSS_0 0.0129779f
C1454 S6_2 VDD 0.00417817f
C1455 S6_2 VSS_0 0.0239823f
C1456 S6_3 S7_6 0.0244125f
C1457 S6_3 VDD 0.0142812f
C1458 S6_3 VSS_0 0.0328013f
C1459 S6_4 S7_6 0.00963497f
C1460 S6_4 VDD 0.00563641f
C1461 S6_4 VSS_0 0.0129458f
C1462 S6_5 S7_7 0.00963497f
C1463 S6_5 VDD 0.00935869f
C1464 S6_5 VSS_0 0.0138227f
C1465 S6_6 VDD 0.00412618f
C1466 S6_6 VSS_0 0.0243207f
C1467 S6_7 VDD 0.010512f
C1468 S6_7 VSS_0 0.0243058f
C1469 S7 S8_7 0.0165468f
C1470 S7 VDD 0.00967979f
C1471 S7 VSS_0 0.0222327f
C1472 S7_1 S8 6.99956e-05f
C1473 S7_1 S8_1 3.97205e-05f
C1474 S7_1 S8_2 0.00938983f
C1475 S7_1 S8_3 0.000103269f
C1476 S7_1 S8_4 4.07575e-05f
C1477 S7_1 S8_5 4.07575e-05f
C1478 S7_1 VDD 0.00549301f
C1479 S7_1 VSS_0 0.0129779f
C1480 S7_2 VDD 0.00417817f
C1481 S7_2 VSS_0 0.0239823f
C1482 S7_3 S8_6 0.0244125f
C1483 S7_3 VDD 0.0142812f
C1484 S7_3 VSS_0 0.0328013f
C1485 S7_4 S8_6 0.00963497f
C1486 S7_4 VDD 0.00563641f
C1487 S7_4 VSS_0 0.0129458f
C1488 S7_5 S8_7 0.00963497f
C1489 S7_5 VDD 0.00935869f
C1490 S7_5 VSS_0 0.0138227f
C1491 S7_6 VDD 0.00412618f
C1492 S7_6 VSS_0 0.0243207f
C1493 S7_7 VDD 0.010512f
C1494 S7_7 VSS_0 0.0243058f
C1495 S8 S9_7 0.0165468f
C1496 S8 VDD 0.00967979f
C1497 S8 VSS_0 0.0222327f
C1498 S8_1 S9 6.99956e-05f
C1499 S8_1 S9_1 3.97205e-05f
C1500 S8_1 S9_2 0.00938983f
C1501 S8_1 S9_3 0.000103269f
C1502 S8_1 S9_4 4.07575e-05f
C1503 S8_1 S9_5 4.07575e-05f
C1504 S8_1 VDD 0.00549301f
C1505 S8_1 VSS_0 0.0129779f
C1506 S8_2 VDD 0.00417817f
C1507 S8_2 VSS_0 0.0239823f
C1508 S8_3 S9_6 0.0244125f
C1509 S8_3 VDD 0.0142812f
C1510 S8_3 VSS_0 0.0328013f
C1511 S8_4 S9_6 0.00963497f
C1512 S8_4 VDD 0.00563641f
C1513 S8_4 VSS_0 0.0129458f
C1514 S8_5 S9_7 0.00963497f
C1515 S8_5 VDD 0.00935869f
C1516 S8_5 VSS_0 0.0138227f
C1517 S8_6 VDD 0.00412618f
C1518 S8_6 VSS_0 0.0243207f
C1519 S8_7 VDD 0.010512f
C1520 S8_7 VSS_0 0.0243058f
C1521 S9 VDD 0.00967979f
C1522 S9 VSS_0 0.0222327f
C1523 S9_1 VDD 0.00549301f
C1524 S9_1 VSS_0 0.0129779f
C1525 S9_2 VDD 0.00417817f
C1526 S9_2 VSS_0 0.0239823f
C1527 S9_3 VDD 0.0142812f
C1528 S9_3 VSS_0 0.0328013f
C1529 S9_4 VDD 0.00563641f
C1530 S9_4 VSS_0 0.0129458f
C1531 S9_5 VDD 0.00935869f
C1532 S9_5 VSS_0 0.0138227f
C1533 S9_6 VDD 0.00412618f
C1534 S9_6 VSS_0 0.0243207f
C1535 S9_7 VDD 0.010512f
C1536 S9_7 VSS_0 0.0243058f
C1537 VDD VSS_0 1.56942f
C1538 VSS_0 VSS_1 1.01481f
.ends
