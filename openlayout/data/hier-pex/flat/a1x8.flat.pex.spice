* A1x8 - parasitic extraction by OpenLayout (openlayout pex, mode rc)
* layout: /tmp/xs/a1x8.gds
* C: FasterCap 3D field solver (k = 4.6 front end, 3.23 above z = 0.074 um); R: KLayout RNetExtractor, reference sheet / via resistances
* 80 transistors, 223 resistors, 3920 capacitors
* total capacitance per net (fF): BLB_0 0.1204, BLB_1 0.1204, BLB_2 0.1205, BLB_3 0.1205, BLB_4 0.1202, BLB_5 0.1204, BLB_6 0.1203, BLB_7 0.1182, BL_0 0.0871, BL_1 0.0897, BL_2 0.0898, BL_3 0.0897, BL_4 0.0899, BL_5 0.0897, BL_6 0.0898, BL_7 0.0897, P_0_0 0.1914, P_0_1 0.1911, P_0_2 0.1914, P_0_3 0.1912, P_0_4 0.1915, P_0_5 0.1912, P_0_6 0.1909, P_0_7 0.1906, VDD_1 1.4385, VSS_0 4.3916, WL_0 2.6778, XB_0_0 0.1694, XB_0_1 0.1700, XB_0_2 0.1691, XB_0_3 0.1697, XB_0_4 0.1698, XB_0_5 0.1697, XB_0_6 0.1705, XB_0_7 0.1678, net12 0.2575, net13 0.4670, net15 0.2575, net16 0.4670, net19 0.2579, net20 0.4676, net22 0.2571, net23 0.4670, net25 0.2566, net26 0.4677, net28 0.2567, net29 0.4675, net4 0.2559, net5 0.4662, net68 0.0585, net69 0.0585, net70 0.0585, net71 0.0585, net72 0.0585, net73 0.0585, net74 0.0585, net75 0.0584, net8 0.2566, net9 0.4671

.subckt A1x8 BLB_0 BLB_1 BLB_2 BLB_3 BLB_4 BLB_5 BLB_6 BLB_7 BL_0 BL_1 BL_2 BL_3 BL_4 BL_5 BL_6 BL_7 P_0_0 P_0_1 P_0_2 P_0_3 P_0_4 P_0_5 P_0_6 P_0_7 VDD_1 VSS_0 WL_0 XB_0_0 XB_0_1 XB_0_2 XB_0_3 XB_0_4 XB_0_5 XB_0_6 XB_0_7
N1 net4_4 WL_0_16 BL_0_1 VSS_0 nmos_sram l=20n nfin=2
N2 VSS_0 net5_5 net4_4 VSS_0 nmos_sram l=20n nfin=2
N3 net5_9 net4_2 VSS_0 VSS_0 nmos_sram l=20n nfin=2
N4 BLB_0_1 WL_0_17 net5_9 VSS_0 nmos_sram l=20n nfin=2
N5 VSS_0 net5_7 P_0_0_3 VSS_0 nmos_sram l=20n nfin=1
N6 P_0_0_4 XB_0_0_2 VSS_0 VSS_0 nmos_sram l=20n nfin=1
N7 net8_4 WL_0_18 BL_1_1 VSS_0 nmos_sram l=20n nfin=2
N8 VSS_0 net9_5 net8_4 VSS_0 nmos_sram l=20n nfin=2
N9 net9_9 net8_2 VSS_0 VSS_0 nmos_sram l=20n nfin=2
N10 BLB_1_1 WL_0_19 net9_9 VSS_0 nmos_sram l=20n nfin=2
N11 VSS_0 net9_7 P_0_1_3 VSS_0 nmos_sram l=20n nfin=1
N12 P_0_1_4 XB_0_1_2 VSS_0 VSS_0 nmos_sram l=20n nfin=1
N13 net12_4 WL_0_20 BL_2_1 VSS_0 nmos_sram l=20n nfin=2
N14 VSS_0 net13_5 net12_4 VSS_0 nmos_sram l=20n nfin=2
N15 net13_9 net12_2 VSS_0 VSS_0 nmos_sram l=20n nfin=2
N16 BLB_2_1 WL_0_21 net13_9 VSS_0 nmos_sram l=20n nfin=2
N17 VSS_0 net13_7 P_0_2_3 VSS_0 nmos_sram l=20n nfin=1
N18 P_0_2_4 XB_0_2_2 VSS_0 VSS_0 nmos_sram l=20n nfin=1
N19 net15_4 WL_0_22 BL_3_1 VSS_0 nmos_sram l=20n nfin=2
N20 VSS_0 net16_5 net15_4 VSS_0 nmos_sram l=20n nfin=2
N21 net16_9 net15_2 VSS_0 VSS_0 nmos_sram l=20n nfin=2
N22 BLB_3_1 WL_0_23 net16_9 VSS_0 nmos_sram l=20n nfin=2
N23 VSS_0 net16_7 P_0_3_3 VSS_0 nmos_sram l=20n nfin=1
N24 P_0_3_4 XB_0_3_2 VSS_0 VSS_0 nmos_sram l=20n nfin=1
N25 net19_4 WL_0_24 BL_4_1 VSS_0 nmos_sram l=20n nfin=2
N26 VSS_0 net20_5 net19_4 VSS_0 nmos_sram l=20n nfin=2
N27 net20_9 net19_2 VSS_0 VSS_0 nmos_sram l=20n nfin=2
N28 BLB_4_1 WL_0_25 net20_9 VSS_0 nmos_sram l=20n nfin=2
N29 VSS_0 net20_7 P_0_4_3 VSS_0 nmos_sram l=20n nfin=1
N30 P_0_4_4 XB_0_4_2 VSS_0 VSS_0 nmos_sram l=20n nfin=1
N31 net22_4 WL_0_26 BL_5_1 VSS_0 nmos_sram l=20n nfin=2
N32 VSS_0 net23_5 net22_4 VSS_0 nmos_sram l=20n nfin=2
N33 net23_9 net22_2 VSS_0 VSS_0 nmos_sram l=20n nfin=2
N34 BLB_5_1 WL_0_27 net23_9 VSS_0 nmos_sram l=20n nfin=2
N35 VSS_0 net23_7 P_0_5_3 VSS_0 nmos_sram l=20n nfin=1
N36 P_0_5_4 XB_0_5_2 VSS_0 VSS_0 nmos_sram l=20n nfin=1
N37 net25_4 WL_0_28 BL_6_1 VSS_0 nmos_sram l=20n nfin=2
N38 VSS_0 net26_5 net25_4 VSS_0 nmos_sram l=20n nfin=2
N39 net26_9 net25_2 VSS_0 VSS_0 nmos_sram l=20n nfin=2
N40 BLB_6_1 WL_0_29 net26_9 VSS_0 nmos_sram l=20n nfin=2
N41 VSS_0 net26_7 P_0_6_3 VSS_0 nmos_sram l=20n nfin=1
N42 P_0_6_4 XB_0_6_2 VSS_0 VSS_0 nmos_sram l=20n nfin=1
N43 net28_4 WL_0_30 BL_7_1 VSS_0 nmos_sram l=20n nfin=2
N44 VSS_0 net29_5 net28_4 VSS_0 nmos_sram l=20n nfin=2
N45 net29_9 net28_2 VSS_0 VSS_0 nmos_sram l=20n nfin=2
N46 BLB_7_1 WL_0_31 net29_9 VSS_0 nmos_sram l=20n nfin=2
N47 VSS_0 net29_7 P_0_7_3 VSS_0 nmos_sram l=20n nfin=1
N48 P_0_7_4 XB_0_7_2 VSS_0 VSS_0 nmos_sram l=20n nfin=1
N49 VDD_1 net5_6 net4_6 VDD_1 pmos_sram l=20n nfin=1
N50 net5_11 net4_3 VDD_1 VDD_1 pmos_sram l=20n nfin=1
N51 net68 net5_8 P_0_0_5 VDD_1 pmos_sram l=20n nfin=2
N52 VDD_1 XB_0_0_3 net68 VDD_1 pmos_sram l=20n nfin=2
N53 VDD_1 net9_6 net8_6 VDD_1 pmos_sram l=20n nfin=1
N54 net9_11 net8_3 VDD_1 VDD_1 pmos_sram l=20n nfin=1
N55 net69 net9_8 P_0_1_5 VDD_1 pmos_sram l=20n nfin=2
N56 VDD_1 XB_0_1_3 net69 VDD_1 pmos_sram l=20n nfin=2
N57 VDD_1 net13_6 net12_6 VDD_1 pmos_sram l=20n nfin=1
N58 net13_11 net12_3 VDD_1 VDD_1 pmos_sram l=20n nfin=1
N59 net70 net13_8 P_0_2_5 VDD_1 pmos_sram l=20n nfin=2
N60 VDD_1 XB_0_2_3 net70 VDD_1 pmos_sram l=20n nfin=2
N61 VDD_1 net16_6 net15_6 VDD_1 pmos_sram l=20n nfin=1
N62 net16_11 net15_3 VDD_1 VDD_1 pmos_sram l=20n nfin=1
N63 net71 net16_8 P_0_3_5 VDD_1 pmos_sram l=20n nfin=2
N64 VDD_1 XB_0_3_3 net71 VDD_1 pmos_sram l=20n nfin=2
N65 VDD_1 net20_6 net19_6 VDD_1 pmos_sram l=20n nfin=1
N66 net20_11 net19_3 VDD_1 VDD_1 pmos_sram l=20n nfin=1
N67 net72 net20_8 P_0_4_5 VDD_1 pmos_sram l=20n nfin=2
N68 VDD_1 XB_0_4_3 net72 VDD_1 pmos_sram l=20n nfin=2
N69 VDD_1 net23_6 net22_6 VDD_1 pmos_sram l=20n nfin=1
N70 net23_11 net22_3 VDD_1 VDD_1 pmos_sram l=20n nfin=1
N71 net73 net23_8 P_0_5_5 VDD_1 pmos_sram l=20n nfin=2
N72 VDD_1 XB_0_5_3 net73 VDD_1 pmos_sram l=20n nfin=2
N73 VDD_1 net26_6 net25_6 VDD_1 pmos_sram l=20n nfin=1
N74 net26_11 net25_3 VDD_1 VDD_1 pmos_sram l=20n nfin=1
N75 net74 net26_8 P_0_6_5 VDD_1 pmos_sram l=20n nfin=2
N76 VDD_1 XB_0_6_3 net74 VDD_1 pmos_sram l=20n nfin=2
N77 VDD_1 net29_6 net28_6 VDD_1 pmos_sram l=20n nfin=1
N78 net29_11 net28_3 VDD_1 VDD_1 pmos_sram l=20n nfin=1
N79 net75 net29_8 P_0_7_5 VDD_1 pmos_sram l=20n nfin=2
N80 VDD_1 XB_0_7_3 net75 VDD_1 pmos_sram l=20n nfin=2
R1 BL_6 BL_6_1 68.2426
R2 BL_7 BL_7_1 68.2426
R3 net4_3 net4 34.1846
R4 net4 net4_2 25.5109
R5 net4_4 net4_7 39.8169
R6 net4_6 net4_7 43.642
R7 net4_7 net4 44.6984
R8 net5_6 net5 34.1846
R9 net5 net5_5 25.5109
R10 net5_8 net5_2 29.5926
R11 net5_2 net5_7 30.1028
R12 net5_4 net5_3 6.2952
R13 net5 net5_4 127.497
R14 net5_2 net5_3 90.749
R15 net5_9 net5_4 98.7906
R16 net5_3 net5_11 70.7246
R17 BLB_0_1 BLB_0 151.187
R18 BL_1 BL_1_1 68.2426
R19 net8_3 net8 34.1846
R20 net8 net8_2 25.5109
R21 net8_4 net8_7 39.8169
R22 net8_6 net8_7 43.642
R23 net8_7 net8 44.6984
R24 net9_6 net9 34.1846
R25 net9 net9_5 25.5109
R26 net9_8 net9_2 29.5926
R27 net9_2 net9_7 30.1028
R28 net9_4 net9_3 6.2952
R29 net9 net9_4 127.497
R30 net9_2 net9_3 90.749
R31 net9_9 net9_4 98.7906
R32 net9_3 net9_11 70.7246
R33 BLB_1_1 BLB_1 151.187
R34 BL_2 BL_2_1 68.2426
R35 net12_3 net12 34.1846
R36 net12 net12_2 25.5109
R37 net12_4 net12_7 39.8169
R38 net12_6 net12_7 43.642
R39 net12_7 net12 44.6984
R40 net13_6 net13 34.1846
R41 net13 net13_5 25.5109
R42 net13_8 net13_2 29.5926
R43 net13_2 net13_7 30.1028
R44 net13_4 net13_3 6.2952
R45 net13 net13_4 127.497
R46 net13_2 net13_3 90.749
R47 net13_9 net13_4 98.7906
R48 net13_3 net13_11 70.7246
R49 BLB_2_1 BLB_2 151.187
R50 net15_3 net15 34.1846
R51 net15 net15_2 25.5109
R52 net15_4 net15_7 39.8169
R53 net15_6 net15_7 43.642
R54 net15_7 net15 44.6984
R55 net16_6 net16 34.1846
R56 net16 net16_5 25.5109
R57 net16_8 net16_2 29.5926
R58 net16_2 net16_7 30.1028
R59 net16_4 net16_3 6.2952
R60 net16 net16_4 127.497
R61 net16_2 net16_3 90.749
R62 net16_9 net16_4 98.7906
R63 net16_3 net16_11 70.7246
R64 BLB_3_1 BLB_3 151.187
R65 BL_4 BL_4_1 68.2426
R66 net19_3 net19 34.1846
R67 net19 net19_2 25.5109
R68 net19_4 net19_7 39.8169
R69 net19_6 net19_7 43.642
R70 net19_7 net19 44.6984
R71 net20_6 net20 34.1846
R72 net20 net20_5 25.5109
R73 net20_8 net20_2 29.5926
R74 net20_2 net20_7 30.1028
R75 net20_4 net20_3 6.2952
R76 net20 net20_4 127.497
R77 net20_2 net20_3 90.749
R78 net20_9 net20_4 98.7906
R79 net20_3 net20_11 70.7246
R80 BLB_4_1 BLB_4 151.187
R81 net22_3 net22 34.1846
R82 net22 net22_2 25.5109
R83 net22_4 net22_7 39.8169
R84 net22_6 net22_7 43.642
R85 net22_7 net22 44.6984
R86 net23_6 net23 34.1846
R87 net23 net23_5 25.5109
R88 net23_8 net23_2 29.5926
R89 net23_2 net23_7 30.1028
R90 net23_4 net23_3 6.2952
R91 net23 net23_4 127.497
R92 net23_2 net23_3 90.749
R93 net23_9 net23_4 98.7906
R94 net23_3 net23_11 70.7246
R95 BLB_5_1 BLB_5 151.187
R96 net25_3 net25 34.1846
R97 net25 net25_2 25.5109
R98 net25_4 net25_7 39.8169
R99 net25_6 net25_7 43.642
R100 net25_7 net25 44.6984
R101 net26_6 net26 34.1846
R102 net26 net26_5 25.5109
R103 net26_8 net26_2 29.5926
R104 net26_2 net26_7 30.1028
R105 net26_4 net26_3 6.2952
R106 net26 net26_4 127.497
R107 net26_2 net26_3 90.749
R108 net26_9 net26_4 98.7906
R109 net26_3 net26_11 70.7246
R110 BLB_6_1 BLB_6 151.187
R111 net28_3 net28 34.1846
R112 net28 net28_2 25.5109
R113 net28_4 net28_7 39.8169
R114 net28_6 net28_7 43.642
R115 net28_7 net28 44.6984
R116 net29_6 net29 34.1846
R117 net29 net29_5 25.5109
R118 net29_8 net29_2 29.5926
R119 net29_2 net29_7 30.1028
R120 net29_4 net29_3 6.2952
R121 net29 net29_4 127.497
R122 net29_2 net29_3 90.749
R123 net29_9 net29_4 98.7906
R124 net29_3 net29_11 70.7246
R125 BLB_7_1 BLB_7 151.187
R126 BL_0 BL_0_1 68.2426
R127 P_0_0_1 P_0_0_2 27.5015
R128 P_0_0_1 P_0_0_3 20.424
R129 P_0_0_4 P_0_0_1 45.6048
R130 P_0_0_5 P_0_0_2 68.5329
R131 P_0_0 P_0_0_2 43.5
R132 XB_0_0_3 XB_0_0_1 36.7357
R133 XB_0_0_1 XB_0_0_2 22.9598
R134 XB_0_0 XB_0_0_1 109.677
R135 P_0_1_2 P_0_1_1 27.5015
R136 P_0_1_1 P_0_1_3 20.424
R137 P_0_1_4 P_0_1_1 45.6048
R138 P_0_1_5 P_0_1_2 68.5329
R139 P_0_1 P_0_1_2 43.5
R140 XB_0_1_3 XB_0_1_1 36.7357
R141 XB_0_1_1 XB_0_1_2 22.9598
R142 XB_0_1 XB_0_1_1 109.677
R143 P_0_2_1 P_0_2_2 27.5015
R144 P_0_2_1 P_0_2_3 20.424
R145 P_0_2_4 P_0_2_1 45.6048
R146 P_0_2_5 P_0_2_2 68.5329
R147 P_0_2 P_0_2_2 43.5
R148 XB_0_2_3 XB_0_2_1 36.7357
R149 XB_0_2_1 XB_0_2_2 22.9598
R150 XB_0_2 XB_0_2_1 109.677
R151 BL_3 BL_3_1 68.2426
R152 P_0_3_1 P_0_3_2 27.5015
R153 P_0_3_1 P_0_3_3 20.424
R154 P_0_3_4 P_0_3_1 45.6048
R155 P_0_3_5 P_0_3_2 68.5329
R156 P_0_3 P_0_3_2 43.5
R157 XB_0_3_3 XB_0_3_1 36.7357
R158 XB_0_3_1 XB_0_3_2 22.9598
R159 XB_0_3 XB_0_3_1 109.677
R160 P_0_4_1 P_0_4_2 27.5015
R161 P_0_4_1 P_0_4_3 20.424
R162 P_0_4_4 P_0_4_1 45.6048
R163 P_0_4_5 P_0_4_2 68.5329
R164 P_0_4 P_0_4_2 43.5
R165 XB_0_4_3 XB_0_4_1 36.7357
R166 XB_0_4_1 XB_0_4_2 22.9598
R167 XB_0_4 XB_0_4_1 109.677
R168 BL_5 BL_5_1 68.2426
R169 P_0_5_1 P_0_5_2 27.5015
R170 P_0_5_1 P_0_5_3 20.424
R171 P_0_5_4 P_0_5_1 45.6048
R172 P_0_5_5 P_0_5_2 68.5329
R173 P_0_5 P_0_5_2 43.5
R174 XB_0_5_3 XB_0_5_1 36.7357
R175 XB_0_5_1 XB_0_5_2 22.9598
R176 XB_0_5 XB_0_5_1 109.677
R177 P_0_6_1 P_0_6_2 27.5015
R178 P_0_6_1 P_0_6_3 20.424
R179 P_0_6_4 P_0_6_1 45.6048
R180 P_0_6_5 P_0_6_2 68.5329
R181 P_0_6 P_0_6_2 43.5
R182 XB_0_6_3 XB_0_6_1 36.7357
R183 XB_0_6_1 XB_0_6_2 22.9598
R184 XB_0_6 XB_0_6_1 109.677
R185 P_0_7_1 P_0_7_2 27.5015
R186 P_0_7_1 P_0_7_3 20.424
R187 P_0_7_4 P_0_7_1 45.6048
R188 P_0_7_5 P_0_7_2 68.5329
R189 P_0_7 P_0_7_2 43.5
R190 XB_0_7_3 XB_0_7_1 36.7357
R191 XB_0_7_1 XB_0_7_2 22.9598
R192 XB_0_7 XB_0_7_1 109.677
R193 WL_0 WL_0_9 35.4396
R194 WL_0_9 WL_0_10 125.904
R195 WL_0_10 WL_0_11 125.904
R196 WL_0_11 WL_0_12 125.904
R197 WL_0_12 WL_0_13 125.904
R198 WL_0_13 WL_0_14 125.904
R199 WL_0_14 WL_0_15 125.904
R200 WL_0_1 WL_0_9 38.915
R201 WL_0_2 WL_0_10 38.915
R202 WL_0_3 WL_0_11 38.915
R203 WL_0_4 WL_0_12 38.915
R204 WL_0_5 WL_0_13 38.915
R205 WL_0_6 WL_0_14 38.915
R206 WL_0_7 WL_0_15 38.915
R207 WL_0_16 WL_0_1 83.7722
R208 WL_0_17 WL_0_1 84.6073
R209 WL_0_18 WL_0_2 83.7722
R210 WL_0_19 WL_0_2 84.6073
R211 WL_0_20 WL_0_3 83.7722
R212 WL_0_21 WL_0_3 84.6073
R213 WL_0_22 WL_0_4 83.7722
R214 WL_0_23 WL_0_4 84.6073
R215 WL_0_24 WL_0_5 83.7722
R216 WL_0_25 WL_0_5 84.6073
R217 WL_0_26 WL_0_6 83.7722
R218 WL_0_27 WL_0_6 84.6073
R219 WL_0_28 WL_0_7 83.7722
R220 WL_0_29 WL_0_7 84.6073
R221 WL_0_30 WL_0_8 83.7722
R222 WL_0_31 WL_0_8 84.6073
R223 WL_0_15 WL_0_8 164.819
C1 BLB_0 BLB_1_1 9.28969e-05f
C2 BLB_0 BLB_2_1 1.91734e-05f
C3 BLB_0 BLB_3_1 1.07558e-05f
C4 BLB_0 BL_0 0.000299138f
C5 BLB_0 BL_1 0.00284388f
C6 BLB_0 BL_2 4.20211e-05f
C7 BLB_0 BL_3 1.56256e-05f
C8 BLB_0 P_0_0_4 0.00155856f
C9 BLB_0 P_0_0_5 0.00306102f
C10 BLB_0 P_0_1 1.19064e-05f
C11 BLB_0 P_0_1_1 2.55054e-05f
C12 BLB_0 P_0_1_2 4.64001e-05f
C13 BLB_0 P_0_1_4 1.03773e-05f
C14 BLB_0 P_0_1_5 2.0381e-05f
C15 BLB_0 P_0_2_2 1.15371e-05f
C16 BLB_0 VDD_1 0.000887706f
C17 BLB_0 VSS_0 0.0181713f
C18 BLB_0 WL_0_10 0.0013221f
C19 BLB_0 WL_0_11 0.00120191f
C20 BLB_0 WL_0_12 0.0013221f
C21 BLB_0 WL_0_13 0.0013221f
C22 BLB_0 WL_0_14 0.0013221f
C23 BLB_0 WL_0_15 0.00288458f
C24 BLB_0 WL_0_18 0.000607818f
C25 BLB_0 WL_0_19 0.000607818f
C26 BLB_0 WL_0_2 0.000798231f
C27 BLB_0 WL_0_20 0.000607818f
C28 BLB_0 WL_0_21 0.000607818f
C29 BLB_0 WL_0_22 0.000607818f
C30 BLB_0 WL_0_23 0.000607818f
C31 BLB_0 WL_0_24 0.000607818f
C32 BLB_0 WL_0_25 0.000607818f
C33 BLB_0 WL_0_26 0.000607818f
C34 BLB_0 WL_0_27 0.000607818f
C35 BLB_0 WL_0_28 0.000607818f
C36 BLB_0 WL_0_29 0.000607818f
C37 BLB_0 WL_0_3 0.000798231f
C38 BLB_0 WL_0_30 0.000607818f
C39 BLB_0 WL_0_31 0.000607818f
C40 BLB_0 WL_0_4 0.000798231f
C41 BLB_0 WL_0_5 0.000798231f
C42 BLB_0 WL_0_6 0.000798231f
C43 BLB_0 WL_0_7 0.000798231f
C44 BLB_0 WL_0_8 0.000798231f
C45 BLB_0 XB_0_0 0.0021915f
C46 BLB_0 XB_0_0_1 0.00916135f
C47 BLB_0 XB_0_0_2 0.00129485f
C48 BLB_0 XB_0_0_3 0.0025897f
C49 BLB_0 XB_0_1_1 2.49056e-05f
C50 BLB_0 net5_2 0.00137869f
C51 BLB_0 net5_8 0.000602094f
C52 BLB_0 net68 7.41255e-05f
C53 BLB_0 net9 0.000135752f
C54 BLB_0 net9_11 7.95821e-05f
C55 BLB_0 net9_2 0.000117773f
C56 BLB_0 net9_3 0.000127843f
C57 BLB_0 net9_4 0.000128782f
C58 BLB_0 net9_5 5.14332e-05f
C59 BLB_0 net9_6 5.14332e-05f
C60 BLB_0 net9_7 2.57166e-05f
C61 BLB_0 net9_8 5.14332e-05f
C62 BLB_0 net9_9 0.000123662f
C63 BLB_0_1 BLB_1_1 0.000107438f
C64 BLB_0_1 BLB_2_1 2.21745e-05f
C65 BLB_0_1 BLB_3_1 1.24393e-05f
C66 BLB_0_1 BL_0_1 0.00034596f
C67 BLB_0_1 BL_1_1 0.00328902f
C68 BLB_0_1 BL_2 4.85984e-05f
C69 BLB_0_1 BL_3 1.80714e-05f
C70 BLB_0_1 P_0_0 0.00178822f
C71 BLB_0_1 P_0_0_1 0.00383065f
C72 BLB_0_1 P_0_0_2 0.00696881f
C73 BLB_0_1 P_0_0_3 0.000773143f
C74 BLB_0_1 VDD_1 0.00102665f
C75 BLB_0_1 VSS_0 0.0210155f
C76 BLB_0_1 WL_0 0.000305467f
C77 BLB_0_1 WL_0_1 0.000733146f
C78 BLB_0_1 WL_0_16 0.000607818f
C79 BLB_0_1 WL_0_17 0.000607818f
C80 BLB_0_1 WL_0_9 0.000841337f
C81 BLB_0_1 net4 3.16728e-05f
C82 BLB_0_1 net4_2 4.12568e-05f
C83 BLB_0_1 net4_3 4.12568e-05f
C84 BLB_0_1 net4_4 7.0237e-05f
C85 BLB_0_1 net4_6 2.98815e-05f
C86 BLB_0_1 net4_7 0.000106793f
C87 BLB_0_1 net5 0.00158915f
C88 BLB_0_1 net5_11 0.000931614f
C89 BLB_0_1 net5_3 0.00149658f
C90 BLB_0_1 net5_4 0.00150757f
C91 BLB_0_1 net5_5 0.000602094f
C92 BLB_0_1 net5_6 0.000602094f
C93 BLB_0_1 net5_7 0.000301047f
C94 BLB_0_1 net5_9 0.00144762f
C95 BLB_0_1 net68 8.5728e-05f
C96 BLB_1 BLB_2_1 8.78796e-05f
C97 BLB_1 BLB_3_1 1.88737e-05f
C98 BLB_1 BLB_4_1 1.02277e-05f
C99 BLB_1 BL_0 3.63774e-05f
C100 BLB_1 BL_2 0.00284394f
C101 BLB_1 BL_3 4.2419e-05f
C102 BLB_1 BL_4 1.5585e-05f
C103 BLB_1 P_0_1_4 0.00155979f
C104 BLB_1 P_0_1_5 0.00306344f
C105 BLB_1 P_0_2 1.08464e-05f
C106 BLB_1 P_0_2_1 2.32346e-05f
C107 BLB_1 P_0_2_2 4.22689e-05f
C108 BLB_1 P_0_2_5 1.85664e-05f
C109 BLB_1 P_0_3_2 1.20016e-05f
C110 BLB_1 VDD_1 0.000934045f
C111 BLB_1 VSS_0 0.0181129f
C112 BLB_1 WL_0_11 0.00119402f
C113 BLB_1 WL_0_12 0.00131342f
C114 BLB_1 WL_0_13 0.00131342f
C115 BLB_1 WL_0_14 0.00131342f
C116 BLB_1 WL_0_15 0.00286564f
C117 BLB_1 WL_0_20 0.000603825f
C118 BLB_1 WL_0_21 0.000603825f
C119 BLB_1 WL_0_22 0.000603825f
C120 BLB_1 WL_0_23 0.000603825f
C121 BLB_1 WL_0_24 0.000603825f
C122 BLB_1 WL_0_25 0.000603825f
C123 BLB_1 WL_0_26 0.000603825f
C124 BLB_1 WL_0_27 0.000603825f
C125 BLB_1 WL_0_28 0.000603825f
C126 BLB_1 WL_0_29 0.000603825f
C127 BLB_1 WL_0_3 0.000792988f
C128 BLB_1 WL_0_30 0.000603825f
C129 BLB_1 WL_0_31 0.000603825f
C130 BLB_1 WL_0_4 0.000792988f
C131 BLB_1 WL_0_5 0.000792988f
C132 BLB_1 WL_0_6 0.000792988f
C133 BLB_1 WL_0_7 0.000792988f
C134 BLB_1 WL_0_8 0.000792988f
C135 BLB_1 XB_0_1 0.00219316f
C136 BLB_1 XB_0_1_1 0.00916826f
C137 BLB_1 XB_0_1_2 0.00129583f
C138 BLB_1 XB_0_1_3 0.00259165f
C139 BLB_1 XB_0_2_1 2.4999e-05f
C140 BLB_1 net13 0.000123466f
C141 BLB_1 net13_11 7.23796e-05f
C142 BLB_1 net13_2 0.000107114f
C143 BLB_1 net13_3 0.000116273f
C144 BLB_1 net13_4 0.000117127f
C145 BLB_1 net13_5 4.67783e-05f
C146 BLB_1 net13_6 4.67783e-05f
C147 BLB_1 net13_7 2.33891e-05f
C148 BLB_1 net13_8 4.67783e-05f
C149 BLB_1 net13_9 0.00011247f
C150 BLB_1 net69 7.39342e-05f
C151 BLB_1 net9_2 0.00137877f
C152 BLB_1 net9_8 0.000602128f
C153 BLB_1_1 BLB_2_1 0.000101635f
C154 BLB_1_1 BLB_3_1 2.18279e-05f
C155 BLB_1_1 BLB_4_1 1.18285e-05f
C156 BLB_1_1 BL_0_1 4.20714e-05f
C157 BLB_1_1 BL_1 0.000322457f
C158 BLB_1_1 BL_1_1 0.000240649f
C159 BLB_1_1 BL_2_1 0.00328909f
C160 BLB_1_1 BL_3 4.90586e-05f
C161 BLB_1_1 BL_4 1.80244e-05f
C162 BLB_1_1 P_0_0_2 1.40493e-05f
C163 BLB_1_1 P_0_1 0.00178964f
C164 BLB_1_1 P_0_1_1 0.00383369f
C165 BLB_1_1 P_0_1_2 0.00697433f
C166 BLB_1_1 P_0_1_3 0.000773756f
C167 BLB_1_1 VDD_1 0.00108025f
C168 BLB_1_1 VSS_0 0.0209481f
C169 BLB_1_1 WL_0 0.000303461f
C170 BLB_1_1 WL_0_1 0.000728331f
C171 BLB_1_1 WL_0_10 0.00131342f
C172 BLB_1_1 WL_0_16 0.000603825f
C173 BLB_1_1 WL_0_17 0.000603825f
C174 BLB_1_1 WL_0_18 0.000603825f
C175 BLB_1_1 WL_0_19 0.000603825f
C176 BLB_1_1 WL_0_2 0.000792988f
C177 BLB_1_1 WL_0_9 0.000835811f
C178 BLB_1_1 XB_0_0_1 2.44079e-05f
C179 BLB_1_1 net5 1.11039e-05f
C180 BLB_1_1 net5_3 1.0457e-05f
C181 BLB_1_1 net5_4 1.05338e-05f
C182 BLB_1_1 net5_9 1.0115e-05f
C183 BLB_1_1 net69 8.55068e-05f
C184 BLB_1_1 net8 3.18049e-05f
C185 BLB_1_1 net8_2 4.14289e-05f
C186 BLB_1_1 net8_3 4.14289e-05f
C187 BLB_1_1 net8_4 7.05299e-05f
C188 BLB_1_1 net8_6 3.00061e-05f
C189 BLB_1_1 net8_7 0.000107238f
C190 BLB_1_1 net9 0.00158925f
C191 BLB_1_1 net9_11 0.000931667f
C192 BLB_1_1 net9_3 0.00149666f
C193 BLB_1_1 net9_4 0.00150765f
C194 BLB_1_1 net9_5 0.000602128f
C195 BLB_1_1 net9_6 0.000602128f
C196 BLB_1_1 net9_7 0.000301064f
C197 BLB_1_1 net9_9 0.00144771f
C198 BLB_2 BLB_3_1 8.44101e-05f
C199 BLB_2 BLB_4_1 1.96166e-05f
C200 BLB_2 BLB_5_1 1.04868e-05f
C201 BLB_2 BL_0 1.5772e-05f
C202 BLB_2 BL_3 0.00283709f
C203 BLB_2 BL_4 4.18419e-05f
C204 BLB_2 BL_5 1.59863e-05f
C205 BLB_2 P_0_2_4 0.00155936f
C206 BLB_2 P_0_2_5 0.00306258f
C207 BLB_2 P_0_3 1.12733e-05f
C208 BLB_2 P_0_3_1 2.41491e-05f
C209 BLB_2 P_0_3_2 4.39325e-05f
C210 BLB_2 P_0_3_5 1.92972e-05f
C211 BLB_2 P_0_4_2 1.2627e-05f
C212 BLB_2 VDD_1 0.000936305f
C213 BLB_2 VSS_0 0.0180542f
C214 BLB_2 WL_0_12 0.00132437f
C215 BLB_2 WL_0_13 0.00132437f
C216 BLB_2 WL_0_14 0.00132437f
C217 BLB_2 WL_0_15 0.00288953f
C218 BLB_2 WL_0_22 0.000608861f
C219 BLB_2 WL_0_23 0.000608861f
C220 BLB_2 WL_0_24 0.000608861f
C221 BLB_2 WL_0_25 0.000608861f
C222 BLB_2 WL_0_26 0.000608861f
C223 BLB_2 WL_0_27 0.000608861f
C224 BLB_2 WL_0_28 0.000608861f
C225 BLB_2 WL_0_29 0.000608861f
C226 BLB_2 WL_0_30 0.000608861f
C227 BLB_2 WL_0_31 0.000608861f
C228 BLB_2 WL_0_4 0.000799601f
C229 BLB_2 WL_0_5 0.000799601f
C230 BLB_2 WL_0_6 0.000799601f
C231 BLB_2 WL_0_7 0.000799601f
C232 BLB_2 WL_0_8 0.000799601f
C233 BLB_2 XB_0_2 0.0021996f
C234 BLB_2 XB_0_2_1 0.0091952f
C235 BLB_2 XB_0_2_2 0.00129963f
C236 BLB_2 XB_0_2_3 0.00259927f
C237 BLB_2 XB_0_3_1 2.40356e-05f
C238 BLB_2 net13_2 0.00137895f
C239 BLB_2 net13_8 0.000602209f
C240 BLB_2 net16 0.00012824f
C241 BLB_2 net16_11 7.51782e-05f
C242 BLB_2 net16_2 0.000111256f
C243 BLB_2 net16_3 0.000120769f
C244 BLB_2 net16_4 0.000121656f
C245 BLB_2 net16_5 4.8587e-05f
C246 BLB_2 net16_6 4.8587e-05f
C247 BLB_2 net16_7 2.42935e-05f
C248 BLB_2 net16_8 4.8587e-05f
C249 BLB_2 net16_9 0.000116819f
C250 BLB_2 net70 7.29567e-05f
C251 BLB_2_1 BLB_3_1 9.76224e-05f
C252 BLB_2_1 BLB_4_1 2.26871e-05f
C253 BLB_2_1 BLB_5_1 1.21282e-05f
C254 BLB_2_1 BL_0_1 1.82408e-05f
C255 BLB_2_1 BL_1 3.29048e-05f
C256 BLB_2_1 BL_1_1 2.45567e-05f
C257 BLB_2_1 BL_2 0.000321647f
C258 BLB_2_1 BL_2_1 0.000240044f
C259 BLB_2_1 BL_3_1 0.00328117f
C260 BLB_2_1 BL_4 4.83912e-05f
C261 BLB_2_1 BL_5 1.84885e-05f
C262 BLB_2_1 P_0_1_2 1.11585e-05f
C263 BLB_2_1 P_0_2 0.00178914f
C264 BLB_2_1 P_0_2_1 0.00383261f
C265 BLB_2_1 P_0_2_2 0.00697237f
C266 BLB_2_1 P_0_2_3 0.000773539f
C267 BLB_2_1 VDD_1 0.00108286f
C268 BLB_2_1 VSS_0 0.0208801f
C269 BLB_2_1 WL_0 0.000305991f
C270 BLB_2_1 WL_0_1 0.000734405f
C271 BLB_2_1 WL_0_10 0.00132437f
C272 BLB_2_1 WL_0_11 0.00120397f
C273 BLB_2_1 WL_0_16 0.000608861f
C274 BLB_2_1 WL_0_17 0.000608861f
C275 BLB_2_1 WL_0_18 0.000608861f
C276 BLB_2_1 WL_0_19 0.000608861f
C277 BLB_2_1 WL_0_2 0.000799601f
C278 BLB_2_1 WL_0_20 0.000608861f
C279 BLB_2_1 WL_0_21 0.000608861f
C280 BLB_2_1 WL_0_3 0.000799601f
C281 BLB_2_1 WL_0_9 0.000842781f
C282 BLB_2_1 XB_0_1_1 1.07874e-05f
C283 BLB_2_1 net12 3.26448e-05f
C284 BLB_2_1 net12_2 4.25229e-05f
C285 BLB_2_1 net12_3 4.25229e-05f
C286 BLB_2_1 net12_4 7.23923e-05f
C287 BLB_2_1 net12_6 3.07985e-05f
C288 BLB_2_1 net12_7 0.00011007f
C289 BLB_2_1 net13 0.00158946f
C290 BLB_2_1 net13_11 0.000931792f
C291 BLB_2_1 net13_3 0.00149686f
C292 BLB_2_1 net13_4 0.00150785f
C293 BLB_2_1 net13_5 0.000602209f
C294 BLB_2_1 net13_6 0.000602209f
C295 BLB_2_1 net13_7 0.000301104f
C296 BLB_2_1 net13_9 0.0014479f
C297 BLB_2_1 net70 8.43763e-05f
C298 BLB_3 BLB_4_1 8.66174e-05f
C299 BLB_3 BLB_5_1 1.95998e-05f
C300 BLB_3 BL_0 1.01675e-05f
C301 BLB_3 BL_3 0.000255819f
C302 BLB_3 BL_4 0.00283431f
C303 BLB_3 BL_5 4.19494e-05f
C304 BLB_3 BL_6 1.84113e-05f
C305 BLB_3 BL_6_1 1.37402e-05f
C306 BLB_3 P_0_3_4 0.00155909f
C307 BLB_3 P_0_3_5 0.00306206f
C308 BLB_3 P_0_4 1.1237e-05f
C309 BLB_3 P_0_4_1 2.40714e-05f
C310 BLB_3 P_0_4_2 4.37913e-05f
C311 BLB_3 P_0_4_5 1.92351e-05f
C312 BLB_3 P_0_5_2 1.16805e-05f
C313 BLB_3 VDD_1 0.000907108f
C314 BLB_3 VSS_0 0.0180937f
C315 BLB_3 WL_0_13 0.00132427f
C316 BLB_3 WL_0_14 0.00132427f
C317 BLB_3 WL_0_15 0.00288931f
C318 BLB_3 WL_0_24 0.000608814f
C319 BLB_3 WL_0_25 0.000608814f
C320 BLB_3 WL_0_26 0.000608814f
C321 BLB_3 WL_0_27 0.000608814f
C322 BLB_3 WL_0_28 0.000608814f
C323 BLB_3 WL_0_29 0.000608814f
C324 BLB_3 WL_0_30 0.000608814f
C325 BLB_3 WL_0_31 0.000608814f
C326 BLB_3 WL_0_5 0.00079954f
C327 BLB_3 WL_0_6 0.00079954f
C328 BLB_3 WL_0_7 0.00079954f
C329 BLB_3 WL_0_8 0.00079954f
C330 BLB_3 XB_0_3 0.00219783f
C331 BLB_3 XB_0_3_1 0.0091878f
C332 BLB_3 XB_0_3_2 0.00129859f
C333 BLB_3 XB_0_3_3 0.00259718f
C334 BLB_3 XB_0_4_1 3.25089e-05f
C335 BLB_3 net16_2 0.00137636f
C336 BLB_3 net16_8 0.000601075f
C337 BLB_3 net20 0.000125867f
C338 BLB_3 net20_11 7.37871e-05f
C339 BLB_3 net20_2 0.000109197f
C340 BLB_3 net20_3 0.000118534f
C341 BLB_3 net20_4 0.000119405f
C342 BLB_3 net20_5 4.7688e-05f
C343 BLB_3 net20_6 4.7688e-05f
C344 BLB_3 net20_7 2.3844e-05f
C345 BLB_3 net20_8 4.7688e-05f
C346 BLB_3 net20_9 0.000114657f
C347 BLB_3 net71 7.35055e-05f
C348 BLB_3_1 BLB_4_1 0.000100175f
C349 BLB_3_1 BLB_5_1 2.26676e-05f
C350 BLB_3_1 BLB_6_1 1.12953e-05f
C351 BLB_3_1 BL_0_1 1.1759e-05f
C352 BLB_3_1 BL_1 1.46611e-05f
C353 BLB_3_1 BL_1_1 1.09415e-05f
C354 BLB_3_1 BL_2 3.16837e-05f
C355 BLB_3_1 BL_2_1 2.36454e-05f
C356 BLB_3_1 BL_3_1 0.000295861f
C357 BLB_3_1 BL_4_1 0.00327795f
C358 BLB_3_1 BL_5 4.85155e-05f
C359 BLB_3_1 P_0_3 0.00178883f
C360 BLB_3_1 P_0_3_1 0.00383196f
C361 BLB_3_1 P_0_3_2 0.00697119f
C362 BLB_3_1 P_0_3_3 0.000773408f
C363 BLB_3_1 VDD_1 0.00104909f
C364 BLB_3_1 VSS_0 0.0209259f
C365 BLB_3_1 WL_0 0.000305968f
C366 BLB_3_1 WL_0_1 0.000734348f
C367 BLB_3_1 WL_0_10 0.00132427f
C368 BLB_3_1 WL_0_11 0.00120388f
C369 BLB_3_1 WL_0_12 0.00132427f
C370 BLB_3_1 WL_0_16 0.000608814f
C371 BLB_3_1 WL_0_17 0.000608814f
C372 BLB_3_1 WL_0_18 0.000608814f
C373 BLB_3_1 WL_0_19 0.000608814f
C374 BLB_3_1 WL_0_2 0.00079954f
C375 BLB_3_1 WL_0_20 0.000608814f
C376 BLB_3_1 WL_0_21 0.000608814f
C377 BLB_3_1 WL_0_22 0.000608814f
C378 BLB_3_1 WL_0_23 0.000608814f
C379 BLB_3_1 WL_0_3 0.00079954f
C380 BLB_3_1 WL_0_4 0.00079954f
C381 BLB_3_1 WL_0_9 0.000842716f
C382 BLB_3_1 net13 1.15121e-05f
C383 BLB_3_1 net13_3 1.08414e-05f
C384 BLB_3_1 net13_4 1.09211e-05f
C385 BLB_3_1 net13_9 1.04868e-05f
C386 BLB_3_1 net15 3.30517e-05f
C387 BLB_3_1 net15_2 4.3053e-05f
C388 BLB_3_1 net15_3 4.3053e-05f
C389 BLB_3_1 net15_4 7.32949e-05f
C390 BLB_3_1 net15_6 3.11825e-05f
C391 BLB_3_1 net15_7 0.000111442f
C392 BLB_3_1 net16 0.00158647f
C393 BLB_3_1 net16_11 0.000930037f
C394 BLB_3_1 net16_3 0.00149404f
C395 BLB_3_1 net16_4 0.00150501f
C396 BLB_3_1 net16_5 0.000601075f
C397 BLB_3_1 net16_6 0.000601075f
C398 BLB_3_1 net16_7 0.000300537f
C399 BLB_3_1 net16_9 0.00144517f
C400 BLB_3_1 net71 8.5011e-05f
C401 BLB_4 BLB_5_1 8.46747e-05f
C402 BLB_4 BLB_6_1 1.95538e-05f
C403 BLB_4 BLB_7_1 1.24661e-05f
C404 BLB_4 BL_3 2.60429e-05f
C405 BLB_4 BL_5 0.00283068f
C406 BLB_4 BL_6 5.05999e-05f
C407 BLB_4 BL_6_1 3.77625e-05f
C408 BLB_4 BL_7 1.88283e-05f
C409 BLB_4 BL_7_1 1.40515e-05f
C410 BLB_4 P_0_4_4 0.00155574f
C411 BLB_4 P_0_4_5 0.00305547f
C412 BLB_4 P_0_5 1.20982e-05f
C413 BLB_4 P_0_5_1 2.59163e-05f
C414 BLB_4 P_0_5_2 4.71475e-05f
C415 BLB_4 P_0_5_4 1.05444e-05f
C416 BLB_4 P_0_5_5 2.07093e-05f
C417 BLB_4 P_0_6_2 1.15767e-05f
C418 BLB_4 VDD_1 0.000925473f
C419 BLB_4 VSS_0 0.0181202f
C420 BLB_4 WL_0_14 0.00130701f
C421 BLB_4 WL_0_15 0.00285166f
C422 BLB_4 WL_0_26 0.000600881f
C423 BLB_4 WL_0_27 0.000600881f
C424 BLB_4 WL_0_28 0.000600881f
C425 BLB_4 WL_0_29 0.000600881f
C426 BLB_4 WL_0_30 0.000600881f
C427 BLB_4 WL_0_31 0.000600881f
C428 BLB_4 WL_0_6 0.000789122f
C429 BLB_4 WL_0_7 0.000789122f
C430 BLB_4 WL_0_8 0.000789122f
C431 BLB_4 XB_0_4 0.00219684f
C432 BLB_4 XB_0_4_1 0.00918365f
C433 BLB_4 XB_0_4_2 0.001298f
C434 BLB_4 XB_0_4_3 0.002596f
C435 BLB_4 XB_0_5_1 2.71468e-05f
C436 BLB_4 net20_2 0.00137935f
C437 BLB_4 net20_8 0.000602382f
C438 BLB_4 net23 0.000131019f
C439 BLB_4 net23_11 7.68076e-05f
C440 BLB_4 net23_2 0.000113667f
C441 BLB_4 net23_3 0.000123386f
C442 BLB_4 net23_4 0.000124292f
C443 BLB_4 net23_5 4.96401e-05f
C444 BLB_4 net23_6 4.96401e-05f
C445 BLB_4 net23_7 2.482e-05f
C446 BLB_4 net23_8 4.96401e-05f
C447 BLB_4 net23_9 0.00011935f
C448 BLB_4 net72 7.17648e-05f
C449 BLB_4_1 BLB_5_1 9.79283e-05f
C450 BLB_4_1 BLB_6_1 2.26145e-05f
C451 BLB_4_1 BLB_7_1 1.44174e-05f
C452 BLB_4_1 BL_2 1.44306e-05f
C453 BLB_4_1 BL_2_1 1.07695e-05f
C454 BLB_4_1 BL_3_1 3.01192e-05f
C455 BLB_4_1 BL_4 0.000318206f
C456 BLB_4_1 BL_4_1 0.000237476f
C457 BLB_4_1 BL_5_1 0.00327375f
C458 BLB_4_1 P_0_4 0.00178499f
C459 BLB_4_1 P_0_4_1 0.00382372f
C460 BLB_4_1 P_0_4_2 0.00695619f
C461 BLB_4_1 P_0_4_3 0.000771744f
C462 BLB_4_1 VDD_1 0.00107033f
C463 BLB_4_1 VSS_0 0.0209564f
C464 BLB_4_1 WL_0 0.000301981f
C465 BLB_4_1 WL_0_1 0.000724779f
C466 BLB_4_1 WL_0_10 0.00130701f
C467 BLB_4_1 WL_0_11 0.00118819f
C468 BLB_4_1 WL_0_12 0.00130701f
C469 BLB_4_1 WL_0_13 0.00130701f
C470 BLB_4_1 WL_0_16 0.000600881f
C471 BLB_4_1 WL_0_17 0.000600881f
C472 BLB_4_1 WL_0_18 0.000600881f
C473 BLB_4_1 WL_0_19 0.000600881f
C474 BLB_4_1 WL_0_2 0.000789122f
C475 BLB_4_1 WL_0_20 0.000600881f
C476 BLB_4_1 WL_0_21 0.000600881f
C477 BLB_4_1 WL_0_22 0.000600881f
C478 BLB_4_1 WL_0_23 0.000600881f
C479 BLB_4_1 WL_0_24 0.000600881f
C480 BLB_4_1 WL_0_25 0.000600881f
C481 BLB_4_1 WL_0_3 0.000789122f
C482 BLB_4_1 WL_0_4 0.000789122f
C483 BLB_4_1 WL_0_5 0.000789122f
C484 BLB_4_1 WL_0_9 0.000831735f
C485 BLB_4_1 net19 2.94524e-05f
C486 BLB_4_1 net19_2 3.83646e-05f
C487 BLB_4_1 net19_3 3.83646e-05f
C488 BLB_4_1 net19_4 6.53131e-05f
C489 BLB_4_1 net19_6 2.77867e-05f
C490 BLB_4_1 net19_7 9.93065e-05f
C491 BLB_4_1 net20 0.00158991f
C492 BLB_4_1 net20_11 0.000932059f
C493 BLB_4_1 net20_3 0.00149729f
C494 BLB_4_1 net20_4 0.00150829f
C495 BLB_4_1 net20_5 0.000602382f
C496 BLB_4_1 net20_6 0.000602382f
C497 BLB_4_1 net20_7 0.000301191f
C498 BLB_4_1 net20_9 0.00144831f
C499 BLB_4_1 net72 8.29977e-05f
C500 BLB_5 BLB_6_1 8.72425e-05f
C501 BLB_5 BLB_7_1 2.62988e-05f
C502 BLB_5 BL_3 1.11758e-05f
C503 BLB_5 BL_5 0.000253797f
C504 BLB_5 BL_6 0.00350528f
C505 BLB_5 BL_6_1 0.00261598f
C506 BLB_5 BL_7 5.07413e-05f
C507 BLB_5 BL_7_1 3.7868e-05f
C508 BLB_5 P_0_5_4 0.00155335f
C509 BLB_5 P_0_5_5 0.00305079f
C510 BLB_5 P_0_6 1.25651e-05f
C511 BLB_5 P_0_6_1 2.69163e-05f
C512 BLB_5 P_0_6_2 4.89668e-05f
C513 BLB_5 P_0_6_4 1.09513e-05f
C514 BLB_5 P_0_6_5 2.15084e-05f
C515 BLB_5 P_0_7_2 1.15365e-05f
C516 BLB_5 VDD_1 0.000911812f
C517 BLB_5 VSS_0 0.0180857f
C518 BLB_5 WL_0_15 0.00286627f
C519 BLB_5 WL_0_28 0.000603959f
C520 BLB_5 WL_0_29 0.000603959f
C521 BLB_5 WL_0_30 0.000603959f
C522 BLB_5 WL_0_31 0.000603959f
C523 BLB_5 WL_0_7 0.000793164f
C524 BLB_5 WL_0_8 0.000793164f
C525 BLB_5 XB_0_5 0.00219907f
C526 BLB_5 XB_0_5_1 0.00919297f
C527 BLB_5 XB_0_5_2 0.00129932f
C528 BLB_5 XB_0_5_3 0.00259864f
C529 BLB_5 XB_0_6_1 2.52626e-05f
C530 BLB_5 net23_2 0.0013873f
C531 BLB_5 net23_8 0.000605856f
C532 BLB_5 net26 0.000136379f
C533 BLB_5 net26_11 7.99497e-05f
C534 BLB_5 net26_2 0.000118317f
C535 BLB_5 net26_3 0.000128434f
C536 BLB_5 net26_4 0.000129377f
C537 BLB_5 net26_5 5.16708e-05f
C538 BLB_5 net26_6 5.16708e-05f
C539 BLB_5 net26_7 2.58354e-05f
C540 BLB_5 net26_8 5.16708e-05f
C541 BLB_5 net26_9 0.000124233f
C542 BLB_5 net73 7.18473e-05f
C543 BLB_5_1 BLB_6_1 0.000100898f
C544 BLB_5_1 BLB_7_1 3.04152e-05f
C545 BLB_5_1 BL_3_1 1.29251e-05f
C546 BLB_5_1 BL_4 3.01632e-05f
C547 BLB_5_1 BL_4_1 2.25107e-05f
C548 BLB_5_1 BL_5_1 0.000293523f
C549 BLB_5_1 P_0_3_2 1.01279e-05f
C550 BLB_5_1 P_0_5 0.00178225f
C551 BLB_5_1 P_0_5_1 0.00381786f
C552 BLB_5_1 P_0_5_2 0.00694553f
C553 BLB_5_1 P_0_5_3 0.000770561f
C554 BLB_5_1 VDD_1 0.00105453f
C555 BLB_5_1 VSS_0 0.0209166f
C556 BLB_5_1 WL_0 0.000303528f
C557 BLB_5_1 WL_0_1 0.000728492f
C558 BLB_5_1 WL_0_10 0.00131371f
C559 BLB_5_1 WL_0_11 0.00119428f
C560 BLB_5_1 WL_0_12 0.00131371f
C561 BLB_5_1 WL_0_13 0.00131371f
C562 BLB_5_1 WL_0_14 0.00131371f
C563 BLB_5_1 WL_0_16 0.000603959f
C564 BLB_5_1 WL_0_17 0.000603959f
C565 BLB_5_1 WL_0_18 0.000603959f
C566 BLB_5_1 WL_0_19 0.000603959f
C567 BLB_5_1 WL_0_2 0.000793164f
C568 BLB_5_1 WL_0_20 0.000603959f
C569 BLB_5_1 WL_0_21 0.000603959f
C570 BLB_5_1 WL_0_22 0.000603959f
C571 BLB_5_1 WL_0_23 0.000603959f
C572 BLB_5_1 WL_0_24 0.000603959f
C573 BLB_5_1 WL_0_25 0.000603959f
C574 BLB_5_1 WL_0_26 0.000603959f
C575 BLB_5_1 WL_0_27 0.000603959f
C576 BLB_5_1 WL_0_3 0.000793164f
C577 BLB_5_1 WL_0_4 0.000793164f
C578 BLB_5_1 WL_0_5 0.000793164f
C579 BLB_5_1 WL_0_6 0.000793164f
C580 BLB_5_1 WL_0_9 0.000835996f
C581 BLB_5_1 net22 3.11766e-05f
C582 BLB_5_1 net22_2 4.06105e-05f
C583 BLB_5_1 net22_3 4.06105e-05f
C584 BLB_5_1 net22_4 6.91366e-05f
C585 BLB_5_1 net22_6 2.94134e-05f
C586 BLB_5_1 net22_7 0.00010512f
C587 BLB_5_1 net23 0.00159908f
C588 BLB_5_1 net23_11 0.000937435f
C589 BLB_5_1 net23_3 0.00150593f
C590 BLB_5_1 net23_4 0.00151699f
C591 BLB_5_1 net23_5 0.000605856f
C592 BLB_5_1 net23_6 0.000605856f
C593 BLB_5_1 net23_7 0.000302928f
C594 BLB_5_1 net23_9 0.00145667f
C595 BLB_5_1 net73 8.30932e-05f
C596 BLB_6 BLB_7_1 0.000103085f
C597 BLB_6 BL_5 2.38731e-05f
C598 BLB_6 BL_7 0.00350045f
C599 BLB_6 BL_7_1 0.00261238f
C600 BLB_6 P_0_6_4 0.00155564f
C601 BLB_6 P_0_6_5 0.00305528f
C602 BLB_6 P_0_7 1.21593e-05f
C603 BLB_6 P_0_7_1 2.60471e-05f
C604 BLB_6 P_0_7_2 4.73855e-05f
C605 BLB_6 P_0_7_4 1.05977e-05f
C606 BLB_6 P_0_7_5 2.08138e-05f
C607 BLB_6 VDD_1 0.000897632f
C608 BLB_6 VSS_0 0.0181636f
C609 BLB_6 WL_0_30 0.000604457f
C610 BLB_6 WL_0_31 0.000604457f
C611 BLB_6 WL_0_8 0.000793818f
C612 BLB_6 XB_0_6 0.00219466f
C613 BLB_6 XB_0_6_1 0.00917454f
C614 BLB_6 XB_0_6_2 0.00129671f
C615 BLB_6 XB_0_6_3 0.00259343f
C616 BLB_6 XB_0_7_1 3.04763e-05f
C617 BLB_6 net26_2 0.00136971f
C618 BLB_6 net26_8 0.000598173f
C619 BLB_6 net28 1.20986e-05f
C620 BLB_6 net28_2 1.57595e-05f
C621 BLB_6 net28_3 1.57595e-05f
C622 BLB_6 net28_4 2.68296e-05f
C623 BLB_6 net28_6 1.14143e-05f
C624 BLB_6 net28_7 4.07935e-05f
C625 BLB_6 net29 0.000129991f
C626 BLB_6 net29_11 7.6205e-05f
C627 BLB_6 net29_2 0.000112775f
C628 BLB_6 net29_3 0.000122418f
C629 BLB_6 net29_4 0.000123317f
C630 BLB_6 net29_5 4.92506e-05f
C631 BLB_6 net29_6 4.92506e-05f
C632 BLB_6 net29_7 2.46253e-05f
C633 BLB_6 net29_8 4.92506e-05f
C634 BLB_6 net29_9 0.000118414f
C635 BLB_6 net74 7.38693e-05f
C636 BLB_6_1 BLB_7_1 0.000119221f
C637 BLB_6_1 BL_4 1.39033e-05f
C638 BLB_6_1 BL_4_1 1.0376e-05f
C639 BLB_6_1 BL_5_1 2.76099e-05f
C640 BLB_6_1 BL_6 0.000328522f
C641 BLB_6_1 BL_6_1 0.000245174f
C642 BLB_6_1 P_0_6 0.00178487f
C643 BLB_6_1 P_0_6_1 0.00382347f
C644 BLB_6_1 P_0_6_2 0.00695575f
C645 BLB_6_1 P_0_6_3 0.000771694f
C646 BLB_6_1 VDD_1 0.00103813f
C647 BLB_6_1 VSS_0 0.0210066f
C648 BLB_6_1 WL_0 0.000303778f
C649 BLB_6_1 WL_0_1 0.000729093f
C650 BLB_6_1 WL_0_10 0.00131479f
C651 BLB_6_1 WL_0_11 0.00119526f
C652 BLB_6_1 WL_0_12 0.00131479f
C653 BLB_6_1 WL_0_13 0.00131479f
C654 BLB_6_1 WL_0_14 0.00131479f
C655 BLB_6_1 WL_0_15 0.00286863f
C656 BLB_6_1 WL_0_16 0.000604457f
C657 BLB_6_1 WL_0_17 0.000604457f
C658 BLB_6_1 WL_0_18 0.000604457f
C659 BLB_6_1 WL_0_19 0.000604457f
C660 BLB_6_1 WL_0_2 0.000793818f
C661 BLB_6_1 WL_0_20 0.000604457f
C662 BLB_6_1 WL_0_21 0.000604457f
C663 BLB_6_1 WL_0_22 0.000604457f
C664 BLB_6_1 WL_0_23 0.000604457f
C665 BLB_6_1 WL_0_24 0.000604457f
C666 BLB_6_1 WL_0_25 0.000604457f
C667 BLB_6_1 WL_0_26 0.000604457f
C668 BLB_6_1 WL_0_27 0.000604457f
C669 BLB_6_1 WL_0_28 0.000604457f
C670 BLB_6_1 WL_0_29 0.000604457f
C671 BLB_6_1 WL_0_3 0.000793818f
C672 BLB_6_1 WL_0_4 0.000793818f
C673 BLB_6_1 WL_0_5 0.000793818f
C674 BLB_6_1 WL_0_6 0.000793818f
C675 BLB_6_1 WL_0_7 0.000793818f
C676 BLB_6_1 WL_0_9 0.000836685f
C677 BLB_6_1 net25 3.24694e-05f
C678 BLB_6_1 net25_2 4.22944e-05f
C679 BLB_6_1 net25_3 4.22944e-05f
C680 BLB_6_1 net25_4 7.20034e-05f
C681 BLB_6_1 net25_6 3.0633e-05f
C682 BLB_6_1 net25_7 0.000109479f
C683 BLB_6_1 net26 0.00157881f
C684 BLB_6_1 net26_11 0.000925548f
C685 BLB_6_1 net26_3 0.00148683f
C686 BLB_6_1 net26_4 0.00149775f
C687 BLB_6_1 net26_5 0.000598173f
C688 BLB_6_1 net26_6 0.000598173f
C689 BLB_6_1 net26_7 0.000299087f
C690 BLB_6_1 net26_9 0.0014382f
C691 BLB_6_1 net74 8.54317e-05f
C692 BLB_7 BL_5 1.42996e-05f
C693 BLB_7 P_0_7_4 0.00156911f
C694 BLB_7 P_0_7_5 0.00308174f
C695 BLB_7 VDD_1 0.000925946f
C696 BLB_7 VSS_0 0.0201677f
C697 BLB_7 XB_0_7 0.00229706f
C698 BLB_7 XB_0_7_1 0.00960263f
C699 BLB_7 XB_0_7_2 0.00135722f
C700 BLB_7 XB_0_7_3 0.00271444f
C701 BLB_7 net29_2 0.00135868f
C702 BLB_7 net29_8 0.000593355f
C703 BLB_7 net75 7.68278e-05f
C704 BLB_7_1 BL_4 1.12918e-05f
C705 BLB_7_1 BL_5_1 1.65378e-05f
C706 BLB_7_1 BL_6 3.61897e-05f
C707 BLB_7_1 BL_6_1 2.70083e-05f
C708 BLB_7_1 BL_7 0.000369565f
C709 BLB_7_1 BL_7_1 0.000275805f
C710 BLB_7_1 P_0_5_2 1.01167e-05f
C711 BLB_7_1 P_0_6_2 1.42799e-05f
C712 BLB_7_1 P_0_7 0.00180033f
C713 BLB_7_1 P_0_7_1 0.00385659f
C714 BLB_7_1 P_0_7_2 0.007016f
C715 BLB_7_1 P_0_7_3 0.000778378f
C716 BLB_7_1 VDD_1 0.00107088f
C717 BLB_7_1 VSS_0 0.0233244f
C718 BLB_7_1 WL_0 0.000303091f
C719 BLB_7_1 WL_0_1 0.000727444f
C720 BLB_7_1 WL_0_10 0.00131182f
C721 BLB_7_1 WL_0_11 0.00119256f
C722 BLB_7_1 WL_0_12 0.00131182f
C723 BLB_7_1 WL_0_13 0.00131182f
C724 BLB_7_1 WL_0_14 0.00131182f
C725 BLB_7_1 WL_0_15 0.00286215f
C726 BLB_7_1 WL_0_16 0.00060309f
C727 BLB_7_1 WL_0_17 0.00060309f
C728 BLB_7_1 WL_0_18 0.00060309f
C729 BLB_7_1 WL_0_19 0.00060309f
C730 BLB_7_1 WL_0_2 0.000792023f
C731 BLB_7_1 WL_0_20 0.00060309f
C732 BLB_7_1 WL_0_21 0.00060309f
C733 BLB_7_1 WL_0_22 0.00060309f
C734 BLB_7_1 WL_0_23 0.00060309f
C735 BLB_7_1 WL_0_24 0.00060309f
C736 BLB_7_1 WL_0_25 0.00060309f
C737 BLB_7_1 WL_0_26 0.00060309f
C738 BLB_7_1 WL_0_27 0.00060309f
C739 BLB_7_1 WL_0_28 0.00060309f
C740 BLB_7_1 WL_0_29 0.00060309f
C741 BLB_7_1 WL_0_3 0.000792023f
C742 BLB_7_1 WL_0_30 0.00060309f
C743 BLB_7_1 WL_0_31 0.00060309f
C744 BLB_7_1 WL_0_4 0.000792023f
C745 BLB_7_1 WL_0_5 0.000792023f
C746 BLB_7_1 WL_0_6 0.000792023f
C747 BLB_7_1 WL_0_7 0.000792023f
C748 BLB_7_1 WL_0_8 0.000792023f
C749 BLB_7_1 WL_0_9 0.000834793f
C750 BLB_7_1 net26 1.32672e-05f
C751 BLB_7_1 net26_2 1.15101e-05f
C752 BLB_7_1 net26_3 1.24943e-05f
C753 BLB_7_1 net26_4 1.2586e-05f
C754 BLB_7_1 net26_9 1.20856e-05f
C755 BLB_7_1 net28 3.14652e-05f
C756 BLB_7_1 net28_2 4.09863e-05f
C757 BLB_7_1 net28_3 4.09863e-05f
C758 BLB_7_1 net28_4 6.97765e-05f
C759 BLB_7_1 net28_6 2.96856e-05f
C760 BLB_7_1 net28_7 0.000106093f
C761 BLB_7_1 net29 0.00156609f
C762 BLB_7_1 net29_11 0.000918092f
C763 BLB_7_1 net29_3 0.00147485f
C764 BLB_7_1 net29_4 0.00148568f
C765 BLB_7_1 net29_5 0.000593355f
C766 BLB_7_1 net29_6 0.000593355f
C767 BLB_7_1 net29_7 0.000296677f
C768 BLB_7_1 net29_9 0.00142661f
C769 BLB_7_1 net75 8.88532e-05f
C770 BL_0 BL_3 1.37185e-05f
C771 BL_0 P_0_0 3.39535e-05f
C772 BL_0 P_0_0_2 0.000132319f
C773 BL_0 P_0_0_5 5.81205e-05f
C774 BL_0 VDD_1 0.00114807f
C775 BL_0 VSS_0 0.0232102f
C776 BL_0 WL_0 0.000299725f
C777 BL_0 WL_0_1 0.000719365f
C778 BL_0 WL_0_10 0.00129725f
C779 BL_0 WL_0_11 0.00117932f
C780 BL_0 WL_0_12 0.00129725f
C781 BL_0 WL_0_2 0.000783227f
C782 BL_0 WL_0_3 0.000783227f
C783 BL_0 WL_0_4 0.000783227f
C784 BL_0 WL_0_9 0.000825522f
C785 BL_0 XB_0_0_1 6.97599e-05f
C786 BL_0 XB_0_0_3 1.97195e-05f
C787 BL_0 net4 0.000585424f
C788 BL_0 net4_3 0.00076257f
C789 BL_0 net4_6 0.000552315f
C790 BL_0 net4_7 0.00197391f
C791 BL_0 net5 0.00162009f
C792 BL_0 net5_11 0.00094975f
C793 BL_0 net5_2 0.00140553f
C794 BL_0 net5_3 0.00152571f
C795 BL_0 net5_4 0.00153691f
C796 BL_0 net5_6 0.000613815f
C797 BL_0 net5_8 0.000613815f
C798 BL_0_1 BL_1 0.000102033f
C799 BL_0_1 BL_1_1 7.61471e-05f
C800 BL_0_1 BL_2 2.90157e-05f
C801 BL_0_1 BL_2_1 2.16543e-05f
C802 BL_0_1 BL_3 1.02381e-05f
C803 BL_0_1 P_0_0_1 7.27338e-05f
C804 BL_0_1 P_0_0_3 1.46799e-05f
C805 BL_0_1 P_0_0_4 2.95928e-05f
C806 BL_0_1 P_0_1_2 1.60996e-05f
C807 BL_0_1 VDD_1 0.000856798f
C808 BL_0_1 VSS_0 0.0173217f
C809 BL_0_1 WL_0_13 0.00129725f
C810 BL_0_1 WL_0_14 0.00129725f
C811 BL_0_1 WL_0_15 0.00283036f
C812 BL_0_1 WL_0_16 0.000596392f
C813 BL_0_1 WL_0_17 0.000596392f
C814 BL_0_1 WL_0_18 0.000596392f
C815 BL_0_1 WL_0_19 0.000596392f
C816 BL_0_1 WL_0_20 0.000596392f
C817 BL_0_1 WL_0_21 0.000596392f
C818 BL_0_1 WL_0_22 0.000596392f
C819 BL_0_1 WL_0_23 0.000596392f
C820 BL_0_1 WL_0_24 0.000596392f
C821 BL_0_1 WL_0_25 0.000596392f
C822 BL_0_1 WL_0_26 0.000596392f
C823 BL_0_1 WL_0_27 0.000596392f
C824 BL_0_1 WL_0_28 0.000596392f
C825 BL_0_1 WL_0_29 0.000596392f
C826 BL_0_1 WL_0_30 0.000596392f
C827 BL_0_1 WL_0_31 0.000596392f
C828 BL_0_1 WL_0_5 0.000783227f
C829 BL_0_1 WL_0_6 0.000783227f
C830 BL_0_1 WL_0_7 0.000783227f
C831 BL_0_1 WL_0_8 0.000783227f
C832 BL_0_1 XB_0_0 1.66874e-05f
C833 BL_0_1 net4_2 0.00076257f
C834 BL_0_1 net4_4 0.00129823f
C835 BL_0_1 net5_5 0.000613815f
C836 BL_0_1 net5_7 0.000306908f
C837 BL_0_1 net5_9 0.0014758f
C838 BL_1 BL_2 8.15715e-05f
C839 BL_1 BL_3 1.95178e-05f
C840 BL_1 P_0_0 6.90511e-05f
C841 BL_1 P_0_0_2 0.000269096f
C842 BL_1 P_0_0_5 0.000118199f
C843 BL_1 P_0_1 2.76856e-05f
C844 BL_1 P_0_1_2 0.000107892f
C845 BL_1 P_0_1_5 4.73911e-05f
C846 BL_1 VDD_1 0.00112396f
C847 BL_1 VSS_0 0.0200893f
C848 BL_1 WL_0 0.000299126f
C849 BL_1 WL_0_1 0.000717928f
C850 BL_1 WL_0_10 0.00129466f
C851 BL_1 WL_0_11 0.00117696f
C852 BL_1 WL_0_12 0.00129466f
C853 BL_1 WL_0_13 0.00129466f
C854 BL_1 WL_0_16 0.0005952f
C855 BL_1 WL_0_2 0.000781661f
C856 BL_1 WL_0_3 0.000781661f
C857 BL_1 WL_0_4 0.000781661f
C858 BL_1 WL_0_5 0.000781661f
C859 BL_1 WL_0_9 0.000823872f
C860 BL_1 XB_0_0 0.000327327f
C861 BL_1 XB_0_0_1 0.00136835f
C862 BL_1 XB_0_0_3 0.000386802f
C863 BL_1 XB_0_1_1 5.48062e-05f
C864 BL_1 XB_0_1_3 1.54924e-05f
C865 BL_1 net5 5.03676e-05f
C866 BL_1 net5_11 2.95271e-05f
C867 BL_1 net5_2 4.3697e-05f
C868 BL_1 net5_3 4.74334e-05f
C869 BL_1 net5_4 4.77817e-05f
C870 BL_1 net5_5 1.90831e-05f
C871 BL_1 net5_6 1.90831e-05f
C872 BL_1 net5_8 1.90831e-05f
C873 BL_1 net68 3.32006e-05f
C874 BL_1 net8 0.000566221f
C875 BL_1 net8_3 0.000737556f
C876 BL_1 net8_6 0.000534198f
C877 BL_1 net8_7 0.00190916f
C878 BL_1 net9 0.00147523f
C879 BL_1 net9_11 0.000864825f
C880 BL_1 net9_2 0.00127985f
C881 BL_1 net9_3 0.00138928f
C882 BL_1 net9_4 0.00139949f
C883 BL_1 net9_6 0.000558929f
C884 BL_1 net9_8 0.000558929f
C885 BL_1_1 BL_2 6.08765e-05f
C886 BL_1_1 BL_3 1.45661e-05f
C887 BL_1_1 P_0_0_1 0.000147918f
C888 BL_1_1 P_0_0_3 2.98545e-05f
C889 BL_1_1 P_0_0_4 6.01828e-05f
C890 BL_1_1 P_0_1_1 5.93068e-05f
C891 BL_1_1 P_0_1_3 1.19699e-05f
C892 BL_1_1 P_0_1_4 2.41299e-05f
C893 BL_1_1 P_0_2_2 1.08372e-05f
C894 BL_1_1 VDD_1 0.000838806f
C895 BL_1_1 VSS_0 0.0149926f
C896 BL_1_1 WL_0_14 0.00129466f
C897 BL_1_1 WL_0_15 0.0028247f
C898 BL_1_1 WL_0_17 0.0005952f
C899 BL_1_1 WL_0_18 0.0005952f
C900 BL_1_1 WL_0_19 0.0005952f
C901 BL_1_1 WL_0_20 0.0005952f
C902 BL_1_1 WL_0_21 0.0005952f
C903 BL_1_1 WL_0_22 0.0005952f
C904 BL_1_1 WL_0_23 0.0005952f
C905 BL_1_1 WL_0_24 0.0005952f
C906 BL_1_1 WL_0_25 0.0005952f
C907 BL_1_1 WL_0_26 0.0005952f
C908 BL_1_1 WL_0_27 0.0005952f
C909 BL_1_1 WL_0_28 0.0005952f
C910 BL_1_1 WL_0_29 0.0005952f
C911 BL_1_1 WL_0_30 0.0005952f
C912 BL_1_1 WL_0_31 0.0005952f
C913 BL_1_1 WL_0_6 0.000781661f
C914 BL_1_1 WL_0_7 0.000781661f
C915 BL_1_1 WL_0_8 0.000781661f
C916 BL_1_1 XB_0_0_2 0.000193401f
C917 BL_1_1 XB_0_1 1.31103e-05f
C918 BL_1_1 net5_9 4.58818e-05f
C919 BL_1_1 net68 2.47774e-05f
C920 BL_1_1 net8_2 0.000737556f
C921 BL_1_1 net8_4 0.00125564f
C922 BL_1_1 net9_5 0.000558929f
C923 BL_1_1 net9_7 0.000279464f
C924 BL_1_1 net9_9 0.00134384f
C925 BL_2 BL_3 8.24053e-05f
C926 BL_2 BL_4 1.79805e-05f
C927 BL_2 BL_5 1.01747e-05f
C928 BL_2 P_0_0_2 1.1547e-05f
C929 BL_2 P_0_1 6.81942e-05f
C930 BL_2 P_0_1_2 0.000265757f
C931 BL_2 P_0_1_5 0.000116732f
C932 BL_2 P_0_2 2.92493e-05f
C933 BL_2 P_0_2_2 0.000113986f
C934 BL_2 P_0_2_5 5.00679e-05f
C935 BL_2 VDD_1 0.00112474f
C936 BL_2 VSS_0 0.0200767f
C937 BL_2 WL_0 0.000298512f
C938 BL_2 WL_0_1 0.000716455f
C939 BL_2 WL_0_10 0.001292f
C940 BL_2 WL_0_11 0.00117455f
C941 BL_2 WL_0_12 0.001292f
C942 BL_2 WL_0_13 0.001292f
C943 BL_2 WL_0_14 0.001292f
C944 BL_2 WL_0_16 0.00059398f
C945 BL_2 WL_0_17 0.00059398f
C946 BL_2 WL_0_18 0.00059398f
C947 BL_2 WL_0_2 0.000780058f
C948 BL_2 WL_0_3 0.000780058f
C949 BL_2 WL_0_4 0.000780058f
C950 BL_2 WL_0_5 0.000780058f
C951 BL_2 WL_0_6 0.000780058f
C952 BL_2 WL_0_9 0.000822183f
C953 BL_2 XB_0_1 0.000327637f
C954 BL_2 XB_0_1_1 0.00136965f
C955 BL_2 XB_0_1_3 0.000387168f
C956 BL_2 XB_0_2_1 4.45825e-05f
C957 BL_2 XB_0_2_3 1.26024e-05f
C958 BL_2 net12 0.000568753f
C959 BL_2 net12_3 0.000740853f
C960 BL_2 net12_6 0.000536586f
C961 BL_2 net12_7 0.0019177f
C962 BL_2 net13 0.00148192f
C963 BL_2 net13_11 0.000868746f
C964 BL_2 net13_2 0.00128565f
C965 BL_2 net13_3 0.00139558f
C966 BL_2 net13_4 0.00140583f
C967 BL_2 net13_6 0.000561463f
C968 BL_2 net13_8 0.000561463f
C969 BL_2 net4_7 1.50221e-05f
C970 BL_2 net69 3.48562e-05f
C971 BL_2 net9 4.66748e-05f
C972 BL_2 net9_11 2.73622e-05f
C973 BL_2 net9_2 4.04932e-05f
C974 BL_2 net9_3 4.39556e-05f
C975 BL_2 net9_4 4.42784e-05f
C976 BL_2 net9_5 1.7684e-05f
C977 BL_2 net9_6 1.7684e-05f
C978 BL_2 net9_8 1.7684e-05f
C979 BL_2_1 BL_3 6.14987e-05f
C980 BL_2_1 BL_4 1.34188e-05f
C981 BL_2_1 P_0_1_1 0.000146083f
C982 BL_2_1 P_0_1_3 2.9484e-05f
C983 BL_2_1 P_0_1_4 5.94359e-05f
C984 BL_2_1 P_0_2_1 6.26566e-05f
C985 BL_2_1 P_0_2_3 1.2646e-05f
C986 BL_2_1 P_0_2_4 2.54928e-05f
C987 BL_2_1 P_0_3_2 1.38788e-05f
C988 BL_2_1 VDD_1 0.000839387f
C989 BL_2_1 VSS_0 0.0149832f
C990 BL_2_1 WL_0_15 0.00281891f
C991 BL_2_1 WL_0_19 0.00059398f
C992 BL_2_1 WL_0_20 0.00059398f
C993 BL_2_1 WL_0_21 0.00059398f
C994 BL_2_1 WL_0_22 0.00059398f
C995 BL_2_1 WL_0_23 0.00059398f
C996 BL_2_1 WL_0_24 0.00059398f
C997 BL_2_1 WL_0_25 0.00059398f
C998 BL_2_1 WL_0_26 0.00059398f
C999 BL_2_1 WL_0_27 0.00059398f
C1000 BL_2_1 WL_0_28 0.00059398f
C1001 BL_2_1 WL_0_29 0.00059398f
C1002 BL_2_1 WL_0_30 0.00059398f
C1003 BL_2_1 WL_0_31 0.00059398f
C1004 BL_2_1 WL_0_7 0.000780058f
C1005 BL_2_1 WL_0_8 0.000780058f
C1006 BL_2_1 XB_0_1_2 0.000193584f
C1007 BL_2_1 XB_0_2 1.06647e-05f
C1008 BL_2_1 net12_2 0.000740853f
C1009 BL_2_1 net12_4 0.00126125f
C1010 BL_2_1 net13_5 0.000561463f
C1011 BL_2_1 net13_7 0.000280732f
C1012 BL_2_1 net13_9 0.00134993f
C1013 BL_2_1 net69 2.6013e-05f
C1014 BL_2_1 net9_9 4.25178e-05f
C1015 BL_3 BL_5 1.98837e-05f
C1016 BL_3 P_0_1_2 1.77359e-05f
C1017 BL_3 P_0_2 6.68914e-05f
C1018 BL_3 P_0_2_2 0.00026068f
C1019 BL_3 P_0_2_5 0.000114502f
C1020 BL_3 P_0_3 3.23969e-05f
C1021 BL_3 P_0_3_2 0.000126253f
C1022 BL_3 P_0_3_5 5.54558e-05f
C1023 BL_3 VDD_1 0.0011664f
C1024 BL_3 VSS_0 0.0199703f
C1025 BL_3 WL_0 0.000297091f
C1026 BL_3 WL_0_1 0.000713043f
C1027 BL_3 WL_0_10 0.00128585f
C1028 BL_3 WL_0_11 0.00116895f
C1029 BL_3 WL_0_12 0.00128585f
C1030 BL_3 WL_0_13 0.00128585f
C1031 BL_3 WL_0_14 0.00128585f
C1032 BL_3 WL_0_15 0.00280549f
C1033 BL_3 WL_0_16 0.000591151f
C1034 BL_3 WL_0_17 0.000591151f
C1035 BL_3 WL_0_18 0.000591151f
C1036 BL_3 WL_0_19 0.000591151f
C1037 BL_3 WL_0_2 0.000776343f
C1038 BL_3 WL_0_20 0.000591151f
C1039 BL_3 WL_0_3 0.000776343f
C1040 BL_3 WL_0_4 0.000776343f
C1041 BL_3 WL_0_5 0.000776343f
C1042 BL_3 WL_0_6 0.000776343f
C1043 BL_3 WL_0_7 0.000776343f
C1044 BL_3 WL_0_9 0.000818267f
C1045 BL_3 XB_0_2 0.000326303f
C1046 BL_3 XB_0_2_1 0.00136407f
C1047 BL_3 XB_0_2_3 0.000385592f
C1048 BL_3 XB_0_3_1 6.08346e-05f
C1049 BL_3 XB_0_3_3 1.71965e-05f
C1050 BL_3 net13 4.68875e-05f
C1051 BL_3 net13_11 2.74869e-05f
C1052 BL_3 net13_2 4.06777e-05f
C1053 BL_3 net13_3 4.4156e-05f
C1054 BL_3 net13_4 4.44802e-05f
C1055 BL_3 net13_5 1.77646e-05f
C1056 BL_3 net13_6 1.77646e-05f
C1057 BL_3 net13_8 1.77646e-05f
C1058 BL_3 net15 0.000573918f
C1059 BL_3 net15_3 0.000747582f
C1060 BL_3 net15_6 0.000541459f
C1061 BL_3 net15_7 0.00193511f
C1062 BL_3 net16 0.00147196f
C1063 BL_3 net16_11 0.000862912f
C1064 BL_3 net16_2 0.00127702f
C1065 BL_3 net16_3 0.00138621f
C1066 BL_3 net16_4 0.00139639f
C1067 BL_3 net16_6 0.000557693f
C1068 BL_3 net16_8 0.000557693f
C1069 BL_3 net20 1.01251e-05f
C1070 BL_3 net70 3.49629e-05f
C1071 BL_3 net8_7 1.30347e-05f
C1072 BL_3_1 BL_4 8.03878e-05f
C1073 BL_3_1 BL_4_1 5.99932e-05f
C1074 BL_3_1 BL_5 1.48391e-05f
C1075 BL_3_1 P_0_2_1 0.000143292f
C1076 BL_3_1 P_0_2_3 2.89207e-05f
C1077 BL_3_1 P_0_2_4 5.83004e-05f
C1078 BL_3_1 P_0_3_1 6.93992e-05f
C1079 BL_3_1 P_0_3_3 1.40069e-05f
C1080 BL_3_1 P_0_3_4 2.82361e-05f
C1081 BL_3_1 P_0_4_2 1.38375e-05f
C1082 BL_3_1 VDD_1 0.000870482f
C1083 BL_3_1 VSS_0 0.0149038f
C1084 BL_3_1 WL_0_21 0.000591151f
C1085 BL_3_1 WL_0_22 0.000591151f
C1086 BL_3_1 WL_0_23 0.000591151f
C1087 BL_3_1 WL_0_24 0.000591151f
C1088 BL_3_1 WL_0_25 0.000591151f
C1089 BL_3_1 WL_0_26 0.000591151f
C1090 BL_3_1 WL_0_27 0.000591151f
C1091 BL_3_1 WL_0_28 0.000591151f
C1092 BL_3_1 WL_0_29 0.000591151f
C1093 BL_3_1 WL_0_30 0.000591151f
C1094 BL_3_1 WL_0_31 0.000591151f
C1095 BL_3_1 WL_0_8 0.000776343f
C1096 BL_3_1 XB_0_2_2 0.000192796f
C1097 BL_3_1 XB_0_3 1.45524e-05f
C1098 BL_3_1 net13_9 4.27116e-05f
C1099 BL_3_1 net15_2 0.000747582f
C1100 BL_3_1 net15_4 0.00127271f
C1101 BL_3_1 net16_5 0.000557693f
C1102 BL_3_1 net16_7 0.000278846f
C1103 BL_3_1 net16_9 0.00134087f
C1104 BL_3_1 net70 2.60927e-05f
C1105 BL_4 BL_5 7.90049e-05f
C1106 BL_4 P_0_2_2 1.12641e-05f
C1107 BL_4 P_0_3 6.93677e-05f
C1108 BL_4 P_0_3_2 0.00027033f
C1109 BL_4 P_0_3_5 0.000118741f
C1110 BL_4 P_0_4 2.89276e-05f
C1111 BL_4 P_0_4_2 0.000112733f
C1112 BL_4 P_0_4_5 4.95173e-05f
C1113 BL_4 VDD_1 0.00114495f
C1114 BL_4 VSS_0 0.0200629f
C1115 BL_4 WL_0 0.00029914f
C1116 BL_4 WL_0_1 0.000717961f
C1117 BL_4 WL_0_10 0.00129472f
C1118 BL_4 WL_0_11 0.00117701f
C1119 BL_4 WL_0_12 0.00129472f
C1120 BL_4 WL_0_13 0.00129472f
C1121 BL_4 WL_0_14 0.00129472f
C1122 BL_4 WL_0_15 0.00282483f
C1123 BL_4 WL_0_16 0.000595228f
C1124 BL_4 WL_0_17 0.000595228f
C1125 BL_4 WL_0_18 0.000595228f
C1126 BL_4 WL_0_19 0.000595228f
C1127 BL_4 WL_0_2 0.000781697f
C1128 BL_4 WL_0_20 0.000595228f
C1129 BL_4 WL_0_21 0.000595228f
C1130 BL_4 WL_0_22 0.000595228f
C1131 BL_4 WL_0_3 0.000781697f
C1132 BL_4 WL_0_4 0.000781697f
C1133 BL_4 WL_0_5 0.000781697f
C1134 BL_4 WL_0_6 0.000781697f
C1135 BL_4 WL_0_7 0.000781697f
C1136 BL_4 WL_0_8 0.000781697f
C1137 BL_4 WL_0_9 0.00082391f
C1138 BL_4 XB_0_3 0.000328972f
C1139 BL_4 XB_0_3_1 0.00137523f
C1140 BL_4 XB_0_3_3 0.000388745f
C1141 BL_4 XB_0_4_1 6.01904e-05f
C1142 BL_4 XB_0_4_3 1.70144e-05f
C1143 BL_4 net12_7 1.35531e-05f
C1144 BL_4 net16 4.17245e-05f
C1145 BL_4 net16_11 2.44603e-05f
C1146 BL_4 net16_2 3.61986e-05f
C1147 BL_4 net16_3 3.92938e-05f
C1148 BL_4 net16_4 3.95823e-05f
C1149 BL_4 net16_5 1.58085e-05f
C1150 BL_4 net16_6 1.58085e-05f
C1151 BL_4 net16_8 1.58085e-05f
C1152 BL_4 net19 0.000567219f
C1153 BL_4 net19_3 0.000738856f
C1154 BL_4 net19_6 0.000535139f
C1155 BL_4 net19_7 0.00191253f
C1156 BL_4 net20 0.00147369f
C1157 BL_4 net20_11 0.000863926f
C1158 BL_4 net20_2 0.00127852f
C1159 BL_4 net20_3 0.00138784f
C1160 BL_4 net20_4 0.00139803f
C1161 BL_4 net20_6 0.000558348f
C1162 BL_4 net20_8 0.000558348f
C1163 BL_4 net71 3.21761e-05f
C1164 BL_4_1 BL_5 5.89611e-05f
C1165 BL_4_1 BL_6 1.89129e-05f
C1166 BL_4_1 BL_6_1 1.41146e-05f
C1167 BL_4_1 P_0_3_1 0.000148597f
C1168 BL_4_1 P_0_3_3 2.99913e-05f
C1169 BL_4_1 P_0_3_4 6.04587e-05f
C1170 BL_4_1 P_0_4_1 6.19675e-05f
C1171 BL_4_1 P_0_4_3 1.25069e-05f
C1172 BL_4_1 P_0_4_4 2.52124e-05f
C1173 BL_4_1 P_0_5_2 1.30747e-05f
C1174 BL_4_1 VDD_1 0.000854469f
C1175 BL_4_1 VSS_0 0.0149728f
C1176 BL_4_1 WL_0_23 0.000595228f
C1177 BL_4_1 WL_0_24 0.000595228f
C1178 BL_4_1 WL_0_25 0.000595228f
C1179 BL_4_1 WL_0_26 0.000595228f
C1180 BL_4_1 WL_0_27 0.000595228f
C1181 BL_4_1 WL_0_28 0.000595228f
C1182 BL_4_1 WL_0_29 0.000595228f
C1183 BL_4_1 WL_0_30 0.000595228f
C1184 BL_4_1 WL_0_31 0.000595228f
C1185 BL_4_1 XB_0_3_2 0.000194373f
C1186 BL_4_1 XB_0_4 1.43983e-05f
C1187 BL_4_1 net16_9 3.80085e-05f
C1188 BL_4_1 net19_2 0.000738856f
C1189 BL_4_1 net19_4 0.00125785f
C1190 BL_4_1 net20_5 0.000558348f
C1191 BL_4_1 net20_7 0.000279174f
C1192 BL_4_1 net20_9 0.00134244f
C1193 BL_4_1 net71 2.40129e-05f
C1194 BL_5 P_0_3_2 1.21463e-05f
C1195 BL_5 P_0_4 6.74365e-05f
C1196 BL_5 P_0_4_2 0.000262804f
C1197 BL_5 P_0_4_5 0.000115435f
C1198 BL_5 P_0_5 2.96091e-05f
C1199 BL_5 P_0_5_2 0.000115389f
C1200 BL_5 P_0_5_5 5.06839e-05f
C1201 BL_5 VDD_1 0.00115355f
C1202 BL_5 VSS_0 0.0200329f
C1203 BL_5 WL_0 0.000298098f
C1204 BL_5 WL_0_1 0.00071546f
C1205 BL_5 WL_0_10 0.00129021f
C1206 BL_5 WL_0_11 0.00117292f
C1207 BL_5 WL_0_12 0.00129021f
C1208 BL_5 WL_0_13 0.00129021f
C1209 BL_5 WL_0_14 0.00129021f
C1210 BL_5 WL_0_15 0.002815f
C1211 BL_5 WL_0_16 0.000593155f
C1212 BL_5 WL_0_17 0.000593155f
C1213 BL_5 WL_0_18 0.000593155f
C1214 BL_5 WL_0_19 0.000593155f
C1215 BL_5 WL_0_2 0.000778975f
C1216 BL_5 WL_0_20 0.000593155f
C1217 BL_5 WL_0_21 0.000593155f
C1218 BL_5 WL_0_22 0.000593155f
C1219 BL_5 WL_0_23 0.000593155f
C1220 BL_5 WL_0_24 0.000593155f
C1221 BL_5 WL_0_3 0.000778975f
C1222 BL_5 WL_0_4 0.000778975f
C1223 BL_5 WL_0_5 0.000778975f
C1224 BL_5 WL_0_6 0.000778975f
C1225 BL_5 WL_0_7 0.000778975f
C1226 BL_5 WL_0_8 0.000778975f
C1227 BL_5 WL_0_9 0.000821041f
C1228 BL_5 XB_0_4 0.000329327f
C1229 BL_5 XB_0_4_1 0.00137672f
C1230 BL_5 XB_0_4_3 0.000389165f
C1231 BL_5 XB_0_5_1 6.34955e-05f
C1232 BL_5 XB_0_5_3 1.79487e-05f
C1233 BL_5 net15_7 1.40288e-05f
C1234 BL_5 net20 4.11482e-05f
C1235 BL_5 net20_11 2.41224e-05f
C1236 BL_5 net20_2 3.56985e-05f
C1237 BL_5 net20_3 3.8751e-05f
C1238 BL_5 net20_4 3.90356e-05f
C1239 BL_5 net20_5 1.55901e-05f
C1240 BL_5 net20_6 1.55901e-05f
C1241 BL_5 net20_8 1.55901e-05f
C1242 BL_5 net22 0.000571582f
C1243 BL_5 net22_3 0.000744539f
C1244 BL_5 net22_6 0.000539255f
C1245 BL_5 net22_7 0.00192724f
C1246 BL_5 net23 0.00147117f
C1247 BL_5 net23_11 0.000862446f
C1248 BL_5 net23_2 0.00127633f
C1249 BL_5 net23_3 0.00138546f
C1250 BL_5 net23_4 0.00139564f
C1251 BL_5 net23_6 0.000557392f
C1252 BL_5 net23_8 0.000557392f
C1253 BL_5 net26 1.03767e-05f
C1254 BL_5 net72 3.45183e-05f
C1255 BL_5_1 BL_6 7.98539e-05f
C1256 BL_5_1 BL_6_1 5.95946e-05f
C1257 BL_5_1 BL_7 1.97387e-05f
C1258 BL_5_1 BL_7_1 1.47309e-05f
C1259 BL_5_1 P_0_4_1 0.00014446f
C1260 BL_5_1 P_0_4_3 2.91564e-05f
C1261 BL_5_1 P_0_4_4 5.87755e-05f
C1262 BL_5_1 P_0_5_1 6.34274e-05f
C1263 BL_5_1 P_0_5_3 1.28016e-05f
C1264 BL_5_1 P_0_5_4 2.58064e-05f
C1265 BL_5_1 P_0_6_2 1.44251e-05f
C1266 BL_5_1 VDD_1 0.000860892f
C1267 BL_5_1 VSS_0 0.0149505f
C1268 BL_5_1 WL_0_25 0.000593155f
C1269 BL_5_1 WL_0_26 0.000593155f
C1270 BL_5_1 WL_0_27 0.000593155f
C1271 BL_5_1 WL_0_28 0.000593155f
C1272 BL_5_1 WL_0_29 0.000593155f
C1273 BL_5_1 WL_0_30 0.000593155f
C1274 BL_5_1 WL_0_31 0.000593155f
C1275 BL_5_1 XB_0_4_2 0.000194583f
C1276 BL_5_1 XB_0_5 1.51889e-05f
C1277 BL_5_1 net20_9 3.74835e-05f
C1278 BL_5_1 net22_2 0.000744539f
C1279 BL_5_1 net22_4 0.00126753f
C1280 BL_5_1 net23_5 0.000557392f
C1281 BL_5_1 net23_7 0.000278696f
C1282 BL_5_1 net23_9 0.00134014f
C1283 BL_5_1 net72 2.57608e-05f
C1284 BL_6 BL_7 8.12797e-05f
C1285 BL_6 P_0_4_2 1.46381e-05f
C1286 BL_6 P_0_5 6.52395e-05f
C1287 BL_6 P_0_5_2 0.000254242f
C1288 BL_6 P_0_5_5 0.000111675f
C1289 BL_6 P_0_6 3.01979e-05f
C1290 BL_6 P_0_6_2 0.000117683f
C1291 BL_6 P_0_6_5 5.16917e-05f
C1292 BL_6 VDD_1 0.00114189f
C1293 BL_6 VSS_0 0.019999f
C1294 BL_6 WL_0 0.000297604f
C1295 BL_6 WL_0_1 0.000714275f
C1296 BL_6 WL_0_10 0.00128807f
C1297 BL_6 WL_0_11 0.00117097f
C1298 BL_6 WL_0_12 0.00128807f
C1299 BL_6 WL_0_13 0.00128807f
C1300 BL_6 WL_0_14 0.00128807f
C1301 BL_6 WL_0_15 0.00281033f
C1302 BL_6 WL_0_16 0.000592172f
C1303 BL_6 WL_0_17 0.000592172f
C1304 BL_6 WL_0_18 0.000592172f
C1305 BL_6 WL_0_19 0.000592172f
C1306 BL_6 WL_0_2 0.000777685f
C1307 BL_6 WL_0_20 0.000592172f
C1308 BL_6 WL_0_21 0.000592172f
C1309 BL_6 WL_0_22 0.000592172f
C1310 BL_6 WL_0_23 0.000592172f
C1311 BL_6 WL_0_24 0.000592172f
C1312 BL_6 WL_0_25 0.000592172f
C1313 BL_6 WL_0_26 0.000592172f
C1314 BL_6 WL_0_3 0.000777685f
C1315 BL_6 WL_0_4 0.000777685f
C1316 BL_6 WL_0_5 0.000777685f
C1317 BL_6 WL_0_6 0.000777685f
C1318 BL_6 WL_0_7 0.000777685f
C1319 BL_6 WL_0_8 0.000777685f
C1320 BL_6 WL_0_9 0.000819681f
C1321 BL_6 XB_0_4_1 1.15261e-05f
C1322 BL_6 XB_0_5 0.000332041f
C1323 BL_6 XB_0_5_1 0.00138806f
C1324 BL_6 XB_0_5_3 0.000392373f
C1325 BL_6 XB_0_6_1 0.000109586f
C1326 BL_6 XB_0_6_3 3.09774e-05f
C1327 BL_6 net19_7 1.43417e-05f
C1328 BL_6 net23 4.19426e-05f
C1329 BL_6 net23_11 2.45881e-05f
C1330 BL_6 net23_2 3.63877e-05f
C1331 BL_6 net23_3 3.94991e-05f
C1332 BL_6 net23_4 3.97892e-05f
C1333 BL_6 net23_5 1.58911e-05f
C1334 BL_6 net23_6 1.58911e-05f
C1335 BL_6 net23_8 1.58911e-05f
C1336 BL_6 net25 0.000587352f
C1337 BL_6 net25_3 0.000765082f
C1338 BL_6 net25_6 0.000554134f
C1339 BL_6 net25_7 0.00198041f
C1340 BL_6 net26 0.00147578f
C1341 BL_6 net26_11 0.000865148f
C1342 BL_6 net26_2 0.00128033f
C1343 BL_6 net26_3 0.0013898f
C1344 BL_6 net26_4 0.00140001f
C1345 BL_6 net26_6 0.000559138f
C1346 BL_6 net26_8 0.000559138f
C1347 BL_6 net73 3.51616e-05f
C1348 BL_6_1 BL_7 6.06588e-05f
C1349 BL_6_1 P_0_5_1 0.000139753f
C1350 BL_6_1 P_0_5_3 2.82065e-05f
C1351 BL_6_1 P_0_5_4 5.68607e-05f
C1352 BL_6_1 P_0_6_1 6.46887e-05f
C1353 BL_6_1 P_0_6_3 1.30562e-05f
C1354 BL_6_1 P_0_6_4 2.63195e-05f
C1355 BL_6_1 P_0_7_2 1.47084e-05f
C1356 BL_6_1 VDD_1 0.000852189f
C1357 BL_6_1 VSS_0 0.0149252f
C1358 BL_6_1 WL_0_27 0.000592172f
C1359 BL_6_1 WL_0_28 0.000592172f
C1360 BL_6_1 WL_0_29 0.000592172f
C1361 BL_6_1 WL_0_30 0.000592172f
C1362 BL_6_1 WL_0_31 0.000592172f
C1363 BL_6_1 XB_0_5_2 0.000196187f
C1364 BL_6_1 XB_0_6 2.62143e-05f
C1365 BL_6_1 XB_0_6_2 1.54887e-05f
C1366 BL_6_1 XB_0_7_1 1.00107e-05f
C1367 BL_6_1 net23_9 3.82071e-05f
C1368 BL_6_1 net25_2 0.000765082f
C1369 BL_6_1 net25_4 0.0013025f
C1370 BL_6_1 net26_5 0.000559138f
C1371 BL_6_1 net26_7 0.000279569f
C1372 BL_6_1 net26_9 0.00134434f
C1373 BL_6_1 net73 2.62409e-05f
C1374 BL_7 P_0_5_2 1.52651e-05f
C1375 BL_7 P_0_6 6.8334e-05f
C1376 BL_7 P_0_6_2 0.000266302f
C1377 BL_7 P_0_6_5 0.000116972f
C1378 BL_7 P_0_7 2.99076e-05f
C1379 BL_7 P_0_7_2 0.000116551f
C1380 BL_7 P_0_7_5 5.11947e-05f
C1381 BL_7 VDD_1 0.00109158f
C1382 BL_7 VSS_0 0.0202137f
C1383 BL_7 WL_0 0.000296697f
C1384 BL_7 WL_0_1 0.000712098f
C1385 BL_7 WL_0_10 0.00128414f
C1386 BL_7 WL_0_11 0.0011674f
C1387 BL_7 WL_0_12 0.00128414f
C1388 BL_7 WL_0_13 0.00128414f
C1389 BL_7 WL_0_14 0.00128414f
C1390 BL_7 WL_0_15 0.00280177f
C1391 BL_7 WL_0_16 0.000590367f
C1392 BL_7 WL_0_17 0.000590367f
C1393 BL_7 WL_0_18 0.000590367f
C1394 BL_7 WL_0_19 0.000590367f
C1395 BL_7 WL_0_2 0.000775314f
C1396 BL_7 WL_0_20 0.000590367f
C1397 BL_7 WL_0_21 0.000590367f
C1398 BL_7 WL_0_22 0.000590367f
C1399 BL_7 WL_0_23 0.000590367f
C1400 BL_7 WL_0_24 0.000590367f
C1401 BL_7 WL_0_25 0.000590367f
C1402 BL_7 WL_0_26 0.000590367f
C1403 BL_7 WL_0_27 0.000590367f
C1404 BL_7 WL_0_28 0.000590367f
C1405 BL_7 WL_0_3 0.000775314f
C1406 BL_7 WL_0_4 0.000775314f
C1407 BL_7 WL_0_5 0.000775314f
C1408 BL_7 WL_0_6 0.000775314f
C1409 BL_7 WL_0_7 0.000775314f
C1410 BL_7 WL_0_8 0.000775314f
C1411 BL_7 WL_0_9 0.000817182f
C1412 BL_7 XB_0_6 0.000329949f
C1413 BL_7 XB_0_6_1 0.00137932f
C1414 BL_7 XB_0_6_3 0.0003899f
C1415 BL_7 XB_0_7_1 9.9162e-05f
C1416 BL_7 XB_0_7_3 2.80308e-05f
C1417 BL_7 net22_4 1.01191e-05f
C1418 BL_7 net22_7 1.53857e-05f
C1419 BL_7 net26 3.68166e-05f
C1420 BL_7 net26_11 2.15831e-05f
C1421 BL_7 net26_2 3.19406e-05f
C1422 BL_7 net26_3 3.46718e-05f
C1423 BL_7 net26_4 3.49264e-05f
C1424 BL_7 net26_5 1.3949e-05f
C1425 BL_7 net26_6 1.3949e-05f
C1426 BL_7 net26_8 1.3949e-05f
C1427 BL_7 net28 0.000581049f
C1428 BL_7 net28_3 0.000756871f
C1429 BL_7 net28_6 0.000548187f
C1430 BL_7 net28_7 0.00195916f
C1431 BL_7 net29 0.00147264f
C1432 BL_7 net29_11 0.000863307f
C1433 BL_7 net29_2 0.0012776f
C1434 BL_7 net29_3 0.00138685f
C1435 BL_7 net29_4 0.00139703f
C1436 BL_7 net29_6 0.000557948f
C1437 BL_7 net29_8 0.000557948f
C1438 BL_7 net74 3.03718e-05f
C1439 BL_7_1 P_0_6_1 0.000146382f
C1440 BL_7_1 P_0_6_3 2.95444e-05f
C1441 BL_7_1 P_0_6_4 5.95578e-05f
C1442 BL_7_1 P_0_7_1 6.40667e-05f
C1443 BL_7_1 P_0_7_3 1.29306e-05f
C1444 BL_7_1 P_0_7_4 2.60665e-05f
C1445 BL_7_1 VDD_1 0.000814645f
C1446 BL_7_1 VSS_0 0.0150854f
C1447 BL_7_1 WL_0_29 0.000590367f
C1448 BL_7_1 WL_0_30 0.000590367f
C1449 BL_7_1 WL_0_31 0.000590367f
C1450 BL_7_1 XB_0_6_2 0.00019495f
C1451 BL_7_1 XB_0_7 2.37208e-05f
C1452 BL_7_1 XB_0_7_2 1.40154e-05f
C1453 BL_7_1 net26_9 3.35377e-05f
C1454 BL_7_1 net28_2 0.000756871f
C1455 BL_7_1 net28_4 0.00128852f
C1456 BL_7_1 net29_5 0.000557948f
C1457 BL_7_1 net29_7 0.000278974f
C1458 BL_7_1 net29_9 0.00134148f
C1459 BL_7_1 net74 2.26664e-05f
C1460 P_0_0 VDD_1 0.00102116f
C1461 P_0_0 VSS_0 0.00768938f
C1462 P_0_0 WL_0 7.37536e-05f
C1463 P_0_0 WL_0_1 0.000177015f
C1464 P_0_0 WL_0_9 0.000203137f
C1465 P_0_0 XB_0_0 0.00180945f
C1466 P_0_0 net5 0.00860565f
C1467 P_0_0 net5_11 0.00504491f
C1468 P_0_0 net5_3 0.00810431f
C1469 P_0_0 net5_4 0.00816382f
C1470 P_0_0 net5_6 0.00326048f
C1471 P_0_0 net68 0.000285259f
C1472 P_0_0_1 VDD_1 0.00218749f
C1473 P_0_0_1 VSS_0 0.0164719f
C1474 P_0_0_1 XB_0_0 0.00387612f
C1475 P_0_0_1 net5_2 0.00746592f
C1476 P_0_0_1 net68 0.000611069f
C1477 P_0_0_2 VDD_1 0.00397953f
C1478 P_0_0_2 VSS_0 0.029966f
C1479 P_0_0_2 WL_0_16 0.000146755f
C1480 P_0_0_2 WL_0_17 0.000146755f
C1481 P_0_0_2 XB_0_0 0.00705152f
C1482 P_0_0_2 net5_5 0.00326048f
C1483 P_0_0_2 net5_9 0.00783922f
C1484 P_0_0_2 net68 0.00111167f
C1485 P_0_0_3 VDD_1 0.000441503f
C1486 P_0_0_3 VSS_0 0.00332453f
C1487 P_0_0_3 XB_0_0 0.000782319f
C1488 P_0_0_3 net5_7 0.00163024f
C1489 P_0_0_3 net68 0.000123333f
C1490 P_0_0_4 VDD_1 0.000890014f
C1491 P_0_0_4 VSS_0 0.00670183f
C1492 P_0_0_4 WL_0_10 0.000319215f
C1493 P_0_0_4 WL_0_11 0.000290196f
C1494 P_0_0_4 WL_0_12 0.000319215f
C1495 P_0_0_4 WL_0_13 0.000319215f
C1496 P_0_0_4 WL_0_14 0.000319215f
C1497 P_0_0_4 WL_0_15 0.00069647f
C1498 P_0_0_4 WL_0_18 0.000146755f
C1499 P_0_0_4 WL_0_19 0.000146755f
C1500 P_0_0_4 WL_0_2 0.000192729f
C1501 P_0_0_4 WL_0_20 0.000146755f
C1502 P_0_0_4 WL_0_21 0.000146755f
C1503 P_0_0_4 WL_0_22 0.000146755f
C1504 P_0_0_4 WL_0_23 0.000146755f
C1505 P_0_0_4 WL_0_24 0.000146755f
C1506 P_0_0_4 WL_0_25 0.000146755f
C1507 P_0_0_4 WL_0_26 0.000146755f
C1508 P_0_0_4 WL_0_27 0.000146755f
C1509 P_0_0_4 WL_0_28 0.000146755f
C1510 P_0_0_4 WL_0_29 0.000146755f
C1511 P_0_0_4 WL_0_3 0.000192729f
C1512 P_0_0_4 WL_0_30 0.000146755f
C1513 P_0_0_4 WL_0_31 0.000146755f
C1514 P_0_0_4 WL_0_4 0.000192729f
C1515 P_0_0_4 WL_0_5 0.000192729f
C1516 P_0_0_4 WL_0_6 0.000192729f
C1517 P_0_0_4 WL_0_7 0.000192729f
C1518 P_0_0_4 WL_0_8 0.000192729f
C1519 P_0_0_4 XB_0_0_2 0.00157706f
C1520 P_0_0_4 net12_7 1.09981e-05f
C1521 P_0_0_4 net68 0.000248623f
C1522 P_0_0_4 net9 4.4361e-05f
C1523 P_0_0_4 net9_11 2.60058e-05f
C1524 P_0_0_4 net9_2 3.84858e-05f
C1525 P_0_0_4 net9_3 4.17766e-05f
C1526 P_0_0_4 net9_4 4.20834e-05f
C1527 P_0_0_4 net9_5 1.68073e-05f
C1528 P_0_0_4 net9_6 1.68073e-05f
C1529 P_0_0_4 net9_8 1.68073e-05f
C1530 P_0_0_4 net9_9 4.04101e-05f
C1531 P_0_0_5 VDD_1 0.00174799f
C1532 P_0_0_5 VSS_0 0.0131624f
C1533 P_0_0_5 XB_0_0_3 0.00309735f
C1534 P_0_0_5 net5_8 0.00326048f
C1535 P_0_0_5 net68 0.000488296f
C1536 P_0_1 VDD_1 0.00101943f
C1537 P_0_1 VSS_0 0.00766296f
C1538 P_0_1 WL_0 7.36347e-05f
C1539 P_0_1 WL_0_1 0.00017673f
C1540 P_0_1 WL_0_10 0.000318701f
C1541 P_0_1 WL_0_2 0.000192419f
C1542 P_0_1 WL_0_9 0.00020281f
C1543 P_0_1 XB_0_1 0.0017942f
C1544 P_0_1 net5 1.54734e-05f
C1545 P_0_1 net5_2 1.34241e-05f
C1546 P_0_1 net5_3 1.4572e-05f
C1547 P_0_1 net5_4 1.4679e-05f
C1548 P_0_1 net69 0.000286924f
C1549 P_0_1 net9 0.00861517f
C1550 P_0_1 net9_11 0.00505049f
C1551 P_0_1 net9_3 0.00811328f
C1552 P_0_1 net9_4 0.00817285f
C1553 P_0_1 net9_6 0.00326409f
C1554 P_0_1_1 VDD_1 0.00218377f
C1555 P_0_1_1 VSS_0 0.0164153f
C1556 P_0_1_1 XB_0_1 0.00384346f
C1557 P_0_1_1 net69 0.000614637f
C1558 P_0_1_1 net9_2 0.00747418f
C1559 P_0_1_2 VDD_1 0.00397277f
C1560 P_0_1_2 VSS_0 0.029863f
C1561 P_0_1_2 WL_0_16 0.000146518f
C1562 P_0_1_2 WL_0_17 0.000146518f
C1563 P_0_1_2 WL_0_18 0.000146518f
C1564 P_0_1_2 WL_0_19 0.000146518f
C1565 P_0_1_2 XB_0_1 0.0069921f
C1566 P_0_1_2 net5_9 1.40953e-05f
C1567 P_0_1_2 net69 0.00111816f
C1568 P_0_1_2 net9_5 0.00326409f
C1569 P_0_1_2 net9_9 0.00784789f
C1570 P_0_1_3 VDD_1 0.000440753f
C1571 P_0_1_3 VSS_0 0.00331311f
C1572 P_0_1_3 XB_0_1 0.000775727f
C1573 P_0_1_3 net69 0.000124053f
C1574 P_0_1_3 net9_7 0.00163204f
C1575 P_0_1_4 VDD_1 0.000888502f
C1576 P_0_1_4 VSS_0 0.0066788f
C1577 P_0_1_4 WL_0_11 0.000289728f
C1578 P_0_1_4 WL_0_12 0.000318701f
C1579 P_0_1_4 WL_0_13 0.000318701f
C1580 P_0_1_4 WL_0_14 0.000318701f
C1581 P_0_1_4 WL_0_15 0.000695347f
C1582 P_0_1_4 WL_0_20 0.000146518f
C1583 P_0_1_4 WL_0_21 0.000146518f
C1584 P_0_1_4 WL_0_22 0.000146518f
C1585 P_0_1_4 WL_0_23 0.000146518f
C1586 P_0_1_4 WL_0_24 0.000146518f
C1587 P_0_1_4 WL_0_25 0.000146518f
C1588 P_0_1_4 WL_0_26 0.000146518f
C1589 P_0_1_4 WL_0_27 0.000146518f
C1590 P_0_1_4 WL_0_28 0.000146518f
C1591 P_0_1_4 WL_0_29 0.000146518f
C1592 P_0_1_4 WL_0_3 0.000192419f
C1593 P_0_1_4 WL_0_30 0.000146518f
C1594 P_0_1_4 WL_0_31 0.000146518f
C1595 P_0_1_4 WL_0_4 0.000192419f
C1596 P_0_1_4 WL_0_5 0.000192419f
C1597 P_0_1_4 WL_0_6 0.000192419f
C1598 P_0_1_4 WL_0_7 0.000192419f
C1599 P_0_1_4 WL_0_8 0.000192419f
C1600 P_0_1_4 XB_0_1_2 0.00156377f
C1601 P_0_1_4 net12_2 1.0611e-05f
C1602 P_0_1_4 net12_3 1.0611e-05f
C1603 P_0_1_4 net12_4 1.80645e-05f
C1604 P_0_1_4 net12_7 2.74665e-05f
C1605 P_0_1_4 net13 2.67224e-05f
C1606 P_0_1_4 net13_11 1.56655e-05f
C1607 P_0_1_4 net13_2 2.31833e-05f
C1608 P_0_1_4 net13_3 2.51656e-05f
C1609 P_0_1_4 net13_4 2.53504e-05f
C1610 P_0_1_4 net13_5 1.01245e-05f
C1611 P_0_1_4 net13_6 1.01245e-05f
C1612 P_0_1_4 net13_8 1.01245e-05f
C1613 P_0_1_4 net13_9 2.43425e-05f
C1614 P_0_1_4 net69 0.000250074f
C1615 P_0_1_5 VDD_1 0.00174502f
C1616 P_0_1_5 VSS_0 0.0131172f
C1617 P_0_1_5 XB_0_1_3 0.00307125f
C1618 P_0_1_5 net69 0.000491147f
C1619 P_0_1_5 net9_8 0.00326409f
C1620 P_0_2 VDD_1 0.00102543f
C1621 P_0_2 VSS_0 0.00768055f
C1622 P_0_2 WL_0 7.31499e-05f
C1623 P_0_2 WL_0_1 0.000175566f
C1624 P_0_2 WL_0_10 0.000316602f
C1625 P_0_2 WL_0_11 0.00028782f
C1626 P_0_2 WL_0_2 0.000191152f
C1627 P_0_2 WL_0_3 0.000191152f
C1628 P_0_2 WL_0_9 0.000201474f
C1629 P_0_2 XB_0_2 0.00179505f
C1630 P_0_2 net12 1.1019e-05f
C1631 P_0_2 net12_3 1.43533e-05f
C1632 P_0_2 net12_6 1.03958e-05f
C1633 P_0_2 net12_7 3.71534e-05f
C1634 P_0_2 net13 0.00861296f
C1635 P_0_2 net13_11 0.0050492f
C1636 P_0_2 net13_3 0.0081112f
C1637 P_0_2 net13_4 0.00817076f
C1638 P_0_2 net13_6 0.00326325f
C1639 P_0_2 net70 0.000282694f
C1640 P_0_2_1 VDD_1 0.00219663f
C1641 P_0_2_1 VSS_0 0.016453f
C1642 P_0_2_1 XB_0_1_2 1.26052e-05f
C1643 P_0_2_1 XB_0_2 0.00384529f
C1644 P_0_2_1 net13_2 0.00747227f
C1645 P_0_2_1 net70 0.000605576f
C1646 P_0_2_2 VDD_1 0.00399616f
C1647 P_0_2_2 VSS_0 0.0299316f
C1648 P_0_2_2 WL_0_16 0.000145554f
C1649 P_0_2_2 WL_0_17 0.000145554f
C1650 P_0_2_2 WL_0_18 0.000145554f
C1651 P_0_2_2 WL_0_19 0.000145554f
C1652 P_0_2_2 WL_0_20 0.000145554f
C1653 P_0_2_2 WL_0_21 0.000145554f
C1654 P_0_2_2 XB_0_1_1 2.29317e-05f
C1655 P_0_2_2 XB_0_2 0.00699543f
C1656 P_0_2_2 net12_2 1.43533e-05f
C1657 P_0_2_2 net12_4 2.44355e-05f
C1658 P_0_2_2 net13_5 0.00326325f
C1659 P_0_2_2 net13_9 0.00784588f
C1660 P_0_2_2 net70 0.00110168f
C1661 P_0_2_3 VDD_1 0.000443348f
C1662 P_0_2_3 VSS_0 0.00332071f
C1663 P_0_2_3 XB_0_2 0.000776097f
C1664 P_0_2_3 net13_7 0.00163163f
C1665 P_0_2_3 net70 0.000122224f
C1666 P_0_2_4 VDD_1 0.000893733f
C1667 P_0_2_4 VSS_0 0.00669413f
C1668 P_0_2_4 WL_0_12 0.000316602f
C1669 P_0_2_4 WL_0_13 0.000316602f
C1670 P_0_2_4 WL_0_14 0.000316602f
C1671 P_0_2_4 WL_0_15 0.000690769f
C1672 P_0_2_4 WL_0_22 0.000145554f
C1673 P_0_2_4 WL_0_23 0.000145554f
C1674 P_0_2_4 WL_0_24 0.000145554f
C1675 P_0_2_4 WL_0_25 0.000145554f
C1676 P_0_2_4 WL_0_26 0.000145554f
C1677 P_0_2_4 WL_0_27 0.000145554f
C1678 P_0_2_4 WL_0_28 0.000145554f
C1679 P_0_2_4 WL_0_29 0.000145554f
C1680 P_0_2_4 WL_0_30 0.000145554f
C1681 P_0_2_4 WL_0_31 0.000145554f
C1682 P_0_2_4 WL_0_4 0.000191152f
C1683 P_0_2_4 WL_0_5 0.000191152f
C1684 P_0_2_4 WL_0_6 0.000191152f
C1685 P_0_2_4 WL_0_7 0.000191152f
C1686 P_0_2_4 WL_0_8 0.000191152f
C1687 P_0_2_4 XB_0_2_2 0.00156451f
C1688 P_0_2_4 net15_4 1.09218e-05f
C1689 P_0_2_4 net15_7 1.66062e-05f
C1690 P_0_2_4 net16 2.77894e-05f
C1691 P_0_2_4 net16_11 1.6291e-05f
C1692 P_0_2_4 net16_2 2.4109e-05f
C1693 P_0_2_4 net16_3 2.61705e-05f
C1694 P_0_2_4 net16_4 2.63626e-05f
C1695 P_0_2_4 net16_5 1.05287e-05f
C1696 P_0_2_4 net16_6 1.05287e-05f
C1697 P_0_2_4 net16_8 1.05287e-05f
C1698 P_0_2_4 net16_9 2.53144e-05f
C1699 P_0_2_4 net70 0.000246388f
C1700 P_0_2_5 VDD_1 0.0017553f
C1701 P_0_2_5 VSS_0 0.0131473f
C1702 P_0_2_5 XB_0_1_3 1.00727e-05f
C1703 P_0_2_5 XB_0_2_3 0.00307271f
C1704 P_0_2_5 net13_8 0.00326325f
C1705 P_0_2_5 net70 0.000483906f
C1706 P_0_3 VDD_1 0.00101679f
C1707 P_0_3 VSS_0 0.00765735f
C1708 P_0_3 WL_0 7.4156e-05f
C1709 P_0_3 WL_0_1 0.000177981f
C1710 P_0_3 WL_0_10 0.000320957f
C1711 P_0_3 WL_0_11 0.000291779f
C1712 P_0_3 WL_0_12 0.000320957f
C1713 P_0_3 WL_0_2 0.000193781f
C1714 P_0_3 WL_0_3 0.000193781f
C1715 P_0_3 WL_0_4 0.000193781f
C1716 P_0_3 WL_0_9 0.000204245f
C1717 P_0_3 XB_0_3 0.00179924f
C1718 P_0_3 net15_7 1.24446e-05f
C1719 P_0_3 net16 0.00862047f
C1720 P_0_3 net16_11 0.0050536f
C1721 P_0_3 net16_3 0.00811827f
C1722 P_0_3 net16_4 0.00817788f
C1723 P_0_3 net16_6 0.0032661f
C1724 P_0_3 net71 0.000284642f
C1725 P_0_3_1 VDD_1 0.00217813f
C1726 P_0_3_1 VSS_0 0.0164033f
C1727 P_0_3_1 XB_0_2_2 1.24739e-05f
C1728 P_0_3_1 XB_0_3 0.00385426f
C1729 P_0_3_1 net16_2 0.00747878f
C1730 P_0_3_1 net71 0.000609747f
C1731 P_0_3_2 VDD_1 0.0039625f
C1732 P_0_3_2 VSS_0 0.0298412f
C1733 P_0_3_2 WL_0_16 0.000147555f
C1734 P_0_3_2 WL_0_17 0.000147555f
C1735 P_0_3_2 WL_0_18 0.000147555f
C1736 P_0_3_2 WL_0_19 0.000147555f
C1737 P_0_3_2 WL_0_20 0.000147555f
C1738 P_0_3_2 WL_0_21 0.000147555f
C1739 P_0_3_2 WL_0_22 0.000147555f
C1740 P_0_3_2 WL_0_23 0.000147555f
C1741 P_0_3_2 XB_0_2_1 2.26928e-05f
C1742 P_0_3_2 XB_0_3 0.00701175f
C1743 P_0_3_2 net16_5 0.0032661f
C1744 P_0_3_2 net16_9 0.00785272f
C1745 P_0_3_2 net71 0.00110927f
C1746 P_0_3_3 VDD_1 0.000439613f
C1747 P_0_3_3 VSS_0 0.00331068f
C1748 P_0_3_3 XB_0_3 0.000777907f
C1749 P_0_3_3 net16_7 0.00163305f
C1750 P_0_3_3 net71 0.000123066f
C1751 P_0_3_4 VDD_1 0.000886205f
C1752 P_0_3_4 VSS_0 0.00667391f
C1753 P_0_3_4 WL_0_13 0.000320957f
C1754 P_0_3_4 WL_0_14 0.000320957f
C1755 P_0_3_4 WL_0_15 0.000700269f
C1756 P_0_3_4 WL_0_24 0.000147555f
C1757 P_0_3_4 WL_0_25 0.000147555f
C1758 P_0_3_4 WL_0_26 0.000147555f
C1759 P_0_3_4 WL_0_27 0.000147555f
C1760 P_0_3_4 WL_0_28 0.000147555f
C1761 P_0_3_4 WL_0_29 0.000147555f
C1762 P_0_3_4 WL_0_30 0.000147555f
C1763 P_0_3_4 WL_0_31 0.000147555f
C1764 P_0_3_4 WL_0_5 0.000193781f
C1765 P_0_3_4 WL_0_6 0.000193781f
C1766 P_0_3_4 WL_0_7 0.000193781f
C1767 P_0_3_4 WL_0_8 0.000193781f
C1768 P_0_3_4 XB_0_3_2 0.00156816f
C1769 P_0_3_4 net19 1.07788e-05f
C1770 P_0_3_4 net19_2 1.40404e-05f
C1771 P_0_3_4 net19_3 1.40404e-05f
C1772 P_0_3_4 net19_4 2.39028e-05f
C1773 P_0_3_4 net19_6 1.01692e-05f
C1774 P_0_3_4 net19_7 3.63435e-05f
C1775 P_0_3_4 net20 2.11666e-05f
C1776 P_0_3_4 net20_11 1.24085e-05f
C1777 P_0_3_4 net20_2 1.83633e-05f
C1778 P_0_3_4 net20_3 1.99335e-05f
C1779 P_0_3_4 net20_4 2.00799e-05f
C1780 P_0_3_4 net20_9 1.92815e-05f
C1781 P_0_3_4 net71 0.000248085f
C1782 P_0_3_5 VDD_1 0.00174051f
C1783 P_0_3_5 VSS_0 0.0131076f
C1784 P_0_3_5 XB_0_3_3 0.00307988f
C1785 P_0_3_5 net16_8 0.0032661f
C1786 P_0_3_5 net71 0.00048724f
C1787 P_0_4 VDD_1 0.0010234f
C1788 P_0_4 VSS_0 0.00766966f
C1789 P_0_4 WL_0 7.50943e-05f
C1790 P_0_4 WL_0_1 0.000180233f
C1791 P_0_4 WL_0_10 0.000325018f
C1792 P_0_4 WL_0_11 0.000295471f
C1793 P_0_4 WL_0_12 0.000325018f
C1794 P_0_4 WL_0_13 0.000325018f
C1795 P_0_4 WL_0_2 0.000196233f
C1796 P_0_4 WL_0_3 0.000196233f
C1797 P_0_4 WL_0_4 0.000196233f
C1798 P_0_4 WL_0_5 0.000196233f
C1799 P_0_4 WL_0_9 0.00020683f
C1800 P_0_4 XB_0_4 0.00178925f
C1801 P_0_4 net19_7 1.86037e-05f
C1802 P_0_4 net20 0.00862865f
C1803 P_0_4 net20_11 0.00505839f
C1804 P_0_4 net20_3 0.00812598f
C1805 P_0_4 net20_4 0.00818565f
C1806 P_0_4 net20_6 0.0032692f
C1807 P_0_4 net72 0.00028829f
C1808 P_0_4_1 VDD_1 0.00219229f
C1809 P_0_4_1 VSS_0 0.0164296f
C1810 P_0_4_1 XB_0_3_2 1.09944e-05f
C1811 P_0_4_1 XB_0_4 0.00383286f
C1812 P_0_4_1 net20_2 0.00748588f
C1813 P_0_4_1 net72 0.000617562f
C1814 P_0_4_2 VDD_1 0.00398826f
C1815 P_0_4_2 VSS_0 0.0298891f
C1816 P_0_4_2 WL_0_16 0.000149423f
C1817 P_0_4_2 WL_0_17 0.000149423f
C1818 P_0_4_2 WL_0_18 0.000149423f
C1819 P_0_4_2 WL_0_19 0.000149423f
C1820 P_0_4_2 WL_0_20 0.000149423f
C1821 P_0_4_2 WL_0_21 0.000149423f
C1822 P_0_4_2 WL_0_22 0.000149423f
C1823 P_0_4_2 WL_0_23 0.000149423f
C1824 P_0_4_2 WL_0_24 0.000149423f
C1825 P_0_4_2 WL_0_25 0.000149423f
C1826 P_0_4_2 XB_0_3_1 2.00013e-05f
C1827 P_0_4_2 XB_0_4 0.00697282f
C1828 P_0_4_2 net19_4 1.22355e-05f
C1829 P_0_4_2 net20_5 0.0032692f
C1830 P_0_4_2 net20_9 0.00786017f
C1831 P_0_4_2 net72 0.00112348f
C1832 P_0_4_3 VDD_1 0.000442471f
C1833 P_0_4_3 VSS_0 0.003316f
C1834 P_0_4_3 XB_0_4 0.000773588f
C1835 P_0_4_3 net20_7 0.0016346f
C1836 P_0_4_3 net72 0.000124643f
C1837 P_0_4_4 VDD_1 0.000891964f
C1838 P_0_4_4 VSS_0 0.00668464f
C1839 P_0_4_4 WL_0_14 0.000325018f
C1840 P_0_4_4 WL_0_15 0.00070913f
C1841 P_0_4_4 WL_0_26 0.000149423f
C1842 P_0_4_4 WL_0_27 0.000149423f
C1843 P_0_4_4 WL_0_28 0.000149423f
C1844 P_0_4_4 WL_0_29 0.000149423f
C1845 P_0_4_4 WL_0_30 0.000149423f
C1846 P_0_4_4 WL_0_31 0.000149423f
C1847 P_0_4_4 WL_0_6 0.000196233f
C1848 P_0_4_4 WL_0_7 0.000196233f
C1849 P_0_4_4 WL_0_8 0.000196233f
C1850 P_0_4_4 XB_0_4_2 0.00155946f
C1851 P_0_4_4 net22_2 1.16329e-05f
C1852 P_0_4_4 net22_3 1.16329e-05f
C1853 P_0_4_4 net22_4 1.98042e-05f
C1854 P_0_4_4 net22_7 3.01117e-05f
C1855 P_0_4_4 net23 2.62587e-05f
C1856 P_0_4_4 net23_11 1.53937e-05f
C1857 P_0_4_4 net23_2 2.2781e-05f
C1858 P_0_4_4 net23_3 2.4729e-05f
C1859 P_0_4_4 net23_4 2.49106e-05f
C1860 P_0_4_4 net23_9 2.39201e-05f
C1861 P_0_4_4 net72 0.000251264f
C1862 P_0_4_5 VDD_1 0.00175182f
C1863 P_0_4_5 VSS_0 0.0131287f
C1864 P_0_4_5 XB_0_4_3 0.00306278f
C1865 P_0_4_5 net20_8 0.0032692f
C1866 P_0_4_5 net72 0.000493484f
C1867 P_0_5 VDD_1 0.00102224f
C1868 P_0_5 VSS_0 0.00764721f
C1869 P_0_5 WL_0 7.54392e-05f
C1870 P_0_5 WL_0_1 0.000181061f
C1871 P_0_5 WL_0_10 0.000326511f
C1872 P_0_5 WL_0_11 0.000296828f
C1873 P_0_5 WL_0_12 0.000326511f
C1874 P_0_5 WL_0_13 0.000326511f
C1875 P_0_5 WL_0_14 0.000326511f
C1876 P_0_5 WL_0_2 0.000197134f
C1877 P_0_5 WL_0_3 0.000197134f
C1878 P_0_5 WL_0_4 0.000197134f
C1879 P_0_5 WL_0_5 0.000197134f
C1880 P_0_5 WL_0_6 0.000197134f
C1881 P_0_5 WL_0_9 0.00020778f
C1882 P_0_5 XB_0_5 0.00178963f
C1883 P_0_5 net22_3 1.23356e-05f
C1884 P_0_5 net22_7 3.19306e-05f
C1885 P_0_5 net23 0.00861122f
C1886 P_0_5 net23_11 0.00504818f
C1887 P_0_5 net23_3 0.00810956f
C1888 P_0_5 net23_4 0.00816911f
C1889 P_0_5 net23_6 0.00326259f
C1890 P_0_5 net73 0.000293338f
C1891 P_0_5_1 VDD_1 0.00218979f
C1892 P_0_5_1 VSS_0 0.0163815f
C1893 P_0_5_1 XB_0_4_2 1.06776e-05f
C1894 P_0_5_1 XB_0_5 0.00383368f
C1895 P_0_5_1 net23_2 0.00747076f
C1896 P_0_5_1 net73 0.000628375f
C1897 P_0_5_2 VDD_1 0.00398372f
C1898 P_0_5_2 VSS_0 0.0298016f
C1899 P_0_5_2 WL_0_16 0.000150109f
C1900 P_0_5_2 WL_0_17 0.000150109f
C1901 P_0_5_2 WL_0_18 0.000150109f
C1902 P_0_5_2 WL_0_19 0.000150109f
C1903 P_0_5_2 WL_0_20 0.000150109f
C1904 P_0_5_2 WL_0_21 0.000150109f
C1905 P_0_5_2 WL_0_22 0.000150109f
C1906 P_0_5_2 WL_0_23 0.000150109f
C1907 P_0_5_2 WL_0_24 0.000150109f
C1908 P_0_5_2 WL_0_25 0.000150109f
C1909 P_0_5_2 WL_0_26 0.000150109f
C1910 P_0_5_2 WL_0_27 0.000150109f
C1911 P_0_5_2 XB_0_4_1 1.94249e-05f
C1912 P_0_5_2 XB_0_5 0.00697431f
C1913 P_0_5_2 net22_2 1.23356e-05f
C1914 P_0_5_2 net22_4 2.10005e-05f
C1915 P_0_5_2 net23_5 0.00326259f
C1916 P_0_5_2 net23_9 0.0078443f
C1917 P_0_5_2 net73 0.00114315f
C1918 P_0_5_3 VDD_1 0.000441967f
C1919 P_0_5_3 VSS_0 0.0033063f
C1920 P_0_5_3 XB_0_5 0.000773754f
C1921 P_0_5_3 net23_7 0.0016313f
C1922 P_0_5_3 net73 0.000126825f
C1923 P_0_5_4 VDD_1 0.00089095f
C1924 P_0_5_4 VSS_0 0.00666507f
C1925 P_0_5_4 WL_0_15 0.000712387f
C1926 P_0_5_4 WL_0_28 0.000150109f
C1927 P_0_5_4 WL_0_29 0.000150109f
C1928 P_0_5_4 WL_0_30 0.000150109f
C1929 P_0_5_4 WL_0_31 0.000150109f
C1930 P_0_5_4 WL_0_7 0.000197134f
C1931 P_0_5_4 WL_0_8 0.000197134f
C1932 P_0_5_4 XB_0_5_2 0.00155979f
C1933 P_0_5_4 net25_4 1.60851e-05f
C1934 P_0_5_4 net25_7 2.44569e-05f
C1935 P_0_5_4 net26 3.73358e-05f
C1936 P_0_5_4 net26_11 2.18875e-05f
C1937 P_0_5_4 net26_2 3.23911e-05f
C1938 P_0_5_4 net26_3 3.51608e-05f
C1939 P_0_5_4 net26_4 3.54189e-05f
C1940 P_0_5_4 net26_5 1.41457e-05f
C1941 P_0_5_4 net26_6 1.41457e-05f
C1942 P_0_5_4 net26_8 1.41457e-05f
C1943 P_0_5_4 net26_9 3.40106e-05f
C1944 P_0_5_4 net73 0.000255664f
C1945 P_0_5_5 VDD_1 0.00174983f
C1946 P_0_5_5 VSS_0 0.0130902f
C1947 P_0_5_5 XB_0_5_3 0.00306343f
C1948 P_0_5_5 net23_8 0.00326259f
C1949 P_0_5_5 net73 0.000502125f
C1950 P_0_6 VDD_1 0.0010201f
C1951 P_0_6 VSS_0 0.00764538f
C1952 P_0_6 WL_0 7.53132e-05f
C1953 P_0_6 WL_0_1 0.000180758f
C1954 P_0_6 WL_0_10 0.000325965f
C1955 P_0_6 WL_0_11 0.000296332f
C1956 P_0_6 WL_0_12 0.000325965f
C1957 P_0_6 WL_0_13 0.000325965f
C1958 P_0_6 WL_0_14 0.000325965f
C1959 P_0_6 WL_0_15 0.000711197f
C1960 P_0_6 WL_0_2 0.000196805f
C1961 P_0_6 WL_0_3 0.000196805f
C1962 P_0_6 WL_0_4 0.000196805f
C1963 P_0_6 WL_0_5 0.000196805f
C1964 P_0_6 WL_0_6 0.000196805f
C1965 P_0_6 WL_0_7 0.000196805f
C1966 P_0_6 WL_0_9 0.000207433f
C1967 P_0_6 XB_0_6 0.00179734f
C1968 P_0_6 net25_3 1.03006e-05f
C1969 P_0_6 net25_7 2.66629e-05f
C1970 P_0_6 net26 0.00854611f
C1971 P_0_6 net26_11 0.00501001f
C1972 P_0_6 net26_3 0.00804825f
C1973 P_0_6 net26_4 0.00810735f
C1974 P_0_6 net26_6 0.00323792f
C1975 P_0_6 net74 0.000302407f
C1976 P_0_6_1 VDD_1 0.00218522f
C1977 P_0_6_1 VSS_0 0.0163776f
C1978 P_0_6_1 XB_0_6 0.00385018f
C1979 P_0_6_1 net26_2 0.00741427f
C1980 P_0_6_1 net74 0.000647803f
C1981 P_0_6_2 VDD_1 0.00397541f
C1982 P_0_6_2 VSS_0 0.0297945f
C1983 P_0_6_2 WL_0_16 0.000149858f
C1984 P_0_6_2 WL_0_17 0.000149858f
C1985 P_0_6_2 WL_0_18 0.000149858f
C1986 P_0_6_2 WL_0_19 0.000149858f
C1987 P_0_6_2 WL_0_20 0.000149858f
C1988 P_0_6_2 WL_0_21 0.000149858f
C1989 P_0_6_2 WL_0_22 0.000149858f
C1990 P_0_6_2 WL_0_23 0.000149858f
C1991 P_0_6_2 WL_0_24 0.000149858f
C1992 P_0_6_2 WL_0_25 0.000149858f
C1993 P_0_6_2 WL_0_26 0.000149858f
C1994 P_0_6_2 WL_0_27 0.000149858f
C1995 P_0_6_2 WL_0_28 0.000149858f
C1996 P_0_6_2 WL_0_29 0.000149858f
C1997 P_0_6_2 XB_0_5_1 1.59288e-05f
C1998 P_0_6_2 XB_0_6 0.00700433f
C1999 P_0_6_2 net25_2 1.03006e-05f
C2000 P_0_6_2 net25_4 1.7536e-05f
C2001 P_0_6_2 net26_5 0.00323792f
C2002 P_0_6_2 net26_9 0.00778499f
C2003 P_0_6_2 net74 0.0011785f
C2004 P_0_6_3 VDD_1 0.000441045f
C2005 P_0_6_3 VSS_0 0.0033055f
C2006 P_0_6_3 XB_0_6 0.000777084f
C2007 P_0_6_3 net26_7 0.00161896f
C2008 P_0_6_3 net74 0.000130746f
C2009 P_0_6_4 VDD_1 0.000889091f
C2010 P_0_6_4 VSS_0 0.00666347f
C2011 P_0_6_4 WL_0_30 0.000149858f
C2012 P_0_6_4 WL_0_31 0.000149858f
C2013 P_0_6_4 WL_0_8 0.000196805f
C2014 P_0_6_4 XB_0_6_2 0.0015665f
C2015 P_0_6_4 net28_4 1.50933e-05f
C2016 P_0_6_4 net28_7 2.29489e-05f
C2017 P_0_6_4 net29 3.71994e-05f
C2018 P_0_6_4 net29_11 2.18075e-05f
C2019 P_0_6_4 net29_2 3.22728e-05f
C2020 P_0_6_4 net29_3 3.50323e-05f
C2021 P_0_6_4 net29_4 3.52896e-05f
C2022 P_0_6_4 net29_5 1.4094e-05f
C2023 P_0_6_4 net29_6 1.4094e-05f
C2024 P_0_6_4 net29_8 1.4094e-05f
C2025 P_0_6_4 net29_9 3.38864e-05f
C2026 P_0_6_4 net74 0.000263568f
C2027 P_0_6_5 VDD_1 0.00174618f
C2028 P_0_6_5 VSS_0 0.0130871f
C2029 P_0_6_5 XB_0_6_3 0.00307662f
C2030 P_0_6_5 net26_8 0.00323792f
C2031 P_0_6_5 net74 0.000517649f
C2032 P_0_7 VDD_1 0.0010267f
C2033 P_0_7 VSS_0 0.00773196f
C2034 P_0_7 WL_0 7.43584e-05f
C2035 P_0_7 WL_0_1 0.000178466f
C2036 P_0_7 WL_0_10 0.000321833f
C2037 P_0_7 WL_0_11 0.000292575f
C2038 P_0_7 WL_0_12 0.000321833f
C2039 P_0_7 WL_0_13 0.000321833f
C2040 P_0_7 WL_0_14 0.000321833f
C2041 P_0_7 WL_0_15 0.000702181f
C2042 P_0_7 WL_0_2 0.00019431f
C2043 P_0_7 WL_0_3 0.00019431f
C2044 P_0_7 WL_0_4 0.00019431f
C2045 P_0_7 WL_0_5 0.00019431f
C2046 P_0_7 WL_0_6 0.00019431f
C2047 P_0_7 WL_0_7 0.00019431f
C2048 P_0_7 WL_0_8 0.00019431f
C2049 P_0_7 WL_0_9 0.000204803f
C2050 P_0_7 XB_0_7 0.00179484f
C2051 P_0_7 net28_7 1.39541e-05f
C2052 P_0_7 net29 0.00857172f
C2053 P_0_7 net29_11 0.00502502f
C2054 P_0_7 net29_3 0.00807236f
C2055 P_0_7 net29_4 0.00813163f
C2056 P_0_7 net29_6 0.00324762f
C2057 P_0_7 net75 0.000279393f
C2058 P_0_7_1 VDD_1 0.00219936f
C2059 P_0_7_1 VSS_0 0.0165631f
C2060 P_0_7_1 XB_0_7 0.00384482f
C2061 P_0_7_1 net29_2 0.00743648f
C2062 P_0_7_1 net75 0.000598504f
C2063 P_0_7_2 VDD_1 0.00400112f
C2064 P_0_7_2 VSS_0 0.0301319f
C2065 P_0_7_2 WL_0_16 0.000147958f
C2066 P_0_7_2 WL_0_17 0.000147958f
C2067 P_0_7_2 WL_0_18 0.000147958f
C2068 P_0_7_2 WL_0_19 0.000147958f
C2069 P_0_7_2 WL_0_20 0.000147958f
C2070 P_0_7_2 WL_0_21 0.000147958f
C2071 P_0_7_2 WL_0_22 0.000147958f
C2072 P_0_7_2 WL_0_23 0.000147958f
C2073 P_0_7_2 WL_0_24 0.000147958f
C2074 P_0_7_2 WL_0_25 0.000147958f
C2075 P_0_7_2 WL_0_26 0.000147958f
C2076 P_0_7_2 WL_0_27 0.000147958f
C2077 P_0_7_2 WL_0_28 0.000147958f
C2078 P_0_7_2 WL_0_29 0.000147958f
C2079 P_0_7_2 WL_0_30 0.000147958f
C2080 P_0_7_2 WL_0_31 0.000147958f
C2081 P_0_7_2 XB_0_7 0.00699458f
C2082 P_0_7_2 net29_5 0.00324762f
C2083 P_0_7_2 net29_9 0.00780831f
C2084 P_0_7_2 net75 0.00108881f
C2085 P_0_7_3 VDD_1 0.000443898f
C2086 P_0_7_3 VSS_0 0.00334293f
C2087 P_0_7_3 XB_0_7 0.000776003f
C2088 P_0_7_3 net29_7 0.00162381f
C2089 P_0_7_3 net75 0.000120796f
C2090 P_0_7_4 VDD_1 0.000894842f
C2091 P_0_7_4 VSS_0 0.00673893f
C2092 P_0_7_4 XB_0_7_2 0.00156432f
C2093 P_0_7_4 net75 0.00024351f
C2094 P_0_7_5 VDD_1 0.00175747f
C2095 P_0_7_5 VSS_0 0.0132353f
C2096 P_0_7_5 XB_0_7_3 0.00307234f
C2097 P_0_7_5 net29_8 0.00324762f
C2098 P_0_7_5 net75 0.000478255f
C2099 VDD_1 VSS_0 0.494792f
C2100 VDD_1 WL_0 0.00150155f
C2101 VDD_1 WL_0_1 0.00360384f
C2102 VDD_1 WL_0_10 0.0064989f
C2103 VDD_1 WL_0_11 0.00590809f
C2104 VDD_1 WL_0_12 0.0064989f
C2105 VDD_1 WL_0_13 0.0064989f
C2106 VDD_1 WL_0_14 0.0064989f
C2107 VDD_1 WL_0_15 0.0141794f
C2108 VDD_1 WL_0_16 0.00298778f
C2109 VDD_1 WL_0_17 0.00298778f
C2110 VDD_1 WL_0_18 0.00298778f
C2111 VDD_1 WL_0_19 0.00298778f
C2112 VDD_1 WL_0_2 0.00392377f
C2113 VDD_1 WL_0_20 0.00298778f
C2114 VDD_1 WL_0_21 0.00298778f
C2115 VDD_1 WL_0_22 0.00298778f
C2116 VDD_1 WL_0_23 0.00298778f
C2117 VDD_1 WL_0_24 0.00298778f
C2118 VDD_1 WL_0_25 0.00298778f
C2119 VDD_1 WL_0_26 0.00298778f
C2120 VDD_1 WL_0_27 0.00298778f
C2121 VDD_1 WL_0_28 0.00298778f
C2122 VDD_1 WL_0_29 0.00298778f
C2123 VDD_1 WL_0_3 0.00392377f
C2124 VDD_1 WL_0_30 0.00298778f
C2125 VDD_1 WL_0_31 0.00298778f
C2126 VDD_1 WL_0_4 0.00392377f
C2127 VDD_1 WL_0_5 0.00392377f
C2128 VDD_1 WL_0_6 0.00392377f
C2129 VDD_1 WL_0_7 0.00392377f
C2130 VDD_1 WL_0_8 0.00392377f
C2131 VDD_1 WL_0_9 0.00413566f
C2132 VDD_1 XB_0_0 0.00350248f
C2133 VDD_1 XB_0_0_1 0.0146417f
C2134 VDD_1 XB_0_0_2 0.00206944f
C2135 VDD_1 XB_0_0_3 0.00413888f
C2136 VDD_1 XB_0_1 0.0035737f
C2137 VDD_1 XB_0_1_1 0.0149395f
C2138 VDD_1 XB_0_1_2 0.00211152f
C2139 VDD_1 XB_0_1_3 0.00422303f
C2140 VDD_1 XB_0_2 0.00345063f
C2141 VDD_1 XB_0_2_1 0.014425f
C2142 VDD_1 XB_0_2_2 0.0020388f
C2143 VDD_1 XB_0_2_3 0.0040776f
C2144 VDD_1 XB_0_3 0.00354103f
C2145 VDD_1 XB_0_3_1 0.0148029f
C2146 VDD_1 XB_0_3_2 0.00209221f
C2147 VDD_1 XB_0_3_3 0.00418443f
C2148 VDD_1 XB_0_4 0.00352449f
C2149 VDD_1 XB_0_4_1 0.0147337f
C2150 VDD_1 XB_0_4_2 0.00208244f
C2151 VDD_1 XB_0_4_3 0.00416488f
C2152 VDD_1 XB_0_5 0.00349134f
C2153 VDD_1 XB_0_5_1 0.0145952f
C2154 VDD_1 XB_0_5_2 0.00206286f
C2155 VDD_1 XB_0_5_3 0.00412572f
C2156 VDD_1 XB_0_6 0.00359856f
C2157 VDD_1 XB_0_6_1 0.0150434f
C2158 VDD_1 XB_0_6_2 0.00212621f
C2159 VDD_1 XB_0_6_3 0.00425242f
C2160 VDD_1 XB_0_7 0.00354326f
C2161 VDD_1 XB_0_7_1 0.0148122f
C2162 VDD_1 XB_0_7_2 0.00209353f
C2163 VDD_1 XB_0_7_3 0.00418706f
C2164 VDD_1 net12 0.0024517f
C2165 VDD_1 net12_2 0.00319357f
C2166 VDD_1 net12_3 0.00319357f
C2167 VDD_1 net12_4 0.00543684f
C2168 VDD_1 net12_6 0.00231304f
C2169 VDD_1 net12_7 0.00826654f
C2170 VDD_1 net13 0.00435445f
C2171 VDD_1 net13_11 0.00255272f
C2172 VDD_1 net13_2 0.00377775f
C2173 VDD_1 net13_3 0.00410077f
C2174 VDD_1 net13_4 0.00413088f
C2175 VDD_1 net13_5 0.0016498f
C2176 VDD_1 net13_6 0.0016498f
C2177 VDD_1 net13_7 0.000824899f
C2178 VDD_1 net13_8 0.0016498f
C2179 VDD_1 net13_9 0.00396663f
C2180 VDD_1 net15 0.00249642f
C2181 VDD_1 net15_2 0.00325182f
C2182 VDD_1 net15_3 0.00325182f
C2183 VDD_1 net15_4 0.005536f
C2184 VDD_1 net15_6 0.00235523f
C2185 VDD_1 net15_7 0.00841731f
C2186 VDD_1 net16 0.00440628f
C2187 VDD_1 net16_11 0.00258311f
C2188 VDD_1 net16_2 0.00382272f
C2189 VDD_1 net16_3 0.00414959f
C2190 VDD_1 net16_4 0.00418006f
C2191 VDD_1 net16_5 0.00166944f
C2192 VDD_1 net16_6 0.00166944f
C2193 VDD_1 net16_7 0.000834719f
C2194 VDD_1 net16_8 0.00166944f
C2195 VDD_1 net16_9 0.00401386f
C2196 VDD_1 net19 0.00247064f
C2197 VDD_1 net19_2 0.00321824f
C2198 VDD_1 net19_3 0.00321824f
C2199 VDD_1 net19_4 0.00547884f
C2200 VDD_1 net19_6 0.00233091f
C2201 VDD_1 net19_7 0.00833039f
C2202 VDD_1 net20 0.00440242f
C2203 VDD_1 net20_11 0.00258084f
C2204 VDD_1 net20_2 0.00381936f
C2205 VDD_1 net20_3 0.00414595f
C2206 VDD_1 net20_4 0.00417639f
C2207 VDD_1 net20_5 0.00166797f
C2208 VDD_1 net20_6 0.00166797f
C2209 VDD_1 net20_7 0.000833987f
C2210 VDD_1 net20_8 0.00166797f
C2211 VDD_1 net20_9 0.00401033f
C2212 VDD_1 net22 0.0024488f
C2213 VDD_1 net22_2 0.00318979f
C2214 VDD_1 net22_3 0.00318979f
C2215 VDD_1 net22_4 0.00543041f
C2216 VDD_1 net22_6 0.0023103f
C2217 VDD_1 net22_7 0.00825676f
C2218 VDD_1 net23 0.00445015f
C2219 VDD_1 net23_11 0.00260882f
C2220 VDD_1 net23_2 0.00386078f
C2221 VDD_1 net23_3 0.0041909f
C2222 VDD_1 net23_4 0.00422168f
C2223 VDD_1 net23_5 0.00168606f
C2224 VDD_1 net23_6 0.00168606f
C2225 VDD_1 net23_7 0.00084303f
C2226 VDD_1 net23_8 0.00168606f
C2227 VDD_1 net23_9 0.00405382f
C2228 VDD_1 net25 0.00244115f
C2229 VDD_1 net25_2 0.00317983f
C2230 VDD_1 net25_3 0.00317983f
C2231 VDD_1 net25_4 0.00541344f
C2232 VDD_1 net25_6 0.00230309f
C2233 VDD_1 net25_7 0.00823097f
C2234 VDD_1 net26 0.00446316f
C2235 VDD_1 net26_11 0.00261645f
C2236 VDD_1 net26_2 0.00387206f
C2237 VDD_1 net26_3 0.00420315f
C2238 VDD_1 net26_4 0.00423401f
C2239 VDD_1 net26_5 0.00169099f
C2240 VDD_1 net26_6 0.00169099f
C2241 VDD_1 net26_7 0.000845494f
C2242 VDD_1 net26_8 0.00169099f
C2243 VDD_1 net26_9 0.00406566f
C2244 VDD_1 net28 0.00247122f
C2245 VDD_1 net28_2 0.00321899f
C2246 VDD_1 net28_3 0.00321899f
C2247 VDD_1 net28_4 0.00548012f
C2248 VDD_1 net28_6 0.00233145f
C2249 VDD_1 net28_7 0.00833234f
C2250 VDD_1 net29 0.00441804f
C2251 VDD_1 net29_11 0.00259f
C2252 VDD_1 net29_2 0.00383292f
C2253 VDD_1 net29_3 0.00416066f
C2254 VDD_1 net29_4 0.00419121f
C2255 VDD_1 net29_5 0.00167389f
C2256 VDD_1 net29_6 0.00167389f
C2257 VDD_1 net29_7 0.000836946f
C2258 VDD_1 net29_8 0.00167389f
C2259 VDD_1 net29_9 0.00402456f
C2260 VDD_1 net4 0.00241083f
C2261 VDD_1 net4_2 0.00314034f
C2262 VDD_1 net4_3 0.00314034f
C2263 VDD_1 net4_4 0.00534621f
C2264 VDD_1 net4_6 0.00227449f
C2265 VDD_1 net4_7 0.00812875f
C2266 VDD_1 net5 0.0044023f
C2267 VDD_1 net5_11 0.00258077f
C2268 VDD_1 net5_2 0.00381927f
C2269 VDD_1 net5_3 0.00414584f
C2270 VDD_1 net5_4 0.00417628f
C2271 VDD_1 net5_5 0.00166793f
C2272 VDD_1 net5_6 0.00166793f
C2273 VDD_1 net5_7 0.000833965f
C2274 VDD_1 net5_8 0.00166793f
C2275 VDD_1 net5_9 0.00401023f
C2276 VDD_1 net68 0.00879947f
C2277 VDD_1 net69 0.00882828f
C2278 VDD_1 net70 0.00902077f
C2279 VDD_1 net71 0.0088172f
C2280 VDD_1 net72 0.00879579f
C2281 VDD_1 net73 0.00897135f
C2282 VDD_1 net74 0.0086696f
C2283 VDD_1 net75 0.00908596f
C2284 VDD_1 net8 0.00249645f
C2285 VDD_1 net8_2 0.00325186f
C2286 VDD_1 net8_3 0.00325186f
C2287 VDD_1 net8_4 0.00553608f
C2288 VDD_1 net8_6 0.00235526f
C2289 VDD_1 net8_7 0.00841743f
C2290 VDD_1 net9 0.0044115f
C2291 VDD_1 net9_11 0.00258617f
C2292 VDD_1 net9_2 0.00382725f
C2293 VDD_1 net9_3 0.0041545f
C2294 VDD_1 net9_4 0.00418501f
C2295 VDD_1 net9_5 0.00167142f
C2296 VDD_1 net9_6 0.00167142f
C2297 VDD_1 net9_7 0.000835708f
C2298 VDD_1 net9_8 0.00167142f
C2299 VDD_1 net9_9 0.00401861f
C2300 VSS_0 WL_0 0.0085485f
C2301 VSS_0 WL_0_1 0.0205171f
C2302 VSS_0 WL_0_10 0.036999f
C2303 VSS_0 WL_0_11 0.0336355f
C2304 VSS_0 WL_0_12 0.036999f
C2305 VSS_0 WL_0_13 0.036999f
C2306 VSS_0 WL_0_14 0.036999f
C2307 VSS_0 WL_0_15 0.0807251f
C2308 VSS_0 WL_0_16 0.0170098f
C2309 VSS_0 WL_0_17 0.0170098f
C2310 VSS_0 WL_0_18 0.0170098f
C2311 VSS_0 WL_0_19 0.0170098f
C2312 VSS_0 WL_0_2 0.0223385f
C2313 VSS_0 WL_0_20 0.0170098f
C2314 VSS_0 WL_0_21 0.0170098f
C2315 VSS_0 WL_0_22 0.0170098f
C2316 VSS_0 WL_0_23 0.0170098f
C2317 VSS_0 WL_0_24 0.0170098f
C2318 VSS_0 WL_0_25 0.0170098f
C2319 VSS_0 WL_0_26 0.0170098f
C2320 VSS_0 WL_0_27 0.0170098f
C2321 VSS_0 WL_0_28 0.0170098f
C2322 VSS_0 WL_0_29 0.0170098f
C2323 VSS_0 WL_0_3 0.0223385f
C2324 VSS_0 WL_0_30 0.0170098f
C2325 VSS_0 WL_0_31 0.0170098f
C2326 VSS_0 WL_0_4 0.0223385f
C2327 VSS_0 WL_0_5 0.0223385f
C2328 VSS_0 WL_0_6 0.0223385f
C2329 VSS_0 WL_0_7 0.0223385f
C2330 VSS_0 WL_0_8 0.0223385f
C2331 VSS_0 WL_0_9 0.0235448f
C2332 VSS_0 XB_0_0 0.00910267f
C2333 VSS_0 XB_0_0_1 0.0380527f
C2334 VSS_0 XB_0_0_2 0.00537831f
C2335 VSS_0 XB_0_0_3 0.0107566f
C2336 VSS_0 XB_0_1 0.009184f
C2337 VSS_0 XB_0_1_1 0.0383927f
C2338 VSS_0 XB_0_1_2 0.00542636f
C2339 VSS_0 XB_0_1_3 0.0108527f
C2340 VSS_0 XB_0_2 0.00913229f
C2341 VSS_0 XB_0_2_1 0.0381765f
C2342 VSS_0 XB_0_2_2 0.00539581f
C2343 VSS_0 XB_0_2_3 0.0107916f
C2344 VSS_0 XB_0_3 0.00909969f
C2345 VSS_0 XB_0_3_1 0.0380403f
C2346 VSS_0 XB_0_3_2 0.00537655f
C2347 VSS_0 XB_0_3_3 0.0107531f
C2348 VSS_0 XB_0_4 0.0091367f
C2349 VSS_0 XB_0_4_1 0.038195f
C2350 VSS_0 XB_0_4_2 0.00539842f
C2351 VSS_0 XB_0_4_3 0.0107968f
C2352 VSS_0 XB_0_5 0.00913556f
C2353 VSS_0 XB_0_5_1 0.0381902f
C2354 VSS_0 XB_0_5_2 0.00539774f
C2355 VSS_0 XB_0_5_3 0.0107955f
C2356 VSS_0 XB_0_6 0.0091283f
C2357 VSS_0 XB_0_6_1 0.0381599f
C2358 VSS_0 XB_0_6_2 0.00539345f
C2359 VSS_0 XB_0_6_3 0.0107869f
C2360 VSS_0 XB_0_7 0.00956672f
C2361 VSS_0 XB_0_7_1 0.0399926f
C2362 VSS_0 XB_0_7_2 0.00565249f
C2363 VSS_0 XB_0_7_3 0.011305f
C2364 VSS_0 net12 0.00633727f
C2365 VSS_0 net12_2 0.00825488f
C2366 VSS_0 net12_3 0.00825488f
C2367 VSS_0 net12_4 0.0140534f
C2368 VSS_0 net12_6 0.00597886f
C2369 VSS_0 net12_7 0.0213677f
C2370 VSS_0 net13 0.0197098f
C2371 VSS_0 net13_11 0.0115545f
C2372 VSS_0 net13_2 0.0170994f
C2373 VSS_0 net13_3 0.0185615f
C2374 VSS_0 net13_4 0.0186978f
C2375 VSS_0 net13_5 0.00746757f
C2376 VSS_0 net13_6 0.00746757f
C2377 VSS_0 net13_7 0.00373378f
C2378 VSS_0 net13_8 0.00746757f
C2379 VSS_0 net13_9 0.0179544f
C2380 VSS_0 net15 0.00634221f
C2381 VSS_0 net15_2 0.00826132f
C2382 VSS_0 net15_3 0.00826132f
C2383 VSS_0 net15_4 0.0140644f
C2384 VSS_0 net15_6 0.00598352f
C2385 VSS_0 net15_7 0.0213844f
C2386 VSS_0 net16 0.0196028f
C2387 VSS_0 net16_11 0.0114918f
C2388 VSS_0 net16_2 0.0170066f
C2389 VSS_0 net16_3 0.0184608f
C2390 VSS_0 net16_4 0.0185963f
C2391 VSS_0 net16_5 0.00742704f
C2392 VSS_0 net16_6 0.00742704f
C2393 VSS_0 net16_7 0.00371352f
C2394 VSS_0 net16_8 0.00742704f
C2395 VSS_0 net16_9 0.0178569f
C2396 VSS_0 net19 0.006402f
C2397 VSS_0 net19_2 0.00833921f
C2398 VSS_0 net19_3 0.00833921f
C2399 VSS_0 net19_4 0.014197f
C2400 VSS_0 net19_6 0.00603993f
C2401 VSS_0 net19_7 0.021586f
C2402 VSS_0 net20 0.0197847f
C2403 VSS_0 net20_11 0.0115984f
C2404 VSS_0 net20_2 0.0171645f
C2405 VSS_0 net20_3 0.0186321f
C2406 VSS_0 net20_4 0.018769f
C2407 VSS_0 net20_5 0.00749598f
C2408 VSS_0 net20_6 0.00749598f
C2409 VSS_0 net20_7 0.00374799f
C2410 VSS_0 net20_8 0.00749598f
C2411 VSS_0 net20_9 0.0180227f
C2412 VSS_0 net22 0.00641584f
C2413 VSS_0 net22_2 0.00835724f
C2414 VSS_0 net22_3 0.00835724f
C2415 VSS_0 net22_4 0.0142276f
C2416 VSS_0 net22_6 0.00605299f
C2417 VSS_0 net22_7 0.0216327f
C2418 VSS_0 net23 0.0196961f
C2419 VSS_0 net23_11 0.0115465f
C2420 VSS_0 net23_2 0.0170876f
C2421 VSS_0 net23_3 0.0185487f
C2422 VSS_0 net23_4 0.0186849f
C2423 VSS_0 net23_5 0.00746241f
C2424 VSS_0 net23_6 0.00746241f
C2425 VSS_0 net23_7 0.0037312f
C2426 VSS_0 net23_8 0.00746241f
C2427 VSS_0 net23_9 0.017942f
C2428 VSS_0 net25 0.00637978f
C2429 VSS_0 net25_2 0.00831026f
C2430 VSS_0 net25_3 0.00831026f
C2431 VSS_0 net25_4 0.0141477f
C2432 VSS_0 net25_6 0.00601896f
C2433 VSS_0 net25_7 0.0215111f
C2434 VSS_0 net26 0.019764f
C2435 VSS_0 net26_11 0.0115863f
C2436 VSS_0 net26_2 0.0171464f
C2437 VSS_0 net26_3 0.0186126f
C2438 VSS_0 net26_4 0.0187493f
C2439 VSS_0 net26_5 0.0074881f
C2440 VSS_0 net26_6 0.0074881f
C2441 VSS_0 net26_7 0.00374405f
C2442 VSS_0 net26_8 0.0074881f
C2443 VSS_0 net26_9 0.0180038f
C2444 VSS_0 net28 0.00634327f
C2445 VSS_0 net28_2 0.0082627f
C2446 VSS_0 net28_3 0.0082627f
C2447 VSS_0 net28_4 0.0140667f
C2448 VSS_0 net28_6 0.00598452f
C2449 VSS_0 net28_7 0.021388f
C2450 VSS_0 net29 0.0198105f
C2451 VSS_0 net29_11 0.0116135f
C2452 VSS_0 net29_2 0.0171868f
C2453 VSS_0 net29_3 0.0186564f
C2454 VSS_0 net29_4 0.0187934f
C2455 VSS_0 net29_5 0.00750573f
C2456 VSS_0 net29_6 0.00750573f
C2457 VSS_0 net29_7 0.00375286f
C2458 VSS_0 net29_8 0.00750573f
C2459 VSS_0 net29_9 0.0180461f
C2460 VSS_0 net4 0.00630793f
C2461 VSS_0 net4_2 0.00821667f
C2462 VSS_0 net4_3 0.00821667f
C2463 VSS_0 net4_4 0.0139883f
C2464 VSS_0 net4_6 0.00595118f
C2465 VSS_0 net4_7 0.0212688f
C2466 VSS_0 net5 0.0200082f
C2467 VSS_0 net5_11 0.0117294f
C2468 VSS_0 net5_2 0.0173583f
C2469 VSS_0 net5_3 0.0188426f
C2470 VSS_0 net5_4 0.0189809f
C2471 VSS_0 net5_5 0.00758063f
C2472 VSS_0 net5_6 0.00758063f
C2473 VSS_0 net5_7 0.00379031f
C2474 VSS_0 net5_8 0.00758063f
C2475 VSS_0 net5_9 0.0182262f
C2476 VSS_0 net68 0.00033596f
C2477 VSS_0 net69 0.000363815f
C2478 VSS_0 net70 0.000391486f
C2479 VSS_0 net71 0.00041472f
C2480 VSS_0 net72 0.000345976f
C2481 VSS_0 net73 0.000463268f
C2482 VSS_0 net74 0.000454624f
C2483 VSS_0 net75 0.000259992f
C2484 VSS_0 net8 0.00625725f
C2485 VSS_0 net8_2 0.00815066f
C2486 VSS_0 net8_3 0.00815066f
C2487 VSS_0 net8_4 0.013876f
C2488 VSS_0 net8_6 0.00590337f
C2489 VSS_0 net8_7 0.0210979f
C2490 VSS_0 net9 0.0196229f
C2491 VSS_0 net9_11 0.0115036f
C2492 VSS_0 net9_2 0.0170241f
C2493 VSS_0 net9_3 0.0184798f
C2494 VSS_0 net9_4 0.0186155f
C2495 VSS_0 net9_5 0.00743467f
C2496 VSS_0 net9_6 0.00743467f
C2497 VSS_0 net9_7 0.00371733f
C2498 VSS_0 net9_8 0.00743467f
C2499 VSS_0 net9_9 0.0178753f
C2500 WL_0 XB_0_0 6.185e-05f
C2501 WL_0 XB_0_1 5.9537e-05f
C2502 WL_0 XB_0_2 6.20837e-05f
C2503 WL_0 XB_0_3 6.07902e-05f
C2504 WL_0 XB_0_4 6.10663e-05f
C2505 WL_0 XB_0_5 6.4196e-05f
C2506 WL_0 XB_0_6 6.22951e-05f
C2507 WL_0 XB_0_7 6.34375e-05f
C2508 WL_0 net12_6 0.000765941f
C2509 WL_0 net13 0.00108415f
C2510 WL_0 net15_6 0.000759879f
C2511 WL_0 net16 0.00108703f
C2512 WL_0 net19_6 0.000765492f
C2513 WL_0 net20 0.00108358f
C2514 WL_0 net22_4 0.00076164f
C2515 WL_0 net23 0.00108907f
C2516 WL_0 net25_4 0.000754782f
C2517 WL_0 net26 0.00109061f
C2518 WL_0 net28_4 0.000751966f
C2519 WL_0 net29 0.00108687f
C2520 WL_0 net4_6 0.000758713f
C2521 WL_0 net5 0.00109016f
C2522 WL_0 net8_6 0.000761803f
C2523 WL_0 net9 0.001087f
C2524 WL_0_1 XB_0_0 0.000148445f
C2525 WL_0_1 XB_0_1 0.000142894f
C2526 WL_0_1 XB_0_2 0.000149006f
C2527 WL_0_1 XB_0_3 0.000145902f
C2528 WL_0_1 XB_0_4 0.000146564f
C2529 WL_0_1 XB_0_5 0.000154076f
C2530 WL_0_1 XB_0_6 0.000149514f
C2531 WL_0_1 XB_0_7 0.000152255f
C2532 WL_0_1 net12_6 0.00183832f
C2533 WL_0_1 net13 0.00260204f
C2534 WL_0_1 net15_6 0.00182377f
C2535 WL_0_1 net16 0.00260896f
C2536 WL_0_1 net19_6 0.00183724f
C2537 WL_0_1 net20 0.00260069f
C2538 WL_0_1 net22_6 0.001828f
C2539 WL_0_1 net23 0.00261385f
C2540 WL_0_1 net25_4 0.00181154f
C2541 WL_0_1 net26 0.00261756f
C2542 WL_0_1 net28_4 0.00180478f
C2543 WL_0_1 net29 0.00260857f
C2544 WL_0_1 net4 0.00182097f
C2545 WL_0_1 net5 0.00261649f
C2546 WL_0_1 net68 1.75626e-05f
C2547 WL_0_1 net69 1.67926e-05f
C2548 WL_0_1 net70 1.74875e-05f
C2549 WL_0_1 net71 1.65767e-05f
C2550 WL_0_1 net72 1.68613e-05f
C2551 WL_0_1 net73 1.55389e-05f
C2552 WL_0_1 net74 1.56767e-05f
C2553 WL_0_1 net75 1.7595e-05f
C2554 WL_0_1 net8_6 0.00182839f
C2555 WL_0_1 net9 0.00260888f
C2556 WL_0_10 XB_0_0_3 0.000267695f
C2557 WL_0_10 XB_0_1 0.000257684f
C2558 WL_0_10 XB_0_2 0.000268707f
C2559 WL_0_10 XB_0_3 0.000263108f
C2560 WL_0_10 XB_0_4 0.000264303f
C2561 WL_0_10 XB_0_5 0.000277849f
C2562 WL_0_10 XB_0_6 0.000269621f
C2563 WL_0_10 XB_0_7 0.000274566f
C2564 WL_0_10 net12_6 0.00331509f
C2565 WL_0_10 net13 0.00469233f
C2566 WL_0_10 net15_6 0.00328886f
C2567 WL_0_10 net16 0.0047048f
C2568 WL_0_10 net19_6 0.00331315f
C2569 WL_0_10 net20 0.00468988f
C2570 WL_0_10 net22_6 0.00329648f
C2571 WL_0_10 net23 0.00471362f
C2572 WL_0_10 net25_6 0.0032668f
C2573 WL_0_10 net26 0.00472031f
C2574 WL_0_10 net28_4 0.00325461f
C2575 WL_0_10 net29 0.0047041f
C2576 WL_0_10 net4 0.00328381f
C2577 WL_0_10 net5_8 0.00471837f
C2578 WL_0_10 net68 3.16711e-05f
C2579 WL_0_10 net69 3.02825e-05f
C2580 WL_0_10 net70 3.15357e-05f
C2581 WL_0_10 net71 2.98931e-05f
C2582 WL_0_10 net72 3.04063e-05f
C2583 WL_0_10 net73 2.80216e-05f
C2584 WL_0_10 net74 2.82702e-05f
C2585 WL_0_10 net75 3.17295e-05f
C2586 WL_0_10 net8 0.00329718f
C2587 WL_0_10 net9 0.00470466f
C2588 WL_0_11 XB_0_0_3 0.000243359f
C2589 WL_0_11 XB_0_1_3 0.000234258f
C2590 WL_0_11 XB_0_2 0.000244279f
C2591 WL_0_11 XB_0_3 0.000239189f
C2592 WL_0_11 XB_0_4 0.000240275f
C2593 WL_0_11 XB_0_5 0.00025259f
C2594 WL_0_11 XB_0_6 0.00024511f
C2595 WL_0_11 XB_0_7 0.000249605f
C2596 WL_0_11 net12 0.00301372f
C2597 WL_0_11 net13 0.00426575f
C2598 WL_0_11 net15_6 0.00298987f
C2599 WL_0_11 net16 0.00427709f
C2600 WL_0_11 net19_6 0.00301195f
C2601 WL_0_11 net20 0.00426353f
C2602 WL_0_11 net22_6 0.0029968f
C2603 WL_0_11 net23 0.00428511f
C2604 WL_0_11 net25_6 0.00296981f
C2605 WL_0_11 net26 0.00429119f
C2606 WL_0_11 net28_6 0.00295874f
C2607 WL_0_11 net29 0.00427645f
C2608 WL_0_11 net4 0.00298528f
C2609 WL_0_11 net5_8 0.00428943f
C2610 WL_0_11 net68 2.87919e-05f
C2611 WL_0_11 net69 2.75295e-05f
C2612 WL_0_11 net70 2.86688e-05f
C2613 WL_0_11 net71 2.71755e-05f
C2614 WL_0_11 net72 2.76421e-05f
C2615 WL_0_11 net73 2.54742e-05f
C2616 WL_0_11 net74 2.57002e-05f
C2617 WL_0_11 net75 2.8845e-05f
C2618 WL_0_11 net8 0.00299744f
C2619 WL_0_11 net9_8 0.00427697f
C2620 WL_0_12 XB_0_0_3 0.000267695f
C2621 WL_0_12 XB_0_1_3 0.000257684f
C2622 WL_0_12 XB_0_2_3 0.000268707f
C2623 WL_0_12 XB_0_3 0.000263108f
C2624 WL_0_12 XB_0_4 0.000264303f
C2625 WL_0_12 XB_0_5 0.000277849f
C2626 WL_0_12 XB_0_6 0.000269621f
C2627 WL_0_12 XB_0_7 0.000274566f
C2628 WL_0_12 net12 0.00331509f
C2629 WL_0_12 net13_8 0.00469233f
C2630 WL_0_12 net15 0.00328886f
C2631 WL_0_12 net16 0.0047048f
C2632 WL_0_12 net19_6 0.00331315f
C2633 WL_0_12 net20 0.00468988f
C2634 WL_0_12 net22_6 0.00329648f
C2635 WL_0_12 net23 0.00471362f
C2636 WL_0_12 net25_6 0.0032668f
C2637 WL_0_12 net26 0.00472031f
C2638 WL_0_12 net28_6 0.00325461f
C2639 WL_0_12 net29 0.0047041f
C2640 WL_0_12 net4 0.00328381f
C2641 WL_0_12 net5_8 0.00471837f
C2642 WL_0_12 net68 3.16711e-05f
C2643 WL_0_12 net69 3.02825e-05f
C2644 WL_0_12 net70 3.15357e-05f
C2645 WL_0_12 net71 2.98931e-05f
C2646 WL_0_12 net72 3.04063e-05f
C2647 WL_0_12 net73 2.80216e-05f
C2648 WL_0_12 net74 2.82702e-05f
C2649 WL_0_12 net75 3.17295e-05f
C2650 WL_0_12 net8 0.00329718f
C2651 WL_0_12 net9_8 0.00470466f
C2652 WL_0_13 XB_0_0_3 0.000267695f
C2653 WL_0_13 XB_0_1_3 0.000257684f
C2654 WL_0_13 XB_0_2_3 0.000268707f
C2655 WL_0_13 XB_0_3_3 0.000263108f
C2656 WL_0_13 XB_0_4 0.000264303f
C2657 WL_0_13 XB_0_5 0.000277849f
C2658 WL_0_13 XB_0_6 0.000269621f
C2659 WL_0_13 XB_0_7 0.000274566f
C2660 WL_0_13 net12 0.00331509f
C2661 WL_0_13 net13_8 0.00469233f
C2662 WL_0_13 net15 0.00328886f
C2663 WL_0_13 net16_8 0.0047048f
C2664 WL_0_13 net19 0.00331315f
C2665 WL_0_13 net20 0.00468988f
C2666 WL_0_13 net22_6 0.00329648f
C2667 WL_0_13 net23 0.00471362f
C2668 WL_0_13 net25_6 0.0032668f
C2669 WL_0_13 net26 0.00472031f
C2670 WL_0_13 net28_6 0.00325461f
C2671 WL_0_13 net29 0.0047041f
C2672 WL_0_13 net4 0.00328381f
C2673 WL_0_13 net5_8 0.00471837f
C2674 WL_0_13 net68 3.16711e-05f
C2675 WL_0_13 net69 3.02825e-05f
C2676 WL_0_13 net70 3.15357e-05f
C2677 WL_0_13 net71 2.98931e-05f
C2678 WL_0_13 net72 3.04063e-05f
C2679 WL_0_13 net73 2.80216e-05f
C2680 WL_0_13 net74 2.82702e-05f
C2681 WL_0_13 net75 3.17295e-05f
C2682 WL_0_13 net8 0.00329718f
C2683 WL_0_13 net9_8 0.00470466f
C2684 WL_0_14 XB_0_0_3 0.000267695f
C2685 WL_0_14 XB_0_1_3 0.000257684f
C2686 WL_0_14 XB_0_2_3 0.000268707f
C2687 WL_0_14 XB_0_3_3 0.000263108f
C2688 WL_0_14 XB_0_4_3 0.000264303f
C2689 WL_0_14 XB_0_5 0.000277849f
C2690 WL_0_14 XB_0_6 0.000269621f
C2691 WL_0_14 XB_0_7 0.000274566f
C2692 WL_0_14 net12 0.00331509f
C2693 WL_0_14 net13_8 0.00469233f
C2694 WL_0_14 net15 0.00328886f
C2695 WL_0_14 net16_8 0.0047048f
C2696 WL_0_14 net19 0.00331315f
C2697 WL_0_14 net20_8 0.00468988f
C2698 WL_0_14 net22 0.00329648f
C2699 WL_0_14 net23 0.00471362f
C2700 WL_0_14 net25_6 0.0032668f
C2701 WL_0_14 net26 0.00472031f
C2702 WL_0_14 net28_6 0.00325461f
C2703 WL_0_14 net29 0.0047041f
C2704 WL_0_14 net4 0.00328381f
C2705 WL_0_14 net5_8 0.00471837f
C2706 WL_0_14 net68 3.16711e-05f
C2707 WL_0_14 net69 3.02825e-05f
C2708 WL_0_14 net70 3.15357e-05f
C2709 WL_0_14 net71 2.98931e-05f
C2710 WL_0_14 net72 3.04063e-05f
C2711 WL_0_14 net73 2.80216e-05f
C2712 WL_0_14 net74 2.82702e-05f
C2713 WL_0_14 net75 3.17295e-05f
C2714 WL_0_14 net8 0.00329718f
C2715 WL_0_14 net9_8 0.00470466f
C2716 WL_0_15 XB_0_0_3 0.000584062f
C2717 WL_0_15 XB_0_1_3 0.000562219f
C2718 WL_0_15 XB_0_2_3 0.000586269f
C2719 WL_0_15 XB_0_3_3 0.000574054f
C2720 WL_0_15 XB_0_4_3 0.000576661f
C2721 WL_0_15 XB_0_5_3 0.000606216f
C2722 WL_0_15 XB_0_6 0.000588265f
C2723 WL_0_15 XB_0_7 0.000599053f
C2724 WL_0_15 net12 0.00723293f
C2725 WL_0_15 net13_8 0.0102378f
C2726 WL_0_15 net15 0.00717569f
C2727 WL_0_15 net16_8 0.010265f
C2728 WL_0_15 net19 0.00722869f
C2729 WL_0_15 net20_8 0.0102325f
C2730 WL_0_15 net22 0.00719232f
C2731 WL_0_15 net23_8 0.0102843f
C2732 WL_0_15 net25 0.00712755f
C2733 WL_0_15 net26 0.0102988f
C2734 WL_0_15 net28_6 0.00710096f
C2735 WL_0_15 net29 0.0102635f
C2736 WL_0_15 net4 0.00716467f
C2737 WL_0_15 net5_8 0.0102946f
C2738 WL_0_15 net68 6.91006e-05f
C2739 WL_0_15 net69 6.60709e-05f
C2740 WL_0_15 net70 6.88052e-05f
C2741 WL_0_15 net71 6.52213e-05f
C2742 WL_0_15 net72 6.63411e-05f
C2743 WL_0_15 net73 6.1138e-05f
C2744 WL_0_15 net74 6.16805e-05f
C2745 WL_0_15 net75 6.92281e-05f
C2746 WL_0_15 net8 0.00719385f
C2747 WL_0_15 net9_8 0.0102647f
C2748 WL_0_16 XB_0_0 0.000123069f
C2749 WL_0_16 XB_0_1 0.000118467f
C2750 WL_0_16 XB_0_2 0.000123534f
C2751 WL_0_16 XB_0_3 0.00012096f
C2752 WL_0_16 XB_0_4 0.00012151f
C2753 WL_0_16 XB_0_5 0.000127737f
C2754 WL_0_16 XB_0_6 0.000123955f
C2755 WL_0_16 XB_0_7 0.000126228f
C2756 WL_0_16 net12_4 0.00152407f
C2757 WL_0_16 net13_5 0.00215723f
C2758 WL_0_16 net15_4 0.00151201f
C2759 WL_0_16 net16_5 0.00216297f
C2760 WL_0_16 net19_4 0.00152317f
C2761 WL_0_16 net20_5 0.00215611f
C2762 WL_0_16 net22_4 0.00151551f
C2763 WL_0_16 net23_5 0.00216702f
C2764 WL_0_16 net25_4 0.00150186f
C2765 WL_0_16 net26_5 0.0021701f
C2766 WL_0_16 net28_4 0.00149626f
C2767 WL_0_16 net29_5 0.00216265f
C2768 WL_0_16 net4_4 0.00150969f
C2769 WL_0_16 net5_5 0.00216921f
C2770 WL_0_16 net68 1.45603e-05f
C2771 WL_0_16 net69 1.3922e-05f
C2772 WL_0_16 net70 1.44981e-05f
C2773 WL_0_16 net71 1.37429e-05f
C2774 WL_0_16 net72 1.39789e-05f
C2775 WL_0_16 net73 1.28825e-05f
C2776 WL_0_16 net74 1.29969e-05f
C2777 WL_0_16 net75 1.45872e-05f
C2778 WL_0_16 net8_4 0.00151583f
C2779 WL_0_16 net9_5 0.0021629f
C2780 WL_0_17 XB_0_0 0.000123069f
C2781 WL_0_17 XB_0_1 0.000118467f
C2782 WL_0_17 XB_0_2 0.000123534f
C2783 WL_0_17 XB_0_3 0.00012096f
C2784 WL_0_17 XB_0_4 0.00012151f
C2785 WL_0_17 XB_0_5 0.000127737f
C2786 WL_0_17 XB_0_6 0.000123955f
C2787 WL_0_17 XB_0_7 0.000126228f
C2788 WL_0_17 net12_4 0.00152407f
C2789 WL_0_17 net13_5 0.00215723f
C2790 WL_0_17 net15_4 0.00151201f
C2791 WL_0_17 net16_5 0.00216297f
C2792 WL_0_17 net19_4 0.00152317f
C2793 WL_0_17 net20_5 0.00215611f
C2794 WL_0_17 net22_4 0.00151551f
C2795 WL_0_17 net23_5 0.00216702f
C2796 WL_0_17 net25_4 0.00150186f
C2797 WL_0_17 net26_5 0.0021701f
C2798 WL_0_17 net28_4 0.00149626f
C2799 WL_0_17 net29_5 0.00216265f
C2800 WL_0_17 net4_2 0.00150969f
C2801 WL_0_17 net5_9 0.00216921f
C2802 WL_0_17 net68 1.45603e-05f
C2803 WL_0_17 net69 1.3922e-05f
C2804 WL_0_17 net70 1.44981e-05f
C2805 WL_0_17 net71 1.37429e-05f
C2806 WL_0_17 net72 1.39789e-05f
C2807 WL_0_17 net73 1.28825e-05f
C2808 WL_0_17 net74 1.29969e-05f
C2809 WL_0_17 net75 1.45872e-05f
C2810 WL_0_17 net8_4 0.00151583f
C2811 WL_0_17 net9_5 0.0021629f
C2812 WL_0_18 XB_0_0_2 0.000123069f
C2813 WL_0_18 XB_0_1 0.000118467f
C2814 WL_0_18 XB_0_2 0.000123534f
C2815 WL_0_18 XB_0_3 0.00012096f
C2816 WL_0_18 XB_0_4 0.00012151f
C2817 WL_0_18 XB_0_5 0.000127737f
C2818 WL_0_18 XB_0_6 0.000123955f
C2819 WL_0_18 XB_0_7 0.000126228f
C2820 WL_0_18 net12_4 0.00152407f
C2821 WL_0_18 net13_5 0.00215723f
C2822 WL_0_18 net15_4 0.00151201f
C2823 WL_0_18 net16_5 0.00216297f
C2824 WL_0_18 net19_4 0.00152317f
C2825 WL_0_18 net20_5 0.00215611f
C2826 WL_0_18 net22_4 0.00151551f
C2827 WL_0_18 net23_5 0.00216702f
C2828 WL_0_18 net25_4 0.00150186f
C2829 WL_0_18 net26_5 0.0021701f
C2830 WL_0_18 net28_4 0.00149626f
C2831 WL_0_18 net29_5 0.00216265f
C2832 WL_0_18 net4_2 0.00150969f
C2833 WL_0_18 net5_7 0.00216921f
C2834 WL_0_18 net68 1.45603e-05f
C2835 WL_0_18 net69 1.3922e-05f
C2836 WL_0_18 net70 1.44981e-05f
C2837 WL_0_18 net71 1.37429e-05f
C2838 WL_0_18 net72 1.39789e-05f
C2839 WL_0_18 net73 1.28825e-05f
C2840 WL_0_18 net74 1.29969e-05f
C2841 WL_0_18 net75 1.45872e-05f
C2842 WL_0_18 net8_4 0.00151583f
C2843 WL_0_18 net9_5 0.0021629f
C2844 WL_0_19 XB_0_0_2 0.000123069f
C2845 WL_0_19 XB_0_1 0.000118467f
C2846 WL_0_19 XB_0_2 0.000123534f
C2847 WL_0_19 XB_0_3 0.00012096f
C2848 WL_0_19 XB_0_4 0.00012151f
C2849 WL_0_19 XB_0_5 0.000127737f
C2850 WL_0_19 XB_0_6 0.000123955f
C2851 WL_0_19 XB_0_7 0.000126228f
C2852 WL_0_19 net12_4 0.00152407f
C2853 WL_0_19 net13_5 0.00215723f
C2854 WL_0_19 net15_4 0.00151201f
C2855 WL_0_19 net16_5 0.00216297f
C2856 WL_0_19 net19_4 0.00152317f
C2857 WL_0_19 net20_5 0.00215611f
C2858 WL_0_19 net22_4 0.00151551f
C2859 WL_0_19 net23_5 0.00216702f
C2860 WL_0_19 net25_4 0.00150186f
C2861 WL_0_19 net26_5 0.0021701f
C2862 WL_0_19 net28_4 0.00149626f
C2863 WL_0_19 net29_5 0.00216265f
C2864 WL_0_19 net4_2 0.00150969f
C2865 WL_0_19 net5_7 0.00216921f
C2866 WL_0_19 net68 1.45603e-05f
C2867 WL_0_19 net69 1.3922e-05f
C2868 WL_0_19 net70 1.44981e-05f
C2869 WL_0_19 net71 1.37429e-05f
C2870 WL_0_19 net72 1.39789e-05f
C2871 WL_0_19 net73 1.28825e-05f
C2872 WL_0_19 net74 1.29969e-05f
C2873 WL_0_19 net75 1.45872e-05f
C2874 WL_0_19 net8_2 0.00151583f
C2875 WL_0_19 net9_9 0.0021629f
C2876 WL_0_2 XB_0_0_3 0.000161624f
C2877 WL_0_2 XB_0_1 0.000155579f
C2878 WL_0_2 XB_0_2 0.000162234f
C2879 WL_0_2 XB_0_3 0.000158854f
C2880 WL_0_2 XB_0_4 0.000159576f
C2881 WL_0_2 XB_0_5 0.000167754f
C2882 WL_0_2 XB_0_6 0.000162787f
C2883 WL_0_2 XB_0_7 0.000165772f
C2884 WL_0_2 net12_6 0.00200152f
C2885 WL_0_2 net13 0.00283304f
C2886 WL_0_2 net15_6 0.00198568f
C2887 WL_0_2 net16 0.00284057f
C2888 WL_0_2 net19_6 0.00200035f
C2889 WL_0_2 net20 0.00283156f
C2890 WL_0_2 net22_6 0.00199028f
C2891 WL_0_2 net23 0.0028459f
C2892 WL_0_2 net25_6 0.00197236f
C2893 WL_0_2 net26 0.00284993f
C2894 WL_0_2 net28_4 0.001965f
C2895 WL_0_2 net29 0.00284015f
C2896 WL_0_2 net4 0.00198263f
C2897 WL_0_2 net5_8 0.00284877f
C2898 WL_0_2 net68 1.91217e-05f
C2899 WL_0_2 net69 1.82833e-05f
C2900 WL_0_2 net70 1.904e-05f
C2901 WL_0_2 net71 1.80482e-05f
C2902 WL_0_2 net72 1.83581e-05f
C2903 WL_0_2 net73 1.69183e-05f
C2904 WL_0_2 net74 1.70684e-05f
C2905 WL_0_2 net75 1.9157e-05f
C2906 WL_0_2 net8 0.00199071f
C2907 WL_0_2 net9 0.00284049f
C2908 WL_0_20 XB_0_0_2 0.000123069f
C2909 WL_0_20 XB_0_1_2 0.000118467f
C2910 WL_0_20 XB_0_2 0.000123534f
C2911 WL_0_20 XB_0_3 0.00012096f
C2912 WL_0_20 XB_0_4 0.00012151f
C2913 WL_0_20 XB_0_5 0.000127737f
C2914 WL_0_20 XB_0_6 0.000123955f
C2915 WL_0_20 XB_0_7 0.000126228f
C2916 WL_0_20 net12_4 0.00152407f
C2917 WL_0_20 net13_5 0.00215723f
C2918 WL_0_20 net15_4 0.00151201f
C2919 WL_0_20 net16_5 0.00216297f
C2920 WL_0_20 net19_4 0.00152317f
C2921 WL_0_20 net20_5 0.00215611f
C2922 WL_0_20 net22_4 0.00151551f
C2923 WL_0_20 net23_5 0.00216702f
C2924 WL_0_20 net25_4 0.00150186f
C2925 WL_0_20 net26_5 0.0021701f
C2926 WL_0_20 net28_4 0.00149626f
C2927 WL_0_20 net29_5 0.00216265f
C2928 WL_0_20 net4_2 0.00150969f
C2929 WL_0_20 net5_7 0.00216921f
C2930 WL_0_20 net68 1.45603e-05f
C2931 WL_0_20 net69 1.3922e-05f
C2932 WL_0_20 net70 1.44981e-05f
C2933 WL_0_20 net71 1.37429e-05f
C2934 WL_0_20 net72 1.39789e-05f
C2935 WL_0_20 net73 1.28825e-05f
C2936 WL_0_20 net74 1.29969e-05f
C2937 WL_0_20 net75 1.45872e-05f
C2938 WL_0_20 net8_2 0.00151583f
C2939 WL_0_20 net9_7 0.0021629f
C2940 WL_0_21 XB_0_0_2 0.000123069f
C2941 WL_0_21 XB_0_1_2 0.000118467f
C2942 WL_0_21 XB_0_2 0.000123534f
C2943 WL_0_21 XB_0_3 0.00012096f
C2944 WL_0_21 XB_0_4 0.00012151f
C2945 WL_0_21 XB_0_5 0.000127737f
C2946 WL_0_21 XB_0_6 0.000123955f
C2947 WL_0_21 XB_0_7 0.000126228f
C2948 WL_0_21 net12_2 0.00152407f
C2949 WL_0_21 net13_9 0.00215723f
C2950 WL_0_21 net15_4 0.00151201f
C2951 WL_0_21 net16_5 0.00216297f
C2952 WL_0_21 net19_4 0.00152317f
C2953 WL_0_21 net20_5 0.00215611f
C2954 WL_0_21 net22_4 0.00151551f
C2955 WL_0_21 net23_5 0.00216702f
C2956 WL_0_21 net25_4 0.00150186f
C2957 WL_0_21 net26_5 0.0021701f
C2958 WL_0_21 net28_4 0.00149626f
C2959 WL_0_21 net29_5 0.00216265f
C2960 WL_0_21 net4_2 0.00150969f
C2961 WL_0_21 net5_7 0.00216921f
C2962 WL_0_21 net68 1.45603e-05f
C2963 WL_0_21 net69 1.3922e-05f
C2964 WL_0_21 net70 1.44981e-05f
C2965 WL_0_21 net71 1.37429e-05f
C2966 WL_0_21 net72 1.39789e-05f
C2967 WL_0_21 net73 1.28825e-05f
C2968 WL_0_21 net74 1.29969e-05f
C2969 WL_0_21 net75 1.45872e-05f
C2970 WL_0_21 net8_2 0.00151583f
C2971 WL_0_21 net9_7 0.0021629f
C2972 WL_0_22 XB_0_0_2 0.000123069f
C2973 WL_0_22 XB_0_1_2 0.000118467f
C2974 WL_0_22 XB_0_2_2 0.000123534f
C2975 WL_0_22 XB_0_3 0.00012096f
C2976 WL_0_22 XB_0_4 0.00012151f
C2977 WL_0_22 XB_0_5 0.000127737f
C2978 WL_0_22 XB_0_6 0.000123955f
C2979 WL_0_22 XB_0_7 0.000126228f
C2980 WL_0_22 net12_2 0.00152407f
C2981 WL_0_22 net13_7 0.00215723f
C2982 WL_0_22 net15_4 0.00151201f
C2983 WL_0_22 net16_5 0.00216297f
C2984 WL_0_22 net19_4 0.00152317f
C2985 WL_0_22 net20_5 0.00215611f
C2986 WL_0_22 net22_4 0.00151551f
C2987 WL_0_22 net23_5 0.00216702f
C2988 WL_0_22 net25_4 0.00150186f
C2989 WL_0_22 net26_5 0.0021701f
C2990 WL_0_22 net28_4 0.00149626f
C2991 WL_0_22 net29_5 0.00216265f
C2992 WL_0_22 net4_2 0.00150969f
C2993 WL_0_22 net5_7 0.00216921f
C2994 WL_0_22 net68 1.45603e-05f
C2995 WL_0_22 net69 1.3922e-05f
C2996 WL_0_22 net70 1.44981e-05f
C2997 WL_0_22 net71 1.37429e-05f
C2998 WL_0_22 net72 1.39789e-05f
C2999 WL_0_22 net73 1.28825e-05f
C3000 WL_0_22 net74 1.29969e-05f
C3001 WL_0_22 net75 1.45872e-05f
C3002 WL_0_22 net8_2 0.00151583f
C3003 WL_0_22 net9_7 0.0021629f
C3004 WL_0_23 XB_0_0_2 0.000123069f
C3005 WL_0_23 XB_0_1_2 0.000118467f
C3006 WL_0_23 XB_0_2_2 0.000123534f
C3007 WL_0_23 XB_0_3 0.00012096f
C3008 WL_0_23 XB_0_4 0.00012151f
C3009 WL_0_23 XB_0_5 0.000127737f
C3010 WL_0_23 XB_0_6 0.000123955f
C3011 WL_0_23 XB_0_7 0.000126228f
C3012 WL_0_23 net12_2 0.00152407f
C3013 WL_0_23 net13_7 0.00215723f
C3014 WL_0_23 net15_2 0.00151201f
C3015 WL_0_23 net16_9 0.00216297f
C3016 WL_0_23 net19_4 0.00152317f
C3017 WL_0_23 net20_5 0.00215611f
C3018 WL_0_23 net22_4 0.00151551f
C3019 WL_0_23 net23_5 0.00216702f
C3020 WL_0_23 net25_4 0.00150186f
C3021 WL_0_23 net26_5 0.0021701f
C3022 WL_0_23 net28_4 0.00149626f
C3023 WL_0_23 net29_5 0.00216265f
C3024 WL_0_23 net4_2 0.00150969f
C3025 WL_0_23 net5_7 0.00216921f
C3026 WL_0_23 net68 1.45603e-05f
C3027 WL_0_23 net69 1.3922e-05f
C3028 WL_0_23 net70 1.44981e-05f
C3029 WL_0_23 net71 1.37429e-05f
C3030 WL_0_23 net72 1.39789e-05f
C3031 WL_0_23 net73 1.28825e-05f
C3032 WL_0_23 net74 1.29969e-05f
C3033 WL_0_23 net75 1.45872e-05f
C3034 WL_0_23 net8_2 0.00151583f
C3035 WL_0_23 net9_7 0.0021629f
C3036 WL_0_24 XB_0_0_2 0.000123069f
C3037 WL_0_24 XB_0_1_2 0.000118467f
C3038 WL_0_24 XB_0_2_2 0.000123534f
C3039 WL_0_24 XB_0_3_2 0.00012096f
C3040 WL_0_24 XB_0_4 0.00012151f
C3041 WL_0_24 XB_0_5 0.000127737f
C3042 WL_0_24 XB_0_6 0.000123955f
C3043 WL_0_24 XB_0_7 0.000126228f
C3044 WL_0_24 net12_2 0.00152407f
C3045 WL_0_24 net13_7 0.00215723f
C3046 WL_0_24 net15_2 0.00151201f
C3047 WL_0_24 net16_7 0.00216297f
C3048 WL_0_24 net19_4 0.00152317f
C3049 WL_0_24 net20_5 0.00215611f
C3050 WL_0_24 net22_4 0.00151551f
C3051 WL_0_24 net23_5 0.00216702f
C3052 WL_0_24 net25_4 0.00150186f
C3053 WL_0_24 net26_5 0.0021701f
C3054 WL_0_24 net28_4 0.00149626f
C3055 WL_0_24 net29_5 0.00216265f
C3056 WL_0_24 net4_2 0.00150969f
C3057 WL_0_24 net5_7 0.00216921f
C3058 WL_0_24 net68 1.45603e-05f
C3059 WL_0_24 net69 1.3922e-05f
C3060 WL_0_24 net70 1.44981e-05f
C3061 WL_0_24 net71 1.37429e-05f
C3062 WL_0_24 net72 1.39789e-05f
C3063 WL_0_24 net73 1.28825e-05f
C3064 WL_0_24 net74 1.29969e-05f
C3065 WL_0_24 net75 1.45872e-05f
C3066 WL_0_24 net8_2 0.00151583f
C3067 WL_0_24 net9_7 0.0021629f
C3068 WL_0_25 XB_0_0_2 0.000123069f
C3069 WL_0_25 XB_0_1_2 0.000118467f
C3070 WL_0_25 XB_0_2_2 0.000123534f
C3071 WL_0_25 XB_0_3_2 0.00012096f
C3072 WL_0_25 XB_0_4 0.00012151f
C3073 WL_0_25 XB_0_5 0.000127737f
C3074 WL_0_25 XB_0_6 0.000123955f
C3075 WL_0_25 XB_0_7 0.000126228f
C3076 WL_0_25 net12_2 0.00152407f
C3077 WL_0_25 net13_7 0.00215723f
C3078 WL_0_25 net15_2 0.00151201f
C3079 WL_0_25 net16_7 0.00216297f
C3080 WL_0_25 net19_2 0.00152317f
C3081 WL_0_25 net20_9 0.00215611f
C3082 WL_0_25 net22_4 0.00151551f
C3083 WL_0_25 net23_5 0.00216702f
C3084 WL_0_25 net25_4 0.00150186f
C3085 WL_0_25 net26_5 0.0021701f
C3086 WL_0_25 net28_4 0.00149626f
C3087 WL_0_25 net29_5 0.00216265f
C3088 WL_0_25 net4_2 0.00150969f
C3089 WL_0_25 net5_7 0.00216921f
C3090 WL_0_25 net68 1.45603e-05f
C3091 WL_0_25 net69 1.3922e-05f
C3092 WL_0_25 net70 1.44981e-05f
C3093 WL_0_25 net71 1.37429e-05f
C3094 WL_0_25 net72 1.39789e-05f
C3095 WL_0_25 net73 1.28825e-05f
C3096 WL_0_25 net74 1.29969e-05f
C3097 WL_0_25 net75 1.45872e-05f
C3098 WL_0_25 net8_2 0.00151583f
C3099 WL_0_25 net9_7 0.0021629f
C3100 WL_0_26 XB_0_0_2 0.000123069f
C3101 WL_0_26 XB_0_1_2 0.000118467f
C3102 WL_0_26 XB_0_2_2 0.000123534f
C3103 WL_0_26 XB_0_3_2 0.00012096f
C3104 WL_0_26 XB_0_4_2 0.00012151f
C3105 WL_0_26 XB_0_5 0.000127737f
C3106 WL_0_26 XB_0_6 0.000123955f
C3107 WL_0_26 XB_0_7 0.000126228f
C3108 WL_0_26 net12_2 0.00152407f
C3109 WL_0_26 net13_7 0.00215723f
C3110 WL_0_26 net15_2 0.00151201f
C3111 WL_0_26 net16_7 0.00216297f
C3112 WL_0_26 net19_2 0.00152317f
C3113 WL_0_26 net20_7 0.00215611f
C3114 WL_0_26 net22_4 0.00151551f
C3115 WL_0_26 net23_5 0.00216702f
C3116 WL_0_26 net25_4 0.00150186f
C3117 WL_0_26 net26_5 0.0021701f
C3118 WL_0_26 net28_4 0.00149626f
C3119 WL_0_26 net29_5 0.00216265f
C3120 WL_0_26 net4_2 0.00150969f
C3121 WL_0_26 net5_7 0.00216921f
C3122 WL_0_26 net68 1.45603e-05f
C3123 WL_0_26 net69 1.3922e-05f
C3124 WL_0_26 net70 1.44981e-05f
C3125 WL_0_26 net71 1.37429e-05f
C3126 WL_0_26 net72 1.39789e-05f
C3127 WL_0_26 net73 1.28825e-05f
C3128 WL_0_26 net74 1.29969e-05f
C3129 WL_0_26 net75 1.45872e-05f
C3130 WL_0_26 net8_2 0.00151583f
C3131 WL_0_26 net9_7 0.0021629f
C3132 WL_0_27 XB_0_0_2 0.000123069f
C3133 WL_0_27 XB_0_1_2 0.000118467f
C3134 WL_0_27 XB_0_2_2 0.000123534f
C3135 WL_0_27 XB_0_3_2 0.00012096f
C3136 WL_0_27 XB_0_4_2 0.00012151f
C3137 WL_0_27 XB_0_5 0.000127737f
C3138 WL_0_27 XB_0_6 0.000123955f
C3139 WL_0_27 XB_0_7 0.000126228f
C3140 WL_0_27 net12_2 0.00152407f
C3141 WL_0_27 net13_7 0.00215723f
C3142 WL_0_27 net15_2 0.00151201f
C3143 WL_0_27 net16_7 0.00216297f
C3144 WL_0_27 net19_2 0.00152317f
C3145 WL_0_27 net20_7 0.00215611f
C3146 WL_0_27 net22_2 0.00151551f
C3147 WL_0_27 net23_9 0.00216702f
C3148 WL_0_27 net25_4 0.00150186f
C3149 WL_0_27 net26_5 0.0021701f
C3150 WL_0_27 net28_4 0.00149626f
C3151 WL_0_27 net29_5 0.00216265f
C3152 WL_0_27 net4_2 0.00150969f
C3153 WL_0_27 net5_7 0.00216921f
C3154 WL_0_27 net68 1.45603e-05f
C3155 WL_0_27 net69 1.3922e-05f
C3156 WL_0_27 net70 1.44981e-05f
C3157 WL_0_27 net71 1.37429e-05f
C3158 WL_0_27 net72 1.39789e-05f
C3159 WL_0_27 net73 1.28825e-05f
C3160 WL_0_27 net74 1.29969e-05f
C3161 WL_0_27 net75 1.45872e-05f
C3162 WL_0_27 net8_2 0.00151583f
C3163 WL_0_27 net9_7 0.0021629f
C3164 WL_0_28 XB_0_0_2 0.000123069f
C3165 WL_0_28 XB_0_1_2 0.000118467f
C3166 WL_0_28 XB_0_2_2 0.000123534f
C3167 WL_0_28 XB_0_3_2 0.00012096f
C3168 WL_0_28 XB_0_4_2 0.00012151f
C3169 WL_0_28 XB_0_5_2 0.000127737f
C3170 WL_0_28 XB_0_6 0.000123955f
C3171 WL_0_28 XB_0_7 0.000126228f
C3172 WL_0_28 net12_2 0.00152407f
C3173 WL_0_28 net13_7 0.00215723f
C3174 WL_0_28 net15_2 0.00151201f
C3175 WL_0_28 net16_7 0.00216297f
C3176 WL_0_28 net19_2 0.00152317f
C3177 WL_0_28 net20_7 0.00215611f
C3178 WL_0_28 net22_2 0.00151551f
C3179 WL_0_28 net23_7 0.00216702f
C3180 WL_0_28 net25_4 0.00150186f
C3181 WL_0_28 net26_5 0.0021701f
C3182 WL_0_28 net28_4 0.00149626f
C3183 WL_0_28 net29_5 0.00216265f
C3184 WL_0_28 net4_2 0.00150969f
C3185 WL_0_28 net5_7 0.00216921f
C3186 WL_0_28 net68 1.45603e-05f
C3187 WL_0_28 net69 1.3922e-05f
C3188 WL_0_28 net70 1.44981e-05f
C3189 WL_0_28 net71 1.37429e-05f
C3190 WL_0_28 net72 1.39789e-05f
C3191 WL_0_28 net73 1.28825e-05f
C3192 WL_0_28 net74 1.29969e-05f
C3193 WL_0_28 net75 1.45872e-05f
C3194 WL_0_28 net8_2 0.00151583f
C3195 WL_0_28 net9_7 0.0021629f
C3196 WL_0_29 XB_0_0_2 0.000123069f
C3197 WL_0_29 XB_0_1_2 0.000118467f
C3198 WL_0_29 XB_0_2_2 0.000123534f
C3199 WL_0_29 XB_0_3_2 0.00012096f
C3200 WL_0_29 XB_0_4_2 0.00012151f
C3201 WL_0_29 XB_0_5_2 0.000127737f
C3202 WL_0_29 XB_0_6 0.000123955f
C3203 WL_0_29 XB_0_7 0.000126228f
C3204 WL_0_29 net12_2 0.00152407f
C3205 WL_0_29 net13_7 0.00215723f
C3206 WL_0_29 net15_2 0.00151201f
C3207 WL_0_29 net16_7 0.00216297f
C3208 WL_0_29 net19_2 0.00152317f
C3209 WL_0_29 net20_7 0.00215611f
C3210 WL_0_29 net22_2 0.00151551f
C3211 WL_0_29 net23_7 0.00216702f
C3212 WL_0_29 net25_2 0.00150186f
C3213 WL_0_29 net26_9 0.0021701f
C3214 WL_0_29 net28_4 0.00149626f
C3215 WL_0_29 net29_5 0.00216265f
C3216 WL_0_29 net4_2 0.00150969f
C3217 WL_0_29 net5_7 0.00216921f
C3218 WL_0_29 net68 1.45603e-05f
C3219 WL_0_29 net69 1.3922e-05f
C3220 WL_0_29 net70 1.44981e-05f
C3221 WL_0_29 net71 1.37429e-05f
C3222 WL_0_29 net72 1.39789e-05f
C3223 WL_0_29 net73 1.28825e-05f
C3224 WL_0_29 net74 1.29969e-05f
C3225 WL_0_29 net75 1.45872e-05f
C3226 WL_0_29 net8_2 0.00151583f
C3227 WL_0_29 net9_7 0.0021629f
C3228 WL_0_3 XB_0_0_3 0.000161624f
C3229 WL_0_3 XB_0_1_3 0.000155579f
C3230 WL_0_3 XB_0_2 0.000162234f
C3231 WL_0_3 XB_0_3 0.000158854f
C3232 WL_0_3 XB_0_4 0.000159576f
C3233 WL_0_3 XB_0_5 0.000167754f
C3234 WL_0_3 XB_0_6 0.000162787f
C3235 WL_0_3 XB_0_7 0.000165772f
C3236 WL_0_3 net12 0.00200152f
C3237 WL_0_3 net13 0.00283304f
C3238 WL_0_3 net15_6 0.00198568f
C3239 WL_0_3 net16 0.00284057f
C3240 WL_0_3 net19_6 0.00200035f
C3241 WL_0_3 net20 0.00283156f
C3242 WL_0_3 net22_6 0.00199028f
C3243 WL_0_3 net23 0.0028459f
C3244 WL_0_3 net25_6 0.00197236f
C3245 WL_0_3 net26 0.00284993f
C3246 WL_0_3 net28_6 0.001965f
C3247 WL_0_3 net29 0.00284015f
C3248 WL_0_3 net4 0.00198263f
C3249 WL_0_3 net5_8 0.00284877f
C3250 WL_0_3 net68 1.91217e-05f
C3251 WL_0_3 net69 1.82833e-05f
C3252 WL_0_3 net70 1.904e-05f
C3253 WL_0_3 net71 1.80482e-05f
C3254 WL_0_3 net72 1.83581e-05f
C3255 WL_0_3 net73 1.69183e-05f
C3256 WL_0_3 net74 1.70684e-05f
C3257 WL_0_3 net75 1.9157e-05f
C3258 WL_0_3 net8 0.00199071f
C3259 WL_0_3 net9_8 0.00284049f
C3260 WL_0_30 XB_0_0_2 0.000123069f
C3261 WL_0_30 XB_0_1_2 0.000118467f
C3262 WL_0_30 XB_0_2_2 0.000123534f
C3263 WL_0_30 XB_0_3_2 0.00012096f
C3264 WL_0_30 XB_0_4_2 0.00012151f
C3265 WL_0_30 XB_0_5_2 0.000127737f
C3266 WL_0_30 XB_0_6_2 0.000123955f
C3267 WL_0_30 XB_0_7 0.000126228f
C3268 WL_0_30 net12_2 0.00152407f
C3269 WL_0_30 net13_7 0.00215723f
C3270 WL_0_30 net15_2 0.00151201f
C3271 WL_0_30 net16_7 0.00216297f
C3272 WL_0_30 net19_2 0.00152317f
C3273 WL_0_30 net20_7 0.00215611f
C3274 WL_0_30 net22_2 0.00151551f
C3275 WL_0_30 net23_7 0.00216702f
C3276 WL_0_30 net25_2 0.00150186f
C3277 WL_0_30 net26_7 0.0021701f
C3278 WL_0_30 net28_4 0.00149626f
C3279 WL_0_30 net29_5 0.00216265f
C3280 WL_0_30 net4_2 0.00150969f
C3281 WL_0_30 net5_7 0.00216921f
C3282 WL_0_30 net68 1.45603e-05f
C3283 WL_0_30 net69 1.3922e-05f
C3284 WL_0_30 net70 1.44981e-05f
C3285 WL_0_30 net71 1.37429e-05f
C3286 WL_0_30 net72 1.39789e-05f
C3287 WL_0_30 net73 1.28825e-05f
C3288 WL_0_30 net74 1.29969e-05f
C3289 WL_0_30 net75 1.45872e-05f
C3290 WL_0_30 net8_2 0.00151583f
C3291 WL_0_30 net9_7 0.0021629f
C3292 WL_0_31 XB_0_0_2 0.000123069f
C3293 WL_0_31 XB_0_1_2 0.000118467f
C3294 WL_0_31 XB_0_2_2 0.000123534f
C3295 WL_0_31 XB_0_3_2 0.00012096f
C3296 WL_0_31 XB_0_4_2 0.00012151f
C3297 WL_0_31 XB_0_5_2 0.000127737f
C3298 WL_0_31 XB_0_6_2 0.000123955f
C3299 WL_0_31 XB_0_7 0.000126228f
C3300 WL_0_31 net12_2 0.00152407f
C3301 WL_0_31 net13_7 0.00215723f
C3302 WL_0_31 net15_2 0.00151201f
C3303 WL_0_31 net16_7 0.00216297f
C3304 WL_0_31 net19_2 0.00152317f
C3305 WL_0_31 net20_7 0.00215611f
C3306 WL_0_31 net22_2 0.00151551f
C3307 WL_0_31 net23_7 0.00216702f
C3308 WL_0_31 net25_2 0.00150186f
C3309 WL_0_31 net26_7 0.0021701f
C3310 WL_0_31 net28_2 0.00149626f
C3311 WL_0_31 net29_9 0.00216265f
C3312 WL_0_31 net4_2 0.00150969f
C3313 WL_0_31 net5_7 0.00216921f
C3314 WL_0_31 net68 1.45603e-05f
C3315 WL_0_31 net69 1.3922e-05f
C3316 WL_0_31 net70 1.44981e-05f
C3317 WL_0_31 net71 1.37429e-05f
C3318 WL_0_31 net72 1.39789e-05f
C3319 WL_0_31 net73 1.28825e-05f
C3320 WL_0_31 net74 1.29969e-05f
C3321 WL_0_31 net75 1.45872e-05f
C3322 WL_0_31 net8_2 0.00151583f
C3323 WL_0_31 net9_7 0.0021629f
C3324 WL_0_4 XB_0_0_3 0.000161624f
C3325 WL_0_4 XB_0_1_3 0.000155579f
C3326 WL_0_4 XB_0_2_3 0.000162234f
C3327 WL_0_4 XB_0_3 0.000158854f
C3328 WL_0_4 XB_0_4 0.000159576f
C3329 WL_0_4 XB_0_5 0.000167754f
C3330 WL_0_4 XB_0_6 0.000162787f
C3331 WL_0_4 XB_0_7 0.000165772f
C3332 WL_0_4 net12 0.00200152f
C3333 WL_0_4 net13_8 0.00283304f
C3334 WL_0_4 net15 0.00198568f
C3335 WL_0_4 net16 0.00284057f
C3336 WL_0_4 net19_6 0.00200035f
C3337 WL_0_4 net20 0.00283156f
C3338 WL_0_4 net22_6 0.00199028f
C3339 WL_0_4 net23 0.0028459f
C3340 WL_0_4 net25_6 0.00197236f
C3341 WL_0_4 net26 0.00284993f
C3342 WL_0_4 net28_6 0.001965f
C3343 WL_0_4 net29 0.00284015f
C3344 WL_0_4 net4 0.00198263f
C3345 WL_0_4 net5_8 0.00284877f
C3346 WL_0_4 net68 1.91217e-05f
C3347 WL_0_4 net69 1.82833e-05f
C3348 WL_0_4 net70 1.904e-05f
C3349 WL_0_4 net71 1.80482e-05f
C3350 WL_0_4 net72 1.83581e-05f
C3351 WL_0_4 net73 1.69183e-05f
C3352 WL_0_4 net74 1.70684e-05f
C3353 WL_0_4 net75 1.9157e-05f
C3354 WL_0_4 net8 0.00199071f
C3355 WL_0_4 net9_8 0.00284049f
C3356 WL_0_5 XB_0_0_3 0.000161624f
C3357 WL_0_5 XB_0_1_3 0.000155579f
C3358 WL_0_5 XB_0_2_3 0.000162234f
C3359 WL_0_5 XB_0_3_3 0.000158854f
C3360 WL_0_5 XB_0_4 0.000159576f
C3361 WL_0_5 XB_0_5 0.000167754f
C3362 WL_0_5 XB_0_6 0.000162787f
C3363 WL_0_5 XB_0_7 0.000165772f
C3364 WL_0_5 net12 0.00200152f
C3365 WL_0_5 net13_8 0.00283304f
C3366 WL_0_5 net15 0.00198568f
C3367 WL_0_5 net16_8 0.00284057f
C3368 WL_0_5 net19 0.00200035f
C3369 WL_0_5 net20 0.00283156f
C3370 WL_0_5 net22_6 0.00199028f
C3371 WL_0_5 net23 0.0028459f
C3372 WL_0_5 net25_6 0.00197236f
C3373 WL_0_5 net26 0.00284993f
C3374 WL_0_5 net28_6 0.001965f
C3375 WL_0_5 net29 0.00284015f
C3376 WL_0_5 net4 0.00198263f
C3377 WL_0_5 net5_8 0.00284877f
C3378 WL_0_5 net68 1.91217e-05f
C3379 WL_0_5 net69 1.82833e-05f
C3380 WL_0_5 net70 1.904e-05f
C3381 WL_0_5 net71 1.80482e-05f
C3382 WL_0_5 net72 1.83581e-05f
C3383 WL_0_5 net73 1.69183e-05f
C3384 WL_0_5 net74 1.70684e-05f
C3385 WL_0_5 net75 1.9157e-05f
C3386 WL_0_5 net8 0.00199071f
C3387 WL_0_5 net9_8 0.00284049f
C3388 WL_0_6 XB_0_0_3 0.000161624f
C3389 WL_0_6 XB_0_1_3 0.000155579f
C3390 WL_0_6 XB_0_2_3 0.000162234f
C3391 WL_0_6 XB_0_3_3 0.000158854f
C3392 WL_0_6 XB_0_4_3 0.000159576f
C3393 WL_0_6 XB_0_5 0.000167754f
C3394 WL_0_6 XB_0_6 0.000162787f
C3395 WL_0_6 XB_0_7 0.000165772f
C3396 WL_0_6 net12 0.00200152f
C3397 WL_0_6 net13_8 0.00283304f
C3398 WL_0_6 net15 0.00198568f
C3399 WL_0_6 net16_8 0.00284057f
C3400 WL_0_6 net19 0.00200035f
C3401 WL_0_6 net20_8 0.00283156f
C3402 WL_0_6 net22 0.00199028f
C3403 WL_0_6 net23 0.0028459f
C3404 WL_0_6 net25_6 0.00197236f
C3405 WL_0_6 net26 0.00284993f
C3406 WL_0_6 net28_6 0.001965f
C3407 WL_0_6 net29 0.00284015f
C3408 WL_0_6 net4 0.00198263f
C3409 WL_0_6 net5_8 0.00284877f
C3410 WL_0_6 net68 1.91217e-05f
C3411 WL_0_6 net69 1.82833e-05f
C3412 WL_0_6 net70 1.904e-05f
C3413 WL_0_6 net71 1.80482e-05f
C3414 WL_0_6 net72 1.83581e-05f
C3415 WL_0_6 net73 1.69183e-05f
C3416 WL_0_6 net74 1.70684e-05f
C3417 WL_0_6 net75 1.9157e-05f
C3418 WL_0_6 net8 0.00199071f
C3419 WL_0_6 net9_8 0.00284049f
C3420 WL_0_7 XB_0_0_3 0.000161624f
C3421 WL_0_7 XB_0_1_3 0.000155579f
C3422 WL_0_7 XB_0_2_3 0.000162234f
C3423 WL_0_7 XB_0_3_3 0.000158854f
C3424 WL_0_7 XB_0_4_3 0.000159576f
C3425 WL_0_7 XB_0_5_3 0.000167754f
C3426 WL_0_7 XB_0_6 0.000162787f
C3427 WL_0_7 XB_0_7 0.000165772f
C3428 WL_0_7 net12 0.00200152f
C3429 WL_0_7 net13_8 0.00283304f
C3430 WL_0_7 net15 0.00198568f
C3431 WL_0_7 net16_8 0.00284057f
C3432 WL_0_7 net19 0.00200035f
C3433 WL_0_7 net20_8 0.00283156f
C3434 WL_0_7 net22 0.00199028f
C3435 WL_0_7 net23_8 0.0028459f
C3436 WL_0_7 net25 0.00197236f
C3437 WL_0_7 net26 0.00284993f
C3438 WL_0_7 net28_6 0.001965f
C3439 WL_0_7 net29 0.00284015f
C3440 WL_0_7 net4 0.00198263f
C3441 WL_0_7 net5_8 0.00284877f
C3442 WL_0_7 net68 1.91217e-05f
C3443 WL_0_7 net69 1.82833e-05f
C3444 WL_0_7 net70 1.904e-05f
C3445 WL_0_7 net71 1.80482e-05f
C3446 WL_0_7 net72 1.83581e-05f
C3447 WL_0_7 net73 1.69183e-05f
C3448 WL_0_7 net74 1.70684e-05f
C3449 WL_0_7 net75 1.9157e-05f
C3450 WL_0_7 net8 0.00199071f
C3451 WL_0_7 net9_8 0.00284049f
C3452 WL_0_8 XB_0_0_3 0.000161624f
C3453 WL_0_8 XB_0_1_3 0.000155579f
C3454 WL_0_8 XB_0_2_3 0.000162234f
C3455 WL_0_8 XB_0_3_3 0.000158854f
C3456 WL_0_8 XB_0_4_3 0.000159576f
C3457 WL_0_8 XB_0_5_3 0.000167754f
C3458 WL_0_8 XB_0_6_3 0.000162787f
C3459 WL_0_8 XB_0_7 0.000165772f
C3460 WL_0_8 net12 0.00200152f
C3461 WL_0_8 net13_8 0.00283304f
C3462 WL_0_8 net15 0.00198568f
C3463 WL_0_8 net16_8 0.00284057f
C3464 WL_0_8 net19 0.00200035f
C3465 WL_0_8 net20_8 0.00283156f
C3466 WL_0_8 net22 0.00199028f
C3467 WL_0_8 net23_8 0.0028459f
C3468 WL_0_8 net25 0.00197236f
C3469 WL_0_8 net26_8 0.00284993f
C3470 WL_0_8 net28 0.001965f
C3471 WL_0_8 net29 0.00284015f
C3472 WL_0_8 net4 0.00198263f
C3473 WL_0_8 net5_8 0.00284877f
C3474 WL_0_8 net68 1.91217e-05f
C3475 WL_0_8 net69 1.82833e-05f
C3476 WL_0_8 net70 1.904e-05f
C3477 WL_0_8 net71 1.80482e-05f
C3478 WL_0_8 net72 1.83581e-05f
C3479 WL_0_8 net73 1.69183e-05f
C3480 WL_0_8 net74 1.70684e-05f
C3481 WL_0_8 net75 1.9157e-05f
C3482 WL_0_8 net8 0.00199071f
C3483 WL_0_8 net9_8 0.00284049f
C3484 WL_0_9 XB_0_0 0.000170351f
C3485 WL_0_9 XB_0_1 0.000163981f
C3486 WL_0_9 XB_0_2 0.000170995f
C3487 WL_0_9 XB_0_3 0.000167432f
C3488 WL_0_9 XB_0_4 0.000168193f
C3489 WL_0_9 XB_0_5 0.000176813f
C3490 WL_0_9 XB_0_6 0.000171577f
C3491 WL_0_9 XB_0_7 0.000174724f
C3492 WL_0_9 net12_6 0.0021096f
C3493 WL_0_9 net13 0.00298603f
C3494 WL_0_9 net15_6 0.00209291f
C3495 WL_0_9 net16 0.00299397f
C3496 WL_0_9 net19_6 0.00210837f
C3497 WL_0_9 net20 0.00298447f
C3498 WL_0_9 net22_6 0.00209776f
C3499 WL_0_9 net23 0.00299958f
C3500 WL_0_9 net25_4 0.00207887f
C3501 WL_0_9 net26 0.00300383f
C3502 WL_0_9 net28_4 0.00207111f
C3503 WL_0_9 net29 0.00299352f
C3504 WL_0_9 net4 0.0020897f
C3505 WL_0_9 net5 0.0030026f
C3506 WL_0_9 net68 2.01543e-05f
C3507 WL_0_9 net69 1.92707e-05f
C3508 WL_0_9 net70 2.00682e-05f
C3509 WL_0_9 net71 1.90229e-05f
C3510 WL_0_9 net72 1.93495e-05f
C3511 WL_0_9 net73 1.78319e-05f
C3512 WL_0_9 net74 1.79902e-05f
C3513 WL_0_9 net75 2.01915e-05f
C3514 WL_0_9 net8_6 0.00209821f
C3515 WL_0_9 net9 0.00299388f
C3516 XB_0_0 net5 0.0021372f
C3517 XB_0_0 net5_2 0.00185415f
C3518 XB_0_0 net5_3 0.00201269f
C3519 XB_0_0 net5_4 0.00202747f
C3520 XB_0_0 net5_5 0.000809736f
C3521 XB_0_0 net5_9 0.00194686f
C3522 XB_0_0 net68 0.00327183f
C3523 XB_0_0_1 net15_7 1.35048e-05f
C3524 XB_0_0_1 net68 0.0136775f
C3525 XB_0_0_1 net8 1.44337e-05f
C3526 XB_0_0_1 net8_7 4.86668e-05f
C3527 XB_0_0_1 net9 0.000519303f
C3528 XB_0_0_1 net9_2 0.000450527f
C3529 XB_0_0_1 net9_3 0.00048905f
C3530 XB_0_0_1 net9_4 0.000492642f
C3531 XB_0_0_2 net5_7 0.000404868f
C3532 XB_0_0_2 net68 0.00193316f
C3533 XB_0_0_2 net8_2 1.88012e-05f
C3534 XB_0_0_2 net8_4 3.20078e-05f
C3535 XB_0_0_2 net9_5 0.000196752f
C3536 XB_0_0_2 net9_7 9.8376e-05f
C3537 XB_0_0_2 net9_9 0.000473053f
C3538 XB_0_0_3 net5_11 0.0012529f
C3539 XB_0_0_3 net5_6 0.000809736f
C3540 XB_0_0_3 net5_8 0.000809736f
C3541 XB_0_0_3 net68 0.00386632f
C3542 XB_0_0_3 net8_3 1.88012e-05f
C3543 XB_0_0_3 net8_6 1.36173e-05f
C3544 XB_0_0_3 net9_11 0.000304432f
C3545 XB_0_0_3 net9_6 0.000196752f
C3546 XB_0_0_3 net9_8 0.000196752f
C3547 XB_0_1 net69 0.00327651f
C3548 XB_0_1 net9 0.00211736f
C3549 XB_0_1 net9_2 0.00183694f
C3550 XB_0_1 net9_3 0.00199401f
C3551 XB_0_1 net9_4 0.00200865f
C3552 XB_0_1 net9_5 0.000802217f
C3553 XB_0_1 net9_9 0.00192878f
C3554 XB_0_1_1 net12_7 2.46662e-05f
C3555 XB_0_1_1 net13 0.000496859f
C3556 XB_0_1_1 net13_2 0.000431055f
C3557 XB_0_1_1 net13_3 0.000467914f
C3558 XB_0_1_1 net13_4 0.00047135f
C3559 XB_0_1_1 net19_7 1.52306e-05f
C3560 XB_0_1_1 net69 0.0136971f
C3561 XB_0_1_2 net12_4 1.62228e-05f
C3562 XB_0_1_2 net13_5 0.000188248f
C3563 XB_0_1_2 net13_7 9.41242e-05f
C3564 XB_0_1_2 net13_9 0.000452608f
C3565 XB_0_1_2 net19_4 1.0017e-05f
C3566 XB_0_1_2 net69 0.00193593f
C3567 XB_0_1_2 net9_7 0.000401109f
C3568 XB_0_1_3 net13_11 0.000291275f
C3569 XB_0_1_3 net13_6 0.000188248f
C3570 XB_0_1_3 net13_8 0.000188248f
C3571 XB_0_1_3 net69 0.00387185f
C3572 XB_0_1_3 net9_11 0.00124126f
C3573 XB_0_1_3 net9_6 0.000802217f
C3574 XB_0_1_3 net9_8 0.000802217f
C3575 XB_0_2 net13 0.00217475f
C3576 XB_0_2 net13_2 0.00188673f
C3577 XB_0_2 net13_3 0.00204806f
C3578 XB_0_2 net13_4 0.0020631f
C3579 XB_0_2 net13_5 0.000823964f
C3580 XB_0_2 net13_9 0.00198107f
C3581 XB_0_2 net4_7 1.29497e-05f
C3582 XB_0_2 net70 0.00324071f
C3583 XB_0_2 net9 1.13626e-05f
C3584 XB_0_2 net9_3 1.07007e-05f
C3585 XB_0_2 net9_4 1.07793e-05f
C3586 XB_0_2 net9_9 1.03507e-05f
C3587 XB_0_2_1 XB_0_3 1.87162e-05f
C3588 XB_0_2_1 net16 0.000502963f
C3589 XB_0_2_1 net16_2 0.000436351f
C3590 XB_0_2_1 net16_3 0.000473662f
C3591 XB_0_2_1 net16_4 0.00047714f
C3592 XB_0_2_1 net22_7 1.23394e-05f
C3593 XB_0_2_1 net70 0.0135475f
C3594 XB_0_2_2 net13_7 0.000411982f
C3595 XB_0_2_2 net16_5 0.000190561f
C3596 XB_0_2_2 net16_7 9.52805e-05f
C3597 XB_0_2_2 net16_9 0.000458168f
C3598 XB_0_2_2 net70 0.00191478f
C3599 XB_0_2_3 net13_11 0.00127491f
C3600 XB_0_2_3 net13_6 0.000823964f
C3601 XB_0_2_3 net13_8 0.000823964f
C3602 XB_0_2_3 net16_11 0.000294853f
C3603 XB_0_2_3 net16_6 0.000190561f
C3604 XB_0_2_3 net16_8 0.000190561f
C3605 XB_0_2_3 net70 0.00382955f
C3606 XB_0_3 net13 1.37814e-05f
C3607 XB_0_3 net13_2 1.19562e-05f
C3608 XB_0_3 net13_3 1.29786e-05f
C3609 XB_0_3 net13_4 1.30739e-05f
C3610 XB_0_3 net13_9 1.2554e-05f
C3611 XB_0_3 net16 0.00217683f
C3612 XB_0_3 net16_2 0.00188853f
C3613 XB_0_3 net16_3 0.00205001f
C3614 XB_0_3 net16_4 0.00206507f
C3615 XB_0_3 net16_5 0.00082475f
C3616 XB_0_3 net16_9 0.00198296f
C3617 XB_0_3 net71 0.0032666f
C3618 XB_0_3_1 net19_7 1.67884e-05f
C3619 XB_0_3_1 net20 0.000493742f
C3620 XB_0_3_1 net20_2 0.000428351f
C3621 XB_0_3_1 net20_3 0.000464978f
C3622 XB_0_3_1 net20_4 0.000468393f
C3623 XB_0_3_1 net25_7 1.30002e-05f
C3624 XB_0_3_1 net71 0.0136557f
C3625 XB_0_3_1 net72 1.56185e-05f
C3626 XB_0_3_2 net16_7 0.000412375f
C3627 XB_0_3_2 net19_4 1.10416e-05f
C3628 XB_0_3_2 net20_5 0.000187067f
C3629 XB_0_3_2 net20_7 9.35337e-05f
C3630 XB_0_3_2 net20_9 0.000449769f
C3631 XB_0_3_2 net71 0.00193007f
C3632 XB_0_3_3 net16_11 0.00127613f
C3633 XB_0_3_3 net16_6 0.00082475f
C3634 XB_0_3_3 net16_8 0.00082475f
C3635 XB_0_3_3 net20_11 0.000289447f
C3636 XB_0_3_3 net20_6 0.000187067f
C3637 XB_0_3_3 net20_8 0.000187067f
C3638 XB_0_3_3 net71 0.00386014f
C3639 XB_0_4 net12_7 1.08372e-05f
C3640 XB_0_4 net20 0.00219588f
C3641 XB_0_4 net20_2 0.00190506f
C3642 XB_0_4 net20_3 0.00206795f
C3643 XB_0_4 net20_4 0.00208314f
C3644 XB_0_4 net20_5 0.000831966f
C3645 XB_0_4 net20_9 0.00200031f
C3646 XB_0_4 net72 0.00326587f
C3647 XB_0_4_1 net23 0.000496854f
C3648 XB_0_4_1 net23_2 0.000431051f
C3649 XB_0_4_1 net23_3 0.000467909f
C3650 XB_0_4_1 net23_4 0.000471345f
C3651 XB_0_4_1 net28_7 1.38038e-05f
C3652 XB_0_4_1 net72 0.0136526f
C3653 XB_0_4_2 net20_7 0.000415983f
C3654 XB_0_4_2 net23_5 0.000188247f
C3655 XB_0_4_2 net23_7 9.41233e-05f
C3656 XB_0_4_2 net23_9 0.000452604f
C3657 XB_0_4_2 net72 0.00192964f
C3658 XB_0_4_3 net20_11 0.00128729f
C3659 XB_0_4_3 net20_6 0.000831966f
C3660 XB_0_4_3 net20_8 0.000831966f
C3661 XB_0_4_3 net23_11 0.000291272f
C3662 XB_0_4_3 net23_6 0.000188247f
C3663 XB_0_4_3 net23_8 0.000188247f
C3664 XB_0_4_3 net72 0.00385928f
C3665 XB_0_5 net20 1.22851e-05f
C3666 XB_0_5 net20_2 1.06581e-05f
C3667 XB_0_5 net20_3 1.15695e-05f
C3668 XB_0_5 net20_4 1.16544e-05f
C3669 XB_0_5 net20_9 1.1191e-05f
C3670 XB_0_5 net23 0.00217478f
C3671 XB_0_5 net23_2 0.00188675f
C3672 XB_0_5 net23_3 0.00204808f
C3673 XB_0_5 net23_4 0.00206312f
C3674 XB_0_5 net23_5 0.000823973f
C3675 XB_0_5 net23_9 0.00198109f
C3676 XB_0_5 net73 0.00323343f
C3677 XB_0_5_1 net26 0.000523939f
C3678 XB_0_5_1 net26_2 0.000454549f
C3679 XB_0_5_1 net26_3 0.000493416f
C3680 XB_0_5_1 net26_4 0.00049704f
C3681 XB_0_5_1 net73 0.013517f
C3682 XB_0_5_2 net23_7 0.000411986f
C3683 XB_0_5_2 net26_5 0.000198508f
C3684 XB_0_5_2 net26_7 9.92542e-05f
C3685 XB_0_5_2 net26_9 0.000477277f
C3686 XB_0_5_2 net73 0.00191047f
C3687 XB_0_5_3 net23_11 0.00127492f
C3688 XB_0_5_3 net23_6 0.000823973f
C3689 XB_0_5_3 net23_8 0.000823973f
C3690 XB_0_5_3 net26_11 0.00030715f
C3691 XB_0_5_3 net26_6 0.000198508f
C3692 XB_0_5_3 net26_8 0.000198508f
C3693 XB_0_5_3 net73 0.00382094f
C3694 XB_0_6 net23 1.07239e-05f
C3695 XB_0_6 net23_3 1.00991e-05f
C3696 XB_0_6 net23_4 1.01733e-05f
C3697 XB_0_6 net26 0.00214665f
C3698 XB_0_6 net26_2 0.00186235f
C3699 XB_0_6 net26_3 0.0020216f
C3700 XB_0_6 net26_4 0.00203644f
C3701 XB_0_6 net26_5 0.000813316f
C3702 XB_0_6 net26_9 0.00195547f
C3703 XB_0_6 net74 0.00328231f
C3704 XB_0_6_1 net28 1.21603e-05f
C3705 XB_0_6_1 net28_7 4.10015e-05f
C3706 XB_0_6_1 net29 0.000516343f
C3707 XB_0_6_1 net29_2 0.000447959f
C3708 XB_0_6_1 net29_3 0.000486263f
C3709 XB_0_6_1 net29_4 0.000489834f
C3710 XB_0_6_1 net74 0.0137213f
C3711 XB_0_6_2 net26_7 0.000406658f
C3712 XB_0_6_2 net28_2 1.58399e-05f
C3713 XB_0_6_2 net28_4 2.69664e-05f
C3714 XB_0_6_2 net29_5 0.00019563f
C3715 XB_0_6_2 net29_7 9.78152e-05f
C3716 XB_0_6_2 net29_9 0.000470357f
C3717 XB_0_6_2 net74 0.00193935f
C3718 XB_0_6_3 net26_11 0.00125844f
C3719 XB_0_6_3 net26_6 0.000813316f
C3720 XB_0_6_3 net26_8 0.000813316f
C3721 XB_0_6_3 net28_3 1.58399e-05f
C3722 XB_0_6_3 net28_6 1.14725e-05f
C3723 XB_0_6_3 net29_11 0.000302697f
C3724 XB_0_6_3 net29_6 0.00019563f
C3725 XB_0_6_3 net29_8 0.00019563f
C3726 XB_0_6_3 net74 0.0038787f
C3727 XB_0_7 net29 0.00215219f
C3728 XB_0_7 net29_2 0.00186716f
C3729 XB_0_7 net29_3 0.00202681f
C3730 XB_0_7 net29_4 0.00204169f
C3731 XB_0_7 net29_5 0.000815415f
C3732 XB_0_7 net29_9 0.00196051f
C3733 XB_0_7 net75 0.00324686f
C3734 XB_0_7_1 net75 0.0135731f
C3735 XB_0_7_2 net29_7 0.000407707f
C3736 XB_0_7_2 net75 0.0019184f
C3737 XB_0_7_3 net29_11 0.00126168f
C3738 XB_0_7_3 net29_6 0.000815415f
C3739 XB_0_7_3 net29_8 0.000815415f
C3740 XB_0_7_3 net75 0.00383681f
C3741 net12 net13_2 0.0125311f
C3742 net12 net13_3 0.0136026f
C3743 net12 net13_4 0.0137025f
C3744 net12_2 net13_7 0.00273627f
C3745 net12_2 net13_9 0.0131577f
C3746 net12_3 net13_11 0.00846759f
C3747 net12_3 net13_8 0.00547253f
C3748 net12_4 net13_5 0.00547253f
C3749 net12_6 net13_6 0.00547253f
C3750 net12_7 net13 0.0144441f
C3751 net13 net70 0.00345561f
C3752 net13_11 net70 0.00202579f
C3753 net13_2 net70 0.00299795f
C3754 net13_3 net70 0.0032543f
C3755 net13_4 net70 0.00327819f
C3756 net13_5 net70 0.00130925f
C3757 net13_6 net70 0.00130925f
C3758 net13_7 net70 0.000654625f
C3759 net13_8 net70 0.00130925f
C3760 net13_9 net70 0.00314785f
C3761 net15 net16_2 0.0125503f
C3762 net15 net16_3 0.0136235f
C3763 net15 net16_4 0.0137235f
C3764 net15_2 net16_7 0.00274046f
C3765 net15_2 net16_9 0.0131779f
C3766 net15_3 net16_11 0.00848058f
C3767 net15_3 net16_8 0.00548092f
C3768 net15_4 net16_5 0.00548092f
C3769 net15_6 net16_6 0.00548092f
C3770 net15_7 net16 0.0144662f
C3771 net16 net20 1.07654e-05f
C3772 net16 net5 1.06309e-05f
C3773 net16 net5_3 1.00116e-05f
C3774 net16 net5_4 1.00851e-05f
C3775 net16 net71 0.00346526f
C3776 net16_11 net71 0.00203144f
C3777 net16_2 net71 0.00300632f
C3778 net16_3 net20 1.01382e-05f
C3779 net16_3 net71 0.00326338f
C3780 net16_4 net20 1.02127e-05f
C3781 net16_4 net71 0.00328735f
C3782 net16_5 net71 0.0013129f
C3783 net16_6 net71 0.0013129f
C3784 net16_7 net71 0.000656452f
C3785 net16_8 net71 0.0013129f
C3786 net16_9 net71 0.00315664f
C3787 net19 net20_2 0.0124915f
C3788 net19 net20_3 0.0135596f
C3789 net19 net20_4 0.0136591f
C3790 net19_2 net20_7 0.0027276f
C3791 net19_2 net20_9 0.013116f
C3792 net19_3 net20_11 0.00844078f
C3793 net19_3 net20_8 0.00545521f
C3794 net19_4 net20_5 0.00545521f
C3795 net19_6 net20_6 0.00545521f
C3796 net19_7 net20 0.0143984f
C3797 net20 net72 0.00347048f
C3798 net20 net9 1.1012e-05f
C3799 net20 net9_3 1.03705e-05f
C3800 net20 net9_4 1.04466e-05f
C3801 net20_11 net72 0.00203451f
C3802 net20_2 net72 0.00301085f
C3803 net20_3 net72 0.0032683f
C3804 net20_4 net72 0.0032923f
C3805 net20_5 net72 0.00131489f
C3806 net20_5 net9_9 1.00312e-05f
C3807 net20_6 net72 0.00131489f
C3808 net20_7 net72 0.000657443f
C3809 net20_8 net72 0.00131489f
C3810 net20_9 net72 0.0031614f
C3811 net22 net23_2 0.0124407f
C3812 net22 net23_3 0.0135044f
C3813 net22 net23_4 0.0136036f
C3814 net22_2 net23_7 0.00271651f
C3815 net22_2 net23_9 0.0130627f
C3816 net22_3 net23_11 0.00840646f
C3817 net22_3 net23_8 0.00543302f
C3818 net22_4 net23_5 0.00543302f
C3819 net22_6 net23_6 0.00543302f
C3820 net22_7 net23 0.0143398f
C3821 net23 net73 0.00344717f
C3822 net23_11 net73 0.00202084f
C3823 net23_2 net73 0.00299063f
C3824 net23_3 net73 0.00324635f
C3825 net23_4 net73 0.00327018f
C3826 net23_5 net73 0.00130605f
C3827 net23_6 net73 0.00130605f
C3828 net23_7 net73 0.000653026f
C3829 net23_8 net73 0.00130605f
C3830 net23_9 net73 0.00314016f
C3831 net25 net26_2 0.0124912f
C3832 net25 net26_3 0.0135592f
C3833 net25 net26_4 0.0136588f
C3834 net25_2 net26_7 0.00272754f
C3835 net25_2 net26_9 0.0131157f
C3836 net25_3 net26_11 0.00844058f
C3837 net25_3 net26_8 0.00545507f
C3838 net25_4 net26_5 0.00545507f
C3839 net25_6 net26_6 0.00545507f
C3840 net25_7 net26 0.014398f
C3841 net26 net29 1.50618e-05f
C3842 net26 net74 0.00343822f
C3843 net26_11 net74 0.0020156f
C3844 net26_2 net29 1.3067e-05f
C3845 net26_2 net74 0.00298287f
C3846 net26_3 net29 1.41844e-05f
C3847 net26_3 net74 0.00323793f
C3848 net26_4 net29 1.42885e-05f
C3849 net26_4 net74 0.0032617f
C3850 net26_5 net74 0.00130266f
C3851 net26_6 net74 0.00130266f
C3852 net26_7 net74 0.000651332f
C3853 net26_8 net74 0.00130266f
C3854 net26_9 net29_5 1.37204e-05f
C3855 net26_9 net74 0.00313201f
C3856 net28 net29_2 0.0125396f
C3857 net28 net29_3 0.0136118f
C3858 net28 net29_4 0.0137118f
C3859 net28_2 net29_7 0.00273812f
C3860 net28_2 net29_9 0.0131666f
C3861 net28_3 net29_11 0.00847332f
C3862 net28_3 net29_8 0.00547624f
C3863 net28_4 net29_5 0.00547624f
C3864 net28_6 net29_6 0.00547624f
C3865 net28_7 net29 0.0144539f
C3866 net28_7 net74 1.22921e-05f
C3867 net29 net75 0.00345685f
C3868 net29_11 net75 0.00202651f
C3869 net29_2 net75 0.00299902f
C3870 net29_3 net75 0.00325546f
C3871 net29_4 net75 0.00327937f
C3872 net29_5 net75 0.00130972f
C3873 net29_6 net75 0.00130972f
C3874 net29_7 net75 0.000654859f
C3875 net29_8 net75 0.00130972f
C3876 net29_9 net75 0.00314897f
C3877 net4 net5_2 0.0125495f
C3878 net4 net5_3 0.0136225f
C3879 net4 net5_4 0.0137226f
C3880 net4_2 net5_7 0.00274027f
C3881 net4_2 net5_9 0.0131769f
C3882 net4_3 net5_11 0.00847997f
C3883 net4_3 net5_8 0.00548053f
C3884 net4_4 net5_5 0.00548053f
C3885 net4_6 net5_6 0.00548053f
C3886 net4_7 net5 0.0144652f
C3887 net5 net68 0.00346323f
C3888 net5 net9 1.14534e-05f
C3889 net5_11 net68 0.00203026f
C3890 net5_2 net68 0.00300456f
C3891 net5_3 net68 0.00326147f
C3892 net5_3 net9 1.07862e-05f
C3893 net5_4 net68 0.00328542f
C3894 net5_4 net9 1.08654e-05f
C3895 net5_5 net68 0.00131214f
C3896 net5_6 net68 0.00131214f
C3897 net5_7 net68 0.000656068f
C3898 net5_8 net68 0.00131214f
C3899 net5_9 net68 0.00315479f
C3900 net5_9 net9_5 1.04334e-05f
C3901 net69 net9 0.0034482f
C3902 net69 net9_11 0.00202145f
C3903 net69 net9_2 0.00299152f
C3904 net69 net9_3 0.00324732f
C3905 net69 net9_4 0.00327116f
C3906 net69 net9_5 0.00130644f
C3907 net69 net9_6 0.00130644f
C3908 net69 net9_7 0.000653221f
C3909 net69 net9_8 0.00130644f
C3910 net69 net9_9 0.0031411f
C3911 net8 net9_2 0.0125601f
C3912 net8 net9_3 0.0136341f
C3913 net8 net9_4 0.0137342f
C3914 net8_2 net9_7 0.00274259f
C3915 net8_2 net9_9 0.0131881f
C3916 net8_3 net9_11 0.00848717f
C3917 net8_3 net9_8 0.00548518f
C3918 net8_4 net9_5 0.00548518f
C3919 net8_6 net9_6 0.00548518f
C3920 net8_7 net9 0.0144775f
.ends
