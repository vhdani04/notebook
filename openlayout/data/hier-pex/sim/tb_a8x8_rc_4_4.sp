* A8x8: write 1 into cell (4, 4), toggle its XB, P delays (load 0 fF)
.include /home/vhdani/openlayout/models/asap7_ngspice/7nm_TT.pm
.include ../win/a8x8.h0.1.pex.spice
VBLB_0 BLB_0 0 0.7
VBLB_1 BLB_1 0 0.7
VBLB_2 BLB_2 0 0.7
VBLB_3 BLB_3 0 0.7
VBLB_4 BLB_4 0 0
VBLB_5 BLB_5 0 0.7
VBLB_6 BLB_6 0 0.7
VBLB_7 BLB_7 0 0.7
VBL_0 BL_0 0 0.7
VBL_1 BL_1 0 0.7
VBL_2 BL_2 0 0.7
VBL_3 BL_3 0 0.7
VBL_4 BL_4 0 0.7
VBL_5 BL_5 0 0.7
VBL_6 BL_6 0 0.7
VBL_7 BL_7 0 0.7
VVDD_1 VDD_1 0 0.7
VVDD_3 VDD_3 0 0.7
VVDD_5 VDD_5 0 0.7
VVDD_7 VDD_7 0 0.7
VVSS_0 VSS_0 0 0
VVSS_2 VSS_2 0 0
VVSS_4 VSS_4 0 0
VVSS_6 VSS_6 0 0
VVSS_8 VSS_8 0 0
VWL_0 WL_0 0 0
VWL_1 WL_1 0 0
VWL_2 WL_2 0 0
VWL_3 WL_3 0 0
VWL_4 WL_4 0 pwl(0 0 0.1n 0 0.12n 0.7 0.6n 0.7 0.62n 0)
VWL_5 WL_5 0 0
VWL_6 WL_6 0 0
VWL_7 WL_7 0 0
VXB_0_0 XB_0_0 0 0.7
VXB_0_1 XB_0_1 0 0.7
VXB_0_2 XB_0_2 0 0.7
VXB_0_3 XB_0_3 0 0.7
VXB_0_4 XB_0_4 0 0.7
VXB_0_5 XB_0_5 0 0.7
VXB_0_6 XB_0_6 0 0.7
VXB_0_7 XB_0_7 0 0.7
VXB_1_0 XB_1_0 0 0.7
VXB_1_1 XB_1_1 0 0.7
VXB_1_2 XB_1_2 0 0.7
VXB_1_3 XB_1_3 0 0.7
VXB_1_4 XB_1_4 0 0.7
VXB_1_5 XB_1_5 0 0.7
VXB_1_6 XB_1_6 0 0.7
VXB_1_7 XB_1_7 0 0.7
VXB_2_0 XB_2_0 0 0.7
VXB_2_1 XB_2_1 0 0.7
VXB_2_2 XB_2_2 0 0.7
VXB_2_3 XB_2_3 0 0.7
VXB_2_4 XB_2_4 0 0.7
VXB_2_5 XB_2_5 0 0.7
VXB_2_6 XB_2_6 0 0.7
VXB_2_7 XB_2_7 0 0.7
VXB_3_0 XB_3_0 0 0.7
VXB_3_1 XB_3_1 0 0.7
VXB_3_2 XB_3_2 0 0.7
VXB_3_3 XB_3_3 0 0.7
VXB_3_4 XB_3_4 0 0.7
VXB_3_5 XB_3_5 0 0.7
VXB_3_6 XB_3_6 0 0.7
VXB_3_7 XB_3_7 0 0.7
VXB_4_0 XB_4_0 0 0.7
VXB_4_1 XB_4_1 0 0.7
VXB_4_2 XB_4_2 0 0.7
VXB_4_3 XB_4_3 0 0.7
VXB_4_4 XB_4_4 0 pwl(0 0.7 1n 0.7 1.02n 0 2n 0 2.02n 0.7 3n 0.7 3.02n 0 4n 0 4.02n 0.7)
VXB_4_5 XB_4_5 0 0.7
VXB_4_6 XB_4_6 0 0.7
VXB_4_7 XB_4_7 0 0.7
VXB_5_0 XB_5_0 0 0.7
VXB_5_1 XB_5_1 0 0.7
VXB_5_2 XB_5_2 0 0.7
VXB_5_3 XB_5_3 0 0.7
VXB_5_4 XB_5_4 0 0.7
VXB_5_5 XB_5_5 0 0.7
VXB_5_6 XB_5_6 0 0.7
VXB_5_7 XB_5_7 0 0.7
VXB_6_0 XB_6_0 0 0.7
VXB_6_1 XB_6_1 0 0.7
VXB_6_2 XB_6_2 0 0.7
VXB_6_3 XB_6_3 0 0.7
VXB_6_4 XB_6_4 0 0.7
VXB_6_5 XB_6_5 0 0.7
VXB_6_6 XB_6_6 0 0.7
VXB_6_7 XB_6_7 0 0.7
VXB_7_0 XB_7_0 0 0.7
VXB_7_1 XB_7_1 0 0.7
VXB_7_2 XB_7_2 0 0.7
VXB_7_3 XB_7_3 0 0.7
VXB_7_4 XB_7_4 0 0.7
VXB_7_5 XB_7_5 0 0.7
VXB_7_6 XB_7_6 0 0.7
VXB_7_7 XB_7_7 0 0.7
X1 BLB_0 BLB_1 BLB_2 BLB_3 BLB_4 BLB_5 BLB_6 BLB_7 BL_0 BL_1 BL_2 BL_3 BL_4 BL_5 BL_6 BL_7 P_0_0 P_0_1 P_0_2 P_0_3 P_0_4 P_0_5 P_0_6 P_0_7 P_1_0 P_1_1 P_1_2 P_1_3 P_1_4 P_1_5 P_1_6 P_1_7 P_2_0 P_2_1 P_2_2 P_2_3 P_2_4 P_2_5 P_2_6 P_2_7 P_3_0 P_3_1 P_3_2 P_3_3 P_3_4 P_3_5 P_3_6 P_3_7 P_4_0 P_4_1 P_4_2 P_4_3 P_4_4 P_4_5 P_4_6 P_4_7 P_5_0 P_5_1 P_5_2 P_5_3 P_5_4 P_5_5 P_5_6 P_5_7 P_6_0 P_6_1 P_6_2 P_6_3 P_6_4 P_6_5 P_6_6 P_6_7 P_7_0 P_7_1 P_7_2 P_7_3 P_7_4 P_7_5 P_7_6 P_7_7 VDD_1 VDD_3 VDD_5 VDD_7 VSS_0 VSS_2 VSS_4 VSS_6 VSS_8 WL_0 WL_1 WL_2 WL_3 WL_4 WL_5 WL_6 WL_7 XB_0_0 XB_0_1 XB_0_2 XB_0_3 XB_0_4 XB_0_5 XB_0_6 XB_0_7 XB_1_0 XB_1_1 XB_1_2 XB_1_3 XB_1_4 XB_1_5 XB_1_6 XB_1_7 XB_2_0 XB_2_1 XB_2_2 XB_2_3 XB_2_4 XB_2_5 XB_2_6 XB_2_7 XB_3_0 XB_3_1 XB_3_2 XB_3_3 XB_3_4 XB_3_5 XB_3_6 XB_3_7 XB_4_0 XB_4_1 XB_4_2 XB_4_3 XB_4_4 XB_4_5 XB_4_6 XB_4_7 XB_5_0 XB_5_1 XB_5_2 XB_5_3 XB_5_4 XB_5_5 XB_5_6 XB_5_7 XB_6_0 XB_6_1 XB_6_2 XB_6_3 XB_6_4 XB_6_5 XB_6_6 XB_6_7 XB_7_0 XB_7_1 XB_7_2 XB_7_3 XB_7_4 XB_7_5 XB_7_6 XB_7_7 A8x8
.tran 1p 4.6n
.control
set num_threads=1
run
meas tran p_at_1p9 find v(P_4_4) at=1.9n
meas tran p_at_2p9 find v(P_4_4) at=2.9n
meas tran tpr1 trig v(XB_4_4) val=0.35 fall=1 targ v(P_4_4) val=0.35 rise=1
meas tran tpf1 trig v(XB_4_4) val=0.35 rise=1 targ v(P_4_4) val=0.35 fall=1
meas tran tpr2 trig v(XB_4_4) val=0.35 fall=2 targ v(P_4_4) val=0.35 rise=2
meas tran tpf2 trig v(XB_4_4) val=0.35 rise=2 targ v(P_4_4) val=0.35 fall=2
meas tran trise trig v(P_4_4) val=0.14 rise=1 targ v(P_4_4) val=0.56 rise=1
meas tran tfall trig v(P_4_4) val=0.56 fall=1 targ v(P_4_4) val=0.14 fall=1
.endc
.end
