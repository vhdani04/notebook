* RO51 - parasitic extraction by OpenLayout (openlayout pex, mode rc)
* layout: /tmp/xs/ro51.gds
* C: FasterCap 3D field solver (k = 4.6 front end, 3.23 above z = 0.074 um); R: KLayout RNetExtractor, reference sheet / via resistances
* 102 transistors, 357 resistors, 4688 capacitors
* total capacitance per net (fF): S0 0.4054, S1 0.3825, S10 0.3853, S11 0.3874, S12 0.3889, S13 0.3878, S14 0.3879, S15 0.3861, S16 0.3850, S17 0.3816, S18 0.3760, S19 0.3704, S2 0.3829, S20 0.3750, S21 0.3788, S22 0.3797, S23 0.3824, S24 0.3839, S25 0.3808, S26 0.4155, S27 0.3825, S28 0.3829, S29 0.3813, S3 0.3813, S30 0.3810, S31 0.3840, S32 0.3841, S33 0.3818, S34 0.3815, S35 0.3824, S36 0.3864, S37 0.3878, S38 0.3860, S39 0.3856, S4 0.3797, S40 0.3859, S41 0.3843, S42 0.3809, S43 0.3797, S44 0.3834, S45 0.3851, S46 0.3812, S47 0.3810, S48 0.3807, S49 0.3824, S5 0.3761, S50 0.3806, S6 0.3733, S7 0.3774, S8 0.3815, S9 0.3830, VDD 4.8452, VSS_0 7.4928, VSS_1 2.6566

.subckt RO51 S0 S1 S10 S11 S12 S13 S14 S15 S16 S17 S18 S19 S2 S20 S21 S22 S23 S24 S25 S26 S27 S28 S29 S3 S30 S31 S32 S33 S34 S35 S36 S37 S38 S39 S4 S40 S41 S42 S43 S44 S45 S46 S47 S48 S49 S5 S50 S6 S7 S8 S9 VDD VSS_0 VSS_1
N1 S1_6 S0_4 VSS_0 VSS_0 nmos_rvt l=20n nfin=3
N2 S2_6 S1_4 VSS_0 VSS_0 nmos_rvt l=20n nfin=3
N3 S3_6 S2_4 VSS_0 VSS_0 nmos_rvt l=20n nfin=3
N4 S4_6 S3_4 VSS_0 VSS_0 nmos_rvt l=20n nfin=3
N5 S5_6 S4_4 VSS_0 VSS_0 nmos_rvt l=20n nfin=3
N6 S6_6 S5_4 VSS_0 VSS_0 nmos_rvt l=20n nfin=3
N7 S7_6 S6_4 VSS_0 VSS_0 nmos_rvt l=20n nfin=3
N8 S8_6 S7_4 VSS_0 VSS_0 nmos_rvt l=20n nfin=3
N9 S9_6 S8_4 VSS_0 VSS_0 nmos_rvt l=20n nfin=3
N10 S10_6 S9_4 VSS_0 VSS_0 nmos_rvt l=20n nfin=3
N11 S11_6 S10_4 VSS_0 VSS_0 nmos_rvt l=20n nfin=3
N12 S12_6 S11_4 VSS_0 VSS_0 nmos_rvt l=20n nfin=3
N13 S13_6 S12_4 VSS_0 VSS_0 nmos_rvt l=20n nfin=3
N14 S14_6 S13_4 VSS_0 VSS_0 nmos_rvt l=20n nfin=3
N15 S15_6 S14_4 VSS_0 VSS_0 nmos_rvt l=20n nfin=3
N16 S16_6 S15_4 VSS_0 VSS_0 nmos_rvt l=20n nfin=3
N17 S17_6 S16_4 VSS_0 VSS_0 nmos_rvt l=20n nfin=3
N18 S18_6 S17_4 VSS_0 VSS_0 nmos_rvt l=20n nfin=3
N19 S19_6 S18_4 VSS_0 VSS_0 nmos_rvt l=20n nfin=3
N20 S20_6 S19_4 VSS_0 VSS_0 nmos_rvt l=20n nfin=3
N21 S21_6 S20_4 VSS_0 VSS_0 nmos_rvt l=20n nfin=3
N22 S22_6 S21_4 VSS_0 VSS_0 nmos_rvt l=20n nfin=3
N23 S23_6 S22_4 VSS_0 VSS_0 nmos_rvt l=20n nfin=3
N24 S24_6 S23_4 VSS_0 VSS_0 nmos_rvt l=20n nfin=3
N25 S25_6 S24_4 VSS_0 VSS_0 nmos_rvt l=20n nfin=3
N26 S26_6 S25_4 VSS_0 VSS_0 nmos_rvt l=20n nfin=3
N27 VSS_1 S50_4 S0_7 VSS_0 nmos_rvt l=20n nfin=3
N28 VSS_1 S49_4 S50_7 VSS_0 nmos_rvt l=20n nfin=3
N29 VSS_1 S48_4 S49_7 VSS_0 nmos_rvt l=20n nfin=3
N30 VSS_1 S47_4 S48_7 VSS_0 nmos_rvt l=20n nfin=3
N31 VSS_1 S46_4 S47_7 VSS_0 nmos_rvt l=20n nfin=3
N32 VSS_1 S45_4 S46_7 VSS_0 nmos_rvt l=20n nfin=3
N33 VSS_1 S44_4 S45_7 VSS_0 nmos_rvt l=20n nfin=3
N34 VSS_1 S43_4 S44_7 VSS_0 nmos_rvt l=20n nfin=3
N35 VSS_1 S42_4 S43_7 VSS_0 nmos_rvt l=20n nfin=3
N36 VSS_1 S41_4 S42_7 VSS_0 nmos_rvt l=20n nfin=3
N37 VSS_1 S40_4 S41_7 VSS_0 nmos_rvt l=20n nfin=3
N38 VSS_1 S39_4 S40_7 VSS_0 nmos_rvt l=20n nfin=3
N39 VSS_1 S38_4 S39_7 VSS_0 nmos_rvt l=20n nfin=3
N40 VSS_1 S37_4 S38_7 VSS_0 nmos_rvt l=20n nfin=3
N41 VSS_1 S36_4 S37_7 VSS_0 nmos_rvt l=20n nfin=3
N42 VSS_1 S35_4 S36_7 VSS_0 nmos_rvt l=20n nfin=3
N43 VSS_1 S34_4 S35_7 VSS_0 nmos_rvt l=20n nfin=3
N44 VSS_1 S33_4 S34_7 VSS_0 nmos_rvt l=20n nfin=3
N45 VSS_1 S32_4 S33_7 VSS_0 nmos_rvt l=20n nfin=3
N46 VSS_1 S31_4 S32_7 VSS_0 nmos_rvt l=20n nfin=3
N47 VSS_1 S30_4 S31_7 VSS_0 nmos_rvt l=20n nfin=3
N48 VSS_1 S29_4 S30_7 VSS_0 nmos_rvt l=20n nfin=3
N49 VSS_1 S28_4 S29_7 VSS_0 nmos_rvt l=20n nfin=3
N50 VSS_1 S27_4 S28_7 VSS_0 nmos_rvt l=20n nfin=3
N51 VSS_1 S26_4 S27_7 VSS_0 nmos_rvt l=20n nfin=3
N52 S1_7 S0_5 VDD VDD pmos_rvt l=20n nfin=3
N53 S2_7 S1_5 VDD VDD pmos_rvt l=20n nfin=3
N54 S3_7 S2_5 VDD VDD pmos_rvt l=20n nfin=3
N55 S4_7 S3_5 VDD VDD pmos_rvt l=20n nfin=3
N56 S5_7 S4_5 VDD VDD pmos_rvt l=20n nfin=3
N57 S6_7 S5_5 VDD VDD pmos_rvt l=20n nfin=3
N58 S7_7 S6_5 VDD VDD pmos_rvt l=20n nfin=3
N59 S8_7 S7_5 VDD VDD pmos_rvt l=20n nfin=3
N60 S9_7 S8_5 VDD VDD pmos_rvt l=20n nfin=3
N61 S10_7 S9_5 VDD VDD pmos_rvt l=20n nfin=3
N62 S11_7 S10_5 VDD VDD pmos_rvt l=20n nfin=3
N63 S12_7 S11_5 VDD VDD pmos_rvt l=20n nfin=3
N64 S13_7 S12_5 VDD VDD pmos_rvt l=20n nfin=3
N65 S14_7 S13_5 VDD VDD pmos_rvt l=20n nfin=3
N66 S15_7 S14_5 VDD VDD pmos_rvt l=20n nfin=3
N67 S16_7 S15_5 VDD VDD pmos_rvt l=20n nfin=3
N68 S17_7 S16_5 VDD VDD pmos_rvt l=20n nfin=3
N69 S18_7 S17_5 VDD VDD pmos_rvt l=20n nfin=3
N70 S19_7 S18_5 VDD VDD pmos_rvt l=20n nfin=3
N71 S20_7 S19_5 VDD VDD pmos_rvt l=20n nfin=3
N72 S21_7 S20_5 VDD VDD pmos_rvt l=20n nfin=3
N73 S22_7 S21_5 VDD VDD pmos_rvt l=20n nfin=3
N74 S23_7 S22_5 VDD VDD pmos_rvt l=20n nfin=3
N75 S24_7 S23_5 VDD VDD pmos_rvt l=20n nfin=3
N76 S25_7 S24_5 VDD VDD pmos_rvt l=20n nfin=3
N77 S26_7 S25_5 VDD VDD pmos_rvt l=20n nfin=3
N78 VDD S50_5 S0_6 VDD pmos_rvt l=20n nfin=3
N79 VDD S49_5 S50_6 VDD pmos_rvt l=20n nfin=3
N80 VDD S48_5 S49_6 VDD pmos_rvt l=20n nfin=3
N81 VDD S47_5 S48_6 VDD pmos_rvt l=20n nfin=3
N82 VDD S46_5 S47_6 VDD pmos_rvt l=20n nfin=3
N83 VDD S45_5 S46_6 VDD pmos_rvt l=20n nfin=3
N84 VDD S44_5 S45_6 VDD pmos_rvt l=20n nfin=3
N85 VDD S43_5 S44_6 VDD pmos_rvt l=20n nfin=3
N86 VDD S42_5 S43_6 VDD pmos_rvt l=20n nfin=3
N87 VDD S41_5 S42_6 VDD pmos_rvt l=20n nfin=3
N88 VDD S40_5 S41_6 VDD pmos_rvt l=20n nfin=3
N89 VDD S39_5 S40_6 VDD pmos_rvt l=20n nfin=3
N90 VDD S38_5 S39_6 VDD pmos_rvt l=20n nfin=3
N91 VDD S37_5 S38_6 VDD pmos_rvt l=20n nfin=3
N92 VDD S36_5 S37_6 VDD pmos_rvt l=20n nfin=3
N93 VDD S35_5 S36_6 VDD pmos_rvt l=20n nfin=3
N94 VDD S34_5 S35_6 VDD pmos_rvt l=20n nfin=3
N95 VDD S33_5 S34_6 VDD pmos_rvt l=20n nfin=3
N96 VDD S32_5 S33_6 VDD pmos_rvt l=20n nfin=3
N97 VDD S31_5 S32_6 VDD pmos_rvt l=20n nfin=3
N98 VDD S30_5 S31_6 VDD pmos_rvt l=20n nfin=3
N99 VDD S29_5 S30_6 VDD pmos_rvt l=20n nfin=3
N100 VDD S28_5 S29_6 VDD pmos_rvt l=20n nfin=3
N101 VDD S27_5 S28_6 VDD pmos_rvt l=20n nfin=3
N102 VDD S26_5 S27_6 VDD pmos_rvt l=20n nfin=3
R1 S1_5 S1_1 22.9598
R2 S1_1 S1_4 22.9598
R3 S1 S1_3 15.1551
R4 S1_6 S1_2 63.5313
R5 S1_7 S1_2 63.5313
R6 S1_1 S1_3 40.8794
R7 S1_3 S1_2 51.6604
R8 S2_5 S2_1 22.9598
R9 S2_1 S2_4 22.9598
R10 S2 S2_3 15.1551
R11 S2_6 S2_2 63.5313
R12 S2_7 S2_2 63.5313
R13 S2_1 S2_3 40.8794
R14 S2_3 S2_2 51.6604
R15 S3_5 S3_1 22.9598
R16 S3_1 S3_4 22.9598
R17 S3 S3_3 15.1551
R18 S3_6 S3_2 63.5313
R19 S3_7 S3_2 63.5313
R20 S3_1 S3_3 40.8794
R21 S3_3 S3_2 51.6604
R22 S4_5 S4_1 22.9598
R23 S4_1 S4_4 22.9598
R24 S4 S4_3 15.1551
R25 S4_6 S4_2 63.5313
R26 S4_7 S4_2 63.5313
R27 S4_1 S4_3 40.8794
R28 S4_3 S4_2 51.6604
R29 S5_5 S5_1 22.9598
R30 S5_1 S5_4 22.9598
R31 S5 S5_3 15.1551
R32 S5_6 S5_2 63.5313
R33 S5_7 S5_2 63.5313
R34 S5_1 S5_3 40.8794
R35 S5_3 S5_2 51.6604
R36 S6_5 S6_1 22.9598
R37 S6_1 S6_4 22.9598
R38 S6 S6_3 15.1551
R39 S6_6 S6_2 63.5313
R40 S6_7 S6_2 63.5313
R41 S6_1 S6_3 40.8794
R42 S6_3 S6_2 51.6604
R43 S7_5 S7_1 22.9598
R44 S7_1 S7_4 22.9598
R45 S7 S7_3 15.1551
R46 S7_6 S7_2 63.5313
R47 S7_7 S7_2 63.5313
R48 S7_1 S7_3 40.8794
R49 S7_3 S7_2 51.6604
R50 S8_5 S8_1 22.9598
R51 S8_1 S8_4 22.9598
R52 S8 S8_3 15.1551
R53 S8_6 S8_2 63.5313
R54 S8_7 S8_2 63.5313
R55 S8_1 S8_3 40.8794
R56 S8_3 S8_2 51.6604
R57 S9_5 S9_1 22.9598
R58 S9_1 S9_4 22.9598
R59 S9 S9_3 15.1551
R60 S9_6 S9_2 63.5313
R61 S9_7 S9_2 63.5313
R62 S9_1 S9_3 40.8794
R63 S9_3 S9_2 51.6604
R64 S10_5 S10_1 22.9598
R65 S10_1 S10_4 22.9598
R66 S10 S10_3 15.1551
R67 S10_6 S10_2 63.5313
R68 S10_7 S10_2 63.5313
R69 S10_1 S10_3 40.8794
R70 S10_3 S10_2 51.6604
R71 S11_5 S11_1 22.9598
R72 S11_1 S11_4 22.9598
R73 S11 S11_3 15.1551
R74 S11_6 S11_2 63.5313
R75 S11_7 S11_2 63.5313
R76 S11_1 S11_3 40.8794
R77 S11_3 S11_2 51.6604
R78 S12_5 S12_1 22.9598
R79 S12_1 S12_4 22.9598
R80 S12 S12_3 15.1551
R81 S12_6 S12_2 63.5313
R82 S12_7 S12_2 63.5313
R83 S12_1 S12_3 40.8794
R84 S12_3 S12_2 51.6604
R85 S13_5 S13_1 22.9598
R86 S13_1 S13_4 22.9598
R87 S13 S13_3 15.1551
R88 S13_6 S13_2 63.5313
R89 S13_7 S13_2 63.5313
R90 S13_1 S13_3 40.8794
R91 S13_3 S13_2 51.6604
R92 S14_5 S14_1 22.9598
R93 S14_1 S14_4 22.9598
R94 S14 S14_3 15.1551
R95 S14_6 S14_2 63.5313
R96 S14_7 S14_2 63.5313
R97 S14_1 S14_3 40.8794
R98 S14_3 S14_2 51.6604
R99 S15_5 S15_1 22.9598
R100 S15_1 S15_4 22.9598
R101 S15 S15_3 15.1551
R102 S15_6 S15_2 63.5313
R103 S15_7 S15_2 63.5313
R104 S15_1 S15_3 40.8794
R105 S15_3 S15_2 51.6604
R106 S16_5 S16_1 22.9598
R107 S16_1 S16_4 22.9598
R108 S16 S16_3 15.1551
R109 S16_6 S16_2 63.5313
R110 S16_7 S16_2 63.5313
R111 S16_1 S16_3 40.8794
R112 S16_3 S16_2 51.6604
R113 S17_5 S17_1 22.9598
R114 S17_1 S17_4 22.9598
R115 S17 S17_3 15.1551
R116 S17_6 S17_2 63.5313
R117 S17_7 S17_2 63.5313
R118 S17_1 S17_3 40.8794
R119 S17_3 S17_2 51.6604
R120 S18_5 S18_1 22.9598
R121 S18_1 S18_4 22.9598
R122 S18 S18_3 15.1551
R123 S18_6 S18_2 63.5313
R124 S18_7 S18_2 63.5313
R125 S18_1 S18_3 40.8794
R126 S18_3 S18_2 51.6604
R127 S19_5 S19_1 22.9598
R128 S19_1 S19_4 22.9598
R129 S19 S19_3 15.1551
R130 S19_6 S19_2 63.5313
R131 S19_7 S19_2 63.5313
R132 S19_1 S19_3 40.8794
R133 S19_3 S19_2 51.6604
R134 S20_5 S20_1 22.9598
R135 S20_1 S20_4 22.9598
R136 S20 S20_3 15.1551
R137 S20_6 S20_2 63.5313
R138 S20_7 S20_2 63.5313
R139 S20_1 S20_3 40.8794
R140 S20_3 S20_2 51.6604
R141 S21_5 S21_1 22.9598
R142 S21_1 S21_4 22.9598
R143 S21 S21_3 15.1551
R144 S21_6 S21_2 63.5313
R145 S21_7 S21_2 63.5313
R146 S21_1 S21_3 40.8794
R147 S21_3 S21_2 51.6604
R148 S22_5 S22_1 22.9598
R149 S22_1 S22_4 22.9598
R150 S22 S22_3 15.1551
R151 S22_6 S22_2 63.5313
R152 S22_7 S22_2 63.5313
R153 S22_1 S22_3 40.8794
R154 S22_3 S22_2 51.6604
R155 S23_5 S23_1 22.9598
R156 S23_1 S23_4 22.9598
R157 S23 S23_3 15.1551
R158 S23_6 S23_2 63.5313
R159 S23_7 S23_2 63.5313
R160 S23_1 S23_3 40.8794
R161 S23_3 S23_2 51.6604
R162 S24_5 S24_1 22.9598
R163 S24_1 S24_4 22.9598
R164 S24 S24_3 15.1551
R165 S24_6 S24_2 63.5313
R166 S24_7 S24_2 63.5313
R167 S24_1 S24_3 40.8794
R168 S24_3 S24_2 51.6604
R169 S25_5 S25_1 22.9598
R170 S25_1 S25_4 22.9598
R171 S25 S25_3 15.1551
R172 S25_6 S25_2 63.5313
R173 S25_7 S25_2 63.5313
R174 S25_1 S25_3 40.8794
R175 S25_3 S25_2 51.6604
R176 S26_4 S26_1 22.9598
R177 S26_1 S26_5 22.9598
R178 S26_3 S26 15.1551
R179 S26_6 S26_2 63.5313
R180 S26_7 S26_2 63.5313
R181 S26_1 S26_3 40.8794
R182 S26_2 S26_3 219.432
R183 S0_5 S0_1 22.9598
R184 S0_1 S0_4 22.9598
R185 S0 S0_2 15.1551
R186 S0_6 S0_3 63.5313
R187 S0_7 S0_3 63.5313
R188 S0_1 S0_2 40.8794
R189 S0_2 S0_3 181.661
R190 S50_4 S50_1 22.9598
R191 S50_1 S50_5 22.9598
R192 S50_2 S50 15.1551
R193 S50_6 S50_3 63.5313
R194 S50_7 S50_3 63.5313
R195 S50_1 S50_2 40.8794
R196 S50_3 S50_2 51.6604
R197 S49_4 S49_1 22.9598
R198 S49_1 S49_5 22.9598
R199 S49_2 S49 15.1551
R200 S49_6 S49_3 63.5313
R201 S49_7 S49_3 63.5313
R202 S49_1 S49_2 40.8794
R203 S49_3 S49_2 51.6604
R204 S48_4 S48_1 22.9598
R205 S48_1 S48_5 22.9598
R206 S48_2 S48 15.1551
R207 S48_6 S48_3 63.5313
R208 S48_7 S48_3 63.5313
R209 S48_1 S48_2 40.8794
R210 S48_3 S48_2 51.6604
R211 S47_4 S47_1 22.9598
R212 S47_1 S47_5 22.9598
R213 S47_2 S47 15.1551
R214 S47_6 S47_3 63.5313
R215 S47_7 S47_3 63.5313
R216 S47_1 S47_2 40.8794
R217 S47_3 S47_2 51.6604
R218 S46_4 S46_1 22.9598
R219 S46_1 S46_5 22.9598
R220 S46_2 S46 15.1551
R221 S46_6 S46_3 63.5313
R222 S46_7 S46_3 63.5313
R223 S46_1 S46_2 40.8794
R224 S46_3 S46_2 51.6604
R225 S45_4 S45_1 22.9598
R226 S45_1 S45_5 22.9598
R227 S45_2 S45 15.1551
R228 S45_6 S45_3 63.5313
R229 S45_7 S45_3 63.5313
R230 S45_1 S45_2 40.8794
R231 S45_3 S45_2 51.6604
R232 S44_4 S44_1 22.9598
R233 S44_1 S44_5 22.9598
R234 S44_2 S44 15.1551
R235 S44_6 S44_3 63.5313
R236 S44_7 S44_3 63.5313
R237 S44_1 S44_2 40.8794
R238 S44_3 S44_2 51.6604
R239 S43_4 S43_1 22.9598
R240 S43_1 S43_5 22.9598
R241 S43_2 S43 15.1551
R242 S43_6 S43_3 63.5313
R243 S43_7 S43_3 63.5313
R244 S43_1 S43_2 40.8794
R245 S43_3 S43_2 51.6604
R246 S42_4 S42_1 22.9598
R247 S42_1 S42_5 22.9598
R248 S42_2 S42 15.1551
R249 S42_6 S42_3 63.5313
R250 S42_7 S42_3 63.5313
R251 S42_1 S42_2 40.8794
R252 S42_3 S42_2 51.6604
R253 S41_4 S41_1 22.9598
R254 S41_1 S41_5 22.9598
R255 S41_2 S41 15.1551
R256 S41_6 S41_3 63.5313
R257 S41_7 S41_3 63.5313
R258 S41_1 S41_2 40.8794
R259 S41_3 S41_2 51.6604
R260 S40_4 S40_1 22.9598
R261 S40_1 S40_5 22.9598
R262 S40_2 S40 15.1551
R263 S40_6 S40_3 63.5313
R264 S40_7 S40_3 63.5313
R265 S40_1 S40_2 40.8794
R266 S40_3 S40_2 51.6604
R267 S39_4 S39_1 22.9598
R268 S39_1 S39_5 22.9598
R269 S39_2 S39 15.1551
R270 S39_6 S39_3 63.5313
R271 S39_7 S39_3 63.5313
R272 S39_1 S39_2 40.8794
R273 S39_3 S39_2 51.6604
R274 S38_4 S38_1 22.9598
R275 S38_1 S38_5 22.9598
R276 S38_2 S38 15.1551
R277 S38_6 S38_3 63.5313
R278 S38_7 S38_3 63.5313
R279 S38_1 S38_2 40.8794
R280 S38_3 S38_2 51.6604
R281 S37_4 S37_1 22.9598
R282 S37_1 S37_5 22.9598
R283 S37_2 S37 15.1551
R284 S37_6 S37_3 63.5313
R285 S37_7 S37_3 63.5313
R286 S37_1 S37_2 40.8794
R287 S37_3 S37_2 51.6604
R288 S36_4 S36_1 22.9598
R289 S36_1 S36_5 22.9598
R290 S36_2 S36 15.1551
R291 S36_6 S36_3 63.5313
R292 S36_7 S36_3 63.5313
R293 S36_1 S36_2 40.8794
R294 S36_3 S36_2 51.6604
R295 S35_4 S35_1 22.9598
R296 S35_1 S35_5 22.9598
R297 S35_2 S35 15.1551
R298 S35_6 S35_3 63.5313
R299 S35_7 S35_3 63.5313
R300 S35_1 S35_2 40.8794
R301 S35_3 S35_2 51.6604
R302 S34_4 S34_1 22.9598
R303 S34_1 S34_5 22.9598
R304 S34_2 S34 15.1551
R305 S34_6 S34_3 63.5313
R306 S34_7 S34_3 63.5313
R307 S34_1 S34_2 40.8794
R308 S34_3 S34_2 51.6604
R309 S33_4 S33_1 22.9598
R310 S33_1 S33_5 22.9598
R311 S33_2 S33 15.1551
R312 S33_6 S33_3 63.5313
R313 S33_7 S33_3 63.5313
R314 S33_1 S33_2 40.8794
R315 S33_3 S33_2 51.6604
R316 S32_4 S32_1 22.9598
R317 S32_1 S32_5 22.9598
R318 S32_2 S32 15.1551
R319 S32_6 S32_3 63.5313
R320 S32_7 S32_3 63.5313
R321 S32_1 S32_2 40.8794
R322 S32_3 S32_2 51.6604
R323 S31_4 S31_1 22.9598
R324 S31_1 S31_5 22.9598
R325 S31_2 S31 15.1551
R326 S31_6 S31_3 63.5313
R327 S31_7 S31_3 63.5313
R328 S31_1 S31_2 40.8794
R329 S31_3 S31_2 51.6604
R330 S30_4 S30_1 22.9598
R331 S30_1 S30_5 22.9598
R332 S30_2 S30 15.1551
R333 S30_6 S30_3 63.5313
R334 S30_7 S30_3 63.5313
R335 S30_1 S30_2 40.8794
R336 S30_3 S30_2 51.6604
R337 S29_4 S29_1 22.9598
R338 S29_1 S29_5 22.9598
R339 S29_2 S29 15.1551
R340 S29_6 S29_3 63.5313
R341 S29_7 S29_3 63.5313
R342 S29_1 S29_2 40.8794
R343 S29_3 S29_2 51.6604
R344 S28_4 S28_1 22.9598
R345 S28_1 S28_5 22.9598
R346 S28_2 S28 15.1551
R347 S28_6 S28_3 63.5313
R348 S28_7 S28_3 63.5313
R349 S28_1 S28_2 40.8794
R350 S28_3 S28_2 51.6604
R351 S27_4 S27_1 22.9598
R352 S27_1 S27_5 22.9598
R353 S27_2 S27 15.1551
R354 S27_6 S27_3 63.5313
R355 S27_7 S27_3 63.5313
R356 S27_1 S27_2 40.8794
R357 S27_3 S27_2 51.6604
C1 S0 S38_5 1.33097e-05f
C2 S0 S39_5 2.10193e-05f
C3 S0 S40_5 2.29777e-05f
C4 S0 S41_5 1.77494e-05f
C5 S0 S46_5 2.4492e-05f
C6 S0 S47_5 4.29361e-05f
C7 S0 S48_5 5.61807e-05f
C8 S0 S49_5 6.23446e-05f
C9 S0 S50_5 0.00686516f
C10 S0 VDD 0.00612287f
C11 S0 VSS_0 0.016817f
C12 S0 VSS_1 0.00168225f
C13 S0_1 S10_1 1.26016e-05f
C14 S0_1 S10_2 2.84502e-05f
C15 S0_1 S10_3 3.27628e-05f
C16 S0_1 S11_1 1.4358e-05f
C17 S0_1 S11_2 3.24155e-05f
C18 S0_1 S11_3 3.73291e-05f
C19 S0_1 S12_1 1.39131e-05f
C20 S0_1 S12_2 3.14111e-05f
C21 S0_1 S12_3 3.61725e-05f
C22 S0_1 S13_2 1.26623e-05f
C23 S0_1 S13_3 1.45816e-05f
C24 S0_1 S1_1 0.0050124f
C25 S0_1 S1_2 0.0113163f
C26 S0_1 S1_3 0.0130317f
C27 S0_1 S23_2 1.42116e-05f
C28 S0_1 S23_3 1.63659e-05f
C29 S0_1 S24_1 1.24913e-05f
C30 S0_1 S24_2 2.82012e-05f
C31 S0_1 S24_3 3.24761e-05f
C32 S0_1 S2_1 6.9642e-05f
C33 S0_1 S2_2 0.000157228f
C34 S0_1 S2_3 0.000181061f
C35 S0_1 S39_5 1.18591e-05f
C36 S0_1 S3_1 4.16065e-05f
C37 S0_1 S3_2 9.39333e-05f
C38 S0_1 S3_3 0.000108172f
C39 S0_1 S40_5 1.2964e-05f
C40 S0_1 S41_5 1.00142e-05f
C41 S0_1 S46_5 1.38184e-05f
C42 S0_1 S47_5 2.42246e-05f
C43 S0_1 S48_5 3.16972e-05f
C44 S0_1 S49_5 3.51749e-05f
C45 S0_1 S4_1 2.16931e-05f
C46 S0_1 S4_2 4.89756e-05f
C47 S0_1 S4_3 5.63995e-05f
C48 S0_1 S50_5 0.00387333f
C49 S0_1 S5_2 1.28565e-05f
C50 S0_1 S5_3 1.48053e-05f
C51 S0_1 S6_1 1.18947e-05f
C52 S0_1 S6_2 2.68542e-05f
C53 S0_1 S6_3 3.09249e-05f
C54 S0_1 VDD 0.00345453f
C55 S0_1 VSS_0 0.00948816f
C56 S0_1 VSS_1 0.000949125f
C57 S0_2 S27_5 1.0472e-05f
C58 S0_2 S28_5 1.55001e-05f
C59 S0_2 S38_5 2.8499e-05f
C60 S0_2 S39_5 4.50068e-05f
C61 S0_2 S40_5 4.92001e-05f
C62 S0_2 S41_5 3.80051e-05f
C63 S0_2 S46_5 5.24426e-05f
C64 S0_2 S47_5 9.19352e-05f
C65 S0_2 S48_5 0.000120295f
C66 S0_2 S49_5 0.000133493f
C67 S0_2 S50_5 0.0146997f
C68 S0_2 VDD 0.0131103f
C69 S0_2 VSS_0 0.0360087f
C70 S0_2 VSS_1 0.00360204f
C71 S0_3 S27_1 1.35586e-05f
C72 S0_3 S28_1 2.00688e-05f
C73 S0_3 S31_1 1.22758e-05f
C74 S0_3 S38_1 3.68991e-05f
C75 S0_3 S39_1 5.82726e-05f
C76 S0_3 S40_1 6.37018e-05f
C77 S0_3 S41_1 4.92072e-05f
C78 S0_3 S46_1 6.79e-05f
C79 S0_3 S47_1 0.000119033f
C80 S0_3 S48_1 0.000155752f
C81 S0_3 S49_1 0.00017284f
C82 S0_3 S50_1 0.0190325f
C83 S0_3 VDD 0.0169746f
C84 S0_3 VSS_0 0.0466223f
C85 S0_3 VSS_1 0.00466375f
C86 S0_4 S10_4 1.29306e-05f
C87 S0_4 S10_6 2.80962e-05f
C88 S0_4 S11_4 1.47328e-05f
C89 S0_4 S11_6 3.20121e-05f
C90 S0_4 S12_4 1.42763e-05f
C91 S0_4 S12_6 3.10202e-05f
C92 S0_4 S13_6 1.25047e-05f
C93 S0_4 S1_4 0.00514326f
C94 S0_4 S1_6 0.0111755f
C95 S0_4 S23_6 1.40348e-05f
C96 S0_4 S24_4 1.28175e-05f
C97 S0_4 S24_6 2.78503e-05f
C98 S0_4 S2_4 7.14601e-05f
C99 S0_4 S2_6 0.000155272f
C100 S0_4 S39_5 1.21687e-05f
C101 S0_4 S3_4 4.26927e-05f
C102 S0_4 S3_6 9.27644e-05f
C103 S0_4 S40_5 1.33025e-05f
C104 S0_4 S41_5 1.02757e-05f
C105 S0_4 S46_5 1.41792e-05f
C106 S0_4 S47_5 2.4857e-05f
C107 S0_4 S48_5 3.25247e-05f
C108 S0_4 S49_5 3.60932e-05f
C109 S0_4 S4_4 2.22594e-05f
C110 S0_4 S4_6 4.83662e-05f
C111 S0_4 S50_5 0.00397445f
C112 S0_4 S5_6 1.26965e-05f
C113 S0_4 S6_4 1.22052e-05f
C114 S0_4 S6_6 2.65201e-05f
C115 S0_4 VDD 0.00354471f
C116 S0_4 VSS_0 0.00973587f
C117 S0_4 VSS_1 0.000973903f
C118 S0_5 S1 0.00883286f
C119 S0_5 S10 2.22066e-05f
C120 S0_5 S10_5 1.29306e-05f
C121 S0_5 S10_7 2.80962e-05f
C122 S0_5 S11 2.53017e-05f
C123 S0_5 S11_5 1.47328e-05f
C124 S0_5 S11_7 3.20121e-05f
C125 S0_5 S12 2.45177e-05f
C126 S0_5 S12_5 1.42763e-05f
C127 S0_5 S12_7 3.10202e-05f
C128 S0_5 S13_7 1.25047e-05f
C129 S0_5 S1_5 0.00514326f
C130 S0_5 S1_7 0.0111755f
C131 S0_5 S2 0.000122723f
C132 S0_5 S23 1.10928e-05f
C133 S0_5 S23_7 1.40348e-05f
C134 S0_5 S24 2.20123e-05f
C135 S0_5 S24_5 1.28175e-05f
C136 S0_5 S24_7 2.78503e-05f
C137 S0_5 S2_5 7.14601e-05f
C138 S0_5 S2_7 0.000155272f
C139 S0_5 S3 7.3319e-05f
C140 S0_5 S39_5 1.21687e-05f
C141 S0_5 S3_5 4.26927e-05f
C142 S0_5 S3_7 9.27644e-05f
C143 S0_5 S4 3.82276e-05f
C144 S0_5 S40_5 1.33025e-05f
C145 S0_5 S41_5 1.02757e-05f
C146 S0_5 S46_5 1.41792e-05f
C147 S0_5 S47_5 2.4857e-05f
C148 S0_5 S48_5 3.25247e-05f
C149 S0_5 S49_5 3.60932e-05f
C150 S0_5 S4_5 2.22594e-05f
C151 S0_5 S4_7 4.83662e-05f
C152 S0_5 S5 1.0035e-05f
C153 S0_5 S50_5 0.00397445f
C154 S0_5 S5_7 1.26965e-05f
C155 S0_5 S6 2.09609e-05f
C156 S0_5 S6_5 1.22052e-05f
C157 S0_5 S6_7 2.65201e-05f
C158 S0_5 VDD 0.00354471f
C159 S0_5 VSS_0 0.00973587f
C160 S0_5 VSS_1 0.000973903f
C161 S0_6 S28_5 1.11088e-05f
C162 S0_6 S38_5 2.04249e-05f
C163 S0_6 S39_5 3.22559e-05f
C164 S0_6 S40_5 3.52612e-05f
C165 S0_6 S41_5 2.72379e-05f
C166 S0_6 S46_5 3.7585e-05f
C167 S0_6 S47_5 6.5889e-05f
C168 S0_6 S48_5 8.62139e-05f
C169 S0_6 S49_5 9.5673e-05f
C170 S0_6 S50_5 0.0105351f
C171 S0_6 VDD 0.00939604f
C172 S0_6 VSS_0 0.025807f
C173 S0_6 VSS_1 0.00258154f
C174 S0_7 S38_4 1.67427e-05f
C175 S0_7 S39_4 2.64407e-05f
C176 S0_7 S40_4 2.89042e-05f
C177 S0_7 S41_4 2.23274e-05f
C178 S0_7 S46_4 3.08091e-05f
C179 S0_7 S47_4 5.40104e-05f
C180 S0_7 S48_4 7.06711e-05f
C181 S0_7 S49_4 7.84249e-05f
C182 S0_7 S50_4 0.00863585f
C183 S0_7 VDD 0.00770211f
C184 S0_7 VSS_0 0.0211545f
C185 S0_7 VSS_1 0.00211614f
C186 S1 S10_7 1.46243e-05f
C187 S1 S11_7 2.39701e-05f
C188 S1 S12_7 2.7487e-05f
C189 S1 S24_7 1.02967e-05f
C190 S1 S25_7 1.39321e-05f
C191 S1 S2_7 0.00885001f
C192 S1 S38_5 1.52122e-05f
C193 S1 S39_5 3.60175e-05f
C194 S1 S3_7 0.000117451f
C195 S1 S40_5 3.31543e-05f
C196 S1 S41_5 2.05441e-05f
C197 S1 S46_5 2.34262e-05f
C198 S1 S47_5 6.08709e-05f
C199 S1 S48_5 6.87895e-05f
C200 S1 S49_5 0.000256534f
C201 S1 S4_7 5.53253e-05f
C202 S1 S50_6 0.000153747f
C203 S1 S6_7 1.11698e-05f
C204 S1 VDD 0.00766505f
C205 S1 VSS_0 0.0213834f
C206 S10 S11_7 0.00880477f
C207 S10 S12_7 0.000166221f
C208 S10 S13_7 8.76795e-05f
C209 S10 S14_7 3.6604e-05f
C210 S10 S15_7 3.27982e-05f
C211 S10 S16_7 1.98742e-05f
C212 S10 S19_7 1.52424e-05f
C213 S10 S34_5 1.16102e-05f
C214 S10 S35_5 1.48633e-05f
C215 S10 S36_5 3.88838e-05f
C216 S10 S37_5 4.5712e-05f
C217 S10 S38_5 7.827e-05f
C218 S10 S39_5 8.72824e-05f
C219 S10 S40_5 0.000275281f
C220 S10 S41_6 0.000146258f
C221 S10 S42_6 8.4985e-05f
C222 S10 S43_6 6.31982e-05f
C223 S10 S49_6 1.12512e-05f
C224 S10 S50_6 1.22806e-05f
C225 S10 VDD 0.00745374f
C226 S10 VSS_0 0.021561f
C227 S10_1 S11_2 0.00499646f
C228 S10_1 S12_6 9.4326e-05f
C229 S10_1 S13_6 4.97556e-05f
C230 S10_1 S14_6 2.07717e-05f
C231 S10_1 S15_6 1.8612e-05f
C232 S10_1 S16_6 1.1278e-05f
C233 S10_1 S36_5 2.20655e-05f
C234 S10_1 S37_5 2.59403e-05f
C235 S10_1 S38_5 4.4416e-05f
C236 S10_1 S39_5 4.95303e-05f
C237 S10_1 S40_5 0.000156214f
C238 S10_1 S41_6 8.29974e-05f
C239 S10_1 S42_6 4.82266e-05f
C240 S10_1 S43_6 3.58632e-05f
C241 S10_1 VDD 0.00422979f
C242 S10_1 VSS_0 0.0122353f
C243 S10_2 S11_6 0.0112803f
C244 S10_2 S12_6 0.000212956f
C245 S10_2 S13_6 0.000112331f
C246 S10_2 S14_6 4.68956e-05f
C247 S10_2 S15_6 4.20197e-05f
C248 S10_2 S16_6 2.5462e-05f
C249 S10_2 S17_6 1.27735e-05f
C250 S10_2 S19_6 1.9528e-05f
C251 S10_2 S34_5 1.48745e-05f
C252 S10_2 S35_5 1.90422e-05f
C253 S10_2 S36_5 4.98164e-05f
C254 S10_2 S37_5 5.85644e-05f
C255 S10_2 S38_5 0.000100276f
C256 S10_2 S39_5 0.000111823f
C257 S10_2 S40_5 0.000352679f
C258 S10_2 S41 0.00018738f
C259 S10_2 S42_6 0.000108879f
C260 S10_2 S43_6 8.0967e-05f
C261 S10_2 S49_6 1.44146e-05f
C262 S10_2 S50_6 1.57334e-05f
C263 S10_2 S9_1 0.00500144f
C264 S10_2 VDD 0.00954943f
C265 S10_2 VSS_0 0.0276231f
C266 S10_3 S11_6 0.0129902f
C267 S10_3 S12_6 0.000245237f
C268 S10_3 S13_6 0.000129359f
C269 S10_3 S14_6 5.40042e-05f
C270 S10_3 S15_6 4.83892e-05f
C271 S10_3 S16_6 2.93216e-05f
C272 S10_3 S17_6 1.47098e-05f
C273 S10_3 S19_6 2.24881e-05f
C274 S10_3 S34_5 1.71292e-05f
C275 S10_3 S35_5 2.19287e-05f
C276 S10_3 S36_5 5.73677e-05f
C277 S10_3 S37_5 6.74418e-05f
C278 S10_3 S38_5 0.000115477f
C279 S10_3 S39_5 0.000128773f
C280 S10_3 S40_5 0.000406139f
C281 S10_3 S41_6 0.000215784f
C282 S10_3 S42_6 0.000125384f
C283 S10_3 S43_6 9.32402e-05f
C284 S10_3 S49_6 1.65997e-05f
C285 S10_3 S50_6 1.81183e-05f
C286 S10_3 VDD 0.010997f
C287 S10_3 VSS_0 0.0318103f
C288 S10_4 S11_6 0.0051269f
C289 S10_4 S12_6 9.67885e-05f
C290 S10_4 S13_6 5.10546e-05f
C291 S10_4 S14_6 2.1314e-05f
C292 S10_4 S15_6 1.90979e-05f
C293 S10_4 S16_6 1.15725e-05f
C294 S10_4 S36_5 2.26415e-05f
C295 S10_4 S37_5 2.66175e-05f
C296 S10_4 S38_5 4.55756e-05f
C297 S10_4 S39_5 5.08234e-05f
C298 S10_4 S40_5 0.000160293f
C299 S10_4 S41_6 8.51642e-05f
C300 S10_4 S42_6 4.94856e-05f
C301 S10_4 S43_6 3.67995e-05f
C302 S10_4 VDD 0.00434021f
C303 S10_4 VSS_0 0.0125547f
C304 S10_5 S11_7 0.0051269f
C305 S10_5 S12_7 9.67885e-05f
C306 S10_5 S13_7 5.10546e-05f
C307 S10_5 S14_7 2.1314e-05f
C308 S10_5 S15_7 1.90979e-05f
C309 S10_5 S16_7 1.15725e-05f
C310 S10_5 S36_5 2.26415e-05f
C311 S10_5 S37_5 2.66175e-05f
C312 S10_5 S38_5 4.55756e-05f
C313 S10_5 S39_5 5.08234e-05f
C314 S10_5 S40_5 0.000160293f
C315 S10_5 S41_6 8.51642e-05f
C316 S10_5 S42_6 4.94856e-05f
C317 S10_5 S43_6 3.67995e-05f
C318 S10_5 VDD 0.00434021f
C319 S10_5 VSS_0 0.0125547f
C320 S10_6 S11_6 0.01114f
C321 S10_6 S12_6 0.000210306f
C322 S10_6 S13_6 0.000110934f
C323 S10_6 S14_6 4.6312e-05f
C324 S10_6 S15_6 4.14968e-05f
C325 S10_6 S16_6 2.51451e-05f
C326 S10_6 S17_6 1.26146e-05f
C327 S10_6 S19_6 1.9285e-05f
C328 S10_6 S1_2 1.8736e-05f
C329 S10_6 S1_3 2.15761e-05f
C330 S10_6 S1_6 1.85029e-05f
C331 S10_6 S34_5 1.46894e-05f
C332 S10_6 S35_5 1.88053e-05f
C333 S10_6 S36_5 4.91965e-05f
C334 S10_6 S37_5 5.78357e-05f
C335 S10_6 S38_5 9.90285e-05f
C336 S10_6 S39_5 0.000110431f
C337 S10_6 S40_5 0.000348291f
C338 S10_6 S41_5 0.000185048f
C339 S10_6 S42_6 0.000107525f
C340 S10_6 S43_6 7.99595e-05f
C341 S10_6 S49_6 1.42353e-05f
C342 S10_6 S50_6 1.55376e-05f
C343 S10_6 S6_2 1.29536e-05f
C344 S10_6 S6_3 1.49172e-05f
C345 S10_6 S6_6 1.27924e-05f
C346 S10_6 S7_1 1.44966e-05f
C347 S10_6 S7_2 3.27284e-05f
C348 S10_6 S7_3 3.76895e-05f
C349 S10_6 S7_4 1.48751e-05f
C350 S10_6 S7_6 3.23212e-05f
C351 S10_6 S8_1 5.39176e-05f
C352 S10_6 S8_2 0.000121728f
C353 S10_6 S8_3 0.00014018f
C354 S10_6 S8_4 5.53252e-05f
C355 S10_6 S8_6 0.000120213f
C356 S10_6 S9_2 0.0112916f
C357 S10_6 S9_3 0.0130032f
C358 S10_6 S9_4 0.00513201f
C359 S10_6 S9_6 0.0111511f
C360 S10_6 VDD 0.0094306f
C361 S10_6 VSS_0 0.0272794f
C362 S10_7 S11_7 0.01114f
C363 S10_7 S12_7 0.000210306f
C364 S10_7 S13_7 0.000110934f
C365 S10_7 S14_7 4.6312e-05f
C366 S10_7 S15_7 4.14968e-05f
C367 S10_7 S16_7 2.51451e-05f
C368 S10_7 S17_7 1.26146e-05f
C369 S10_7 S19_7 1.9285e-05f
C370 S10_7 S1_7 1.85029e-05f
C371 S10_7 S34_5 1.46894e-05f
C372 S10_7 S35_5 1.88053e-05f
C373 S10_7 S36_5 4.91965e-05f
C374 S10_7 S37_5 5.78357e-05f
C375 S10_7 S38_5 9.90285e-05f
C376 S10_7 S39_5 0.000110431f
C377 S10_7 S40_5 0.000348291f
C378 S10_7 S41_5 0.000185048f
C379 S10_7 S42_6 0.000107525f
C380 S10_7 S43_6 7.99595e-05f
C381 S10_7 S49_6 1.42353e-05f
C382 S10_7 S50_6 1.55376e-05f
C383 S10_7 S6 1.01109e-05f
C384 S10_7 S6_7 1.27924e-05f
C385 S10_7 S7 2.55459e-05f
C386 S10_7 S7_5 1.48751e-05f
C387 S10_7 S7_7 3.23212e-05f
C388 S10_7 S8 9.50137e-05f
C389 S10_7 S8_5 5.53252e-05f
C390 S10_7 S8_7 0.000120213f
C391 S10_7 S9 0.00881355f
C392 S10_7 S9_5 0.00513201f
C393 S10_7 S9_7 0.0111511f
C394 S10_7 VDD 0.0094306f
C395 S10_7 VSS_0 0.0272794f
C396 S11 S12_7 0.00883868f
C397 S11 S13_7 0.000125492f
C398 S11 S14_7 7.70488e-05f
C399 S11 S15_7 3.26904e-05f
C400 S11 S16_7 2.85324e-05f
C401 S11 S17_7 1.95647e-05f
C402 S11 S19_7 1.52794e-05f
C403 S11 S34_5 1.46379e-05f
C404 S11 S35_5 3.75107e-05f
C405 S11 S36_5 5.11855e-05f
C406 S11 S37_5 6.33493e-05f
C407 S11 S38_5 8.30711e-05f
C408 S11 S39_5 0.000274709f
C409 S11 S40_6 0.000190958f
C410 S11 S41_6 0.000136295f
C411 S11 S42_6 9.88106e-05f
C412 S11 S43_6 3.16478e-05f
C413 S11 S49_6 2.36972e-05f
C414 S11 S50_6 2.33971e-05f
C415 S11 VDD 0.00738666f
C416 S11 VSS_0 0.0216564f
C417 S11_1 S12_2 0.0050157f
C418 S11_1 S13_6 7.1213e-05f
C419 S11_1 S14_6 4.3723e-05f
C420 S11_1 S15_6 1.85509e-05f
C421 S11_1 S16_6 1.61913e-05f
C422 S11_1 S17_6 1.11024e-05f
C423 S11_1 S35_5 2.12863e-05f
C424 S11_1 S36_5 2.90464e-05f
C425 S11_1 S37_5 3.5949e-05f
C426 S11_1 S38_5 4.71405e-05f
C427 S11_1 S39_5 0.000155889f
C428 S11_1 S40_6 0.000108363f
C429 S11_1 S41_6 7.73436e-05f
C430 S11_1 S42_6 5.60722e-05f
C431 S11_1 S43_6 1.79592e-05f
C432 S11_1 S49_6 1.34475e-05f
C433 S11_1 S50_6 1.32772e-05f
C434 S11_1 VDD 0.00419172f
C435 S11_1 VSS_0 0.0122894f
C436 S11_2 S12_6 0.0113238f
C437 S11_2 S13_6 0.000160775f
C438 S11_2 S14_6 9.87118e-05f
C439 S11_2 S15_6 4.18816e-05f
C440 S11_2 S16_6 3.65545e-05f
C441 S11_2 S17_6 2.50655e-05f
C442 S11_2 S19_6 1.95753e-05f
C443 S11_2 S33_5 1.044e-05f
C444 S11_2 S34_5 1.87535e-05f
C445 S11_2 S35_5 4.80572e-05f
C446 S11_2 S36_5 6.55768e-05f
C447 S11_2 S37_5 8.11606e-05f
C448 S11_2 S38_5 0.000106427f
C449 S11_2 S39_5 0.000351946f
C450 S11_2 S40 0.000244648f
C451 S11_2 S41_6 0.000174616f
C452 S11_2 S42_6 0.000126592f
C453 S11_2 S43_6 4.05458e-05f
C454 S11_2 S48_6 1.14695e-05f
C455 S11_2 S49_6 3.03599e-05f
C456 S11_2 S50_6 2.99754e-05f
C457 S11_2 VDD 0.00946348f
C458 S11_2 VSS_0 0.0277453f
C459 S11_3 S12_6 0.0130403f
C460 S11_3 S13_6 0.000185146f
C461 S11_3 S14_6 0.000113675f
C462 S11_3 S15_6 4.82301e-05f
C463 S11_3 S16_6 4.20956e-05f
C464 S11_3 S17_6 2.8865e-05f
C465 S11_3 S19_6 2.25426e-05f
C466 S11_3 S33_5 1.20225e-05f
C467 S11_3 S34_5 2.15962e-05f
C468 S11_3 S35_5 5.53419e-05f
C469 S11_3 S36_5 7.55172e-05f
C470 S11_3 S37_5 9.34632e-05f
C471 S11_3 S38_5 0.00012256f
C472 S11_3 S39_5 0.000405295f
C473 S11_3 S40_6 0.000281733f
C474 S11_3 S41_6 0.000201085f
C475 S11_3 S42_6 0.000145781f
C476 S11_3 S43_6 4.66919e-05f
C477 S11_3 S48_6 1.32081e-05f
C478 S11_3 S49_6 3.4962e-05f
C479 S11_3 S50_6 3.45191e-05f
C480 S11_3 VDD 0.010898f
C481 S11_3 VSS_0 0.031951f
C482 S11_4 S12_6 0.00514665f
C483 S11_4 S13_6 7.30722e-05f
C484 S11_4 S14_6 4.48645e-05f
C485 S11_4 S15_6 1.90352e-05f
C486 S11_4 S16_6 1.6614e-05f
C487 S11_4 S17_6 1.13923e-05f
C488 S11_4 S35_5 2.1842e-05f
C489 S11_4 S36_5 2.98047e-05f
C490 S11_4 S37_5 3.68875e-05f
C491 S11_4 S38_5 4.83712e-05f
C492 S11_4 S39_5 0.000159959f
C493 S11_4 S40_6 0.000111192f
C494 S11_4 S41_6 7.93628e-05f
C495 S11_4 S42_6 5.75361e-05f
C496 S11_4 S43_6 1.84281e-05f
C497 S11_4 S49_6 1.37986e-05f
C498 S11_4 S50_6 1.36238e-05f
C499 S11_4 VDD 0.00430115f
C500 S11_4 VSS_0 0.0126102f
C501 S11_5 S12_7 0.00514665f
C502 S11_5 S13_7 7.30722e-05f
C503 S11_5 S14_7 4.48645e-05f
C504 S11_5 S15_7 1.90352e-05f
C505 S11_5 S16_7 1.6614e-05f
C506 S11_5 S17_7 1.13923e-05f
C507 S11_5 S35_5 2.1842e-05f
C508 S11_5 S36_5 2.98047e-05f
C509 S11_5 S37_5 3.68875e-05f
C510 S11_5 S38_5 4.83712e-05f
C511 S11_5 S39_5 0.000159959f
C512 S11_5 S40_6 0.000111192f
C513 S11_5 S41_6 7.93628e-05f
C514 S11_5 S42_6 5.75361e-05f
C515 S11_5 S43_6 1.84281e-05f
C516 S11_5 S49_6 1.37986e-05f
C517 S11_5 S50_6 1.36238e-05f
C518 S11_5 VDD 0.00430115f
C519 S11_5 VSS_0 0.0126102f
C520 S11_6 S12_6 0.0111829f
C521 S11_6 S13_6 0.000158774f
C522 S11_6 S14_6 9.74835e-05f
C523 S11_6 S15_6 4.13604e-05f
C524 S11_6 S16_6 3.60996e-05f
C525 S11_6 S17_6 2.47536e-05f
C526 S11_6 S19_6 1.93317e-05f
C527 S11_6 S1_1 1.36024e-05f
C528 S11_6 S1_2 3.07096e-05f
C529 S11_6 S1_3 3.53646e-05f
C530 S11_6 S1_4 1.39575e-05f
C531 S11_6 S1_6 3.03274e-05f
C532 S11_6 S2_2 2.18687e-05f
C533 S11_6 S2_3 2.51836e-05f
C534 S11_6 S2_6 2.15966e-05f
C535 S11_6 S33_5 1.03101e-05f
C536 S11_6 S34_5 1.85202e-05f
C537 S11_6 S35_5 4.74592e-05f
C538 S11_6 S36_5 6.47608e-05f
C539 S11_6 S37_5 8.01507e-05f
C540 S11_6 S38_5 0.000105103f
C541 S11_6 S39_5 0.000347566f
C542 S11_6 S40_5 0.000241604f
C543 S11_6 S41_6 0.000172443f
C544 S11_6 S42_6 0.000125017f
C545 S11_6 S43_6 4.00413e-05f
C546 S11_6 S48_6 1.13268e-05f
C547 S11_6 S49_6 2.99821e-05f
C548 S11_6 S50_6 2.96024e-05f
C549 S11_6 S6_1 1.44631e-05f
C550 S11_6 S6_2 3.26528e-05f
C551 S11_6 S6_3 3.76025e-05f
C552 S11_6 S6_4 1.48407e-05f
C553 S11_6 S6_6 3.22465e-05f
C554 S11_6 S8_1 3.30628e-05f
C555 S11_6 S8_2 7.46447e-05f
C556 S11_6 S8_3 8.59596e-05f
C557 S11_6 S8_4 3.3926e-05f
C558 S11_6 S8_6 7.37158e-05f
C559 S11_6 S9_1 7.18766e-05f
C560 S11_6 S9_2 0.000162273f
C561 S11_6 S9_3 0.000186871f
C562 S11_6 S9_4 7.3753e-05f
C563 S11_6 S9_6 0.000160254f
C564 S11_6 VDD 0.00934572f
C565 S11_6 VSS_0 0.0274f
C566 S11_7 S12_7 0.0111829f
C567 S11_7 S13_7 0.000158774f
C568 S11_7 S14_7 9.74835e-05f
C569 S11_7 S15_7 4.13604e-05f
C570 S11_7 S16_7 3.60996e-05f
C571 S11_7 S17_7 2.47536e-05f
C572 S11_7 S19_7 1.93317e-05f
C573 S11_7 S1_5 1.39575e-05f
C574 S11_7 S1_7 3.03274e-05f
C575 S11_7 S2 1.70695e-05f
C576 S11_7 S2_7 2.15966e-05f
C577 S11_7 S33_5 1.03101e-05f
C578 S11_7 S34_5 1.85202e-05f
C579 S11_7 S35_5 4.74592e-05f
C580 S11_7 S36_5 6.47608e-05f
C581 S11_7 S37_5 8.01507e-05f
C582 S11_7 S38_5 0.000105103f
C583 S11_7 S39_5 0.000347566f
C584 S11_7 S40_5 0.000241604f
C585 S11_7 S41_6 0.000172443f
C586 S11_7 S42_6 0.000125017f
C587 S11_7 S43_6 4.00413e-05f
C588 S11_7 S48_6 1.13268e-05f
C589 S11_7 S49_6 2.99821e-05f
C590 S11_7 S50_6 2.96024e-05f
C591 S11_7 S6 2.54869e-05f
C592 S11_7 S6_5 1.48407e-05f
C593 S11_7 S6_7 3.22465e-05f
C594 S11_7 S8 5.82634e-05f
C595 S11_7 S8_5 3.3926e-05f
C596 S11_7 S8_7 7.37158e-05f
C597 S11_7 S9 0.000126661f
C598 S11_7 S9_5 7.3753e-05f
C599 S11_7 S9_7 0.000160254f
C600 S11_7 VDD 0.00934572f
C601 S11_7 VSS_0 0.0274f
C602 S12 S13_7 0.00881492f
C603 S12 S14_7 0.000149004f
C604 S12 S15_7 6.16734e-05f
C605 S12 S16_7 4.20914e-05f
C606 S12 S17_7 3.8646e-05f
C607 S12 S18_7 1.01608e-05f
C608 S12 S19_7 1.51182e-05f
C609 S12 S34_5 3.9702e-05f
C610 S12 S35_5 4.52727e-05f
C611 S12 S36_5 7.80492e-05f
C612 S12 S37_5 6.43223e-05f
C613 S12 S38_5 0.000254113f
C614 S12 S39_6 0.00016727f
C615 S12 S40_6 0.000139101f
C616 S12 S41_6 0.000138851f
C617 S12 S42_6 7.21151e-05f
C618 S12 S43_6 2.03618e-05f
C619 S12 S48_6 1.31293e-05f
C620 S12 S49_6 2.82401e-05f
C621 S12 S50_6 2.56366e-05f
C622 S12 VDD 0.00731835f
C623 S12 VSS_0 0.0217334f
C624 S12_1 S13_2 0.00500222f
C625 S12_1 S14_6 8.45553e-05f
C626 S12_1 S15_6 3.49979e-05f
C627 S12_1 S16_6 2.38857e-05f
C628 S12_1 S17_6 2.19305e-05f
C629 S12_1 S34_5 2.25298e-05f
C630 S12_1 S35_5 2.5691e-05f
C631 S12_1 S36_5 4.42907e-05f
C632 S12_1 S37_5 3.65011e-05f
C633 S12_1 S38_5 0.000144202f
C634 S12_1 S39_6 9.49211e-05f
C635 S12_1 S40_6 7.89362e-05f
C636 S12_1 S41_6 7.87939e-05f
C637 S12_1 S42_6 4.09233e-05f
C638 S12_1 S43_6 1.15547e-05f
C639 S12_1 S49_6 1.60255e-05f
C640 S12_1 S50_6 1.45481e-05f
C641 S12_1 VDD 0.00415296f
C642 S12_1 VSS_0 0.0123331f
C643 S12_2 S13_6 0.0112933f
C644 S12_2 S14_6 0.000190897f
C645 S12_2 S15_6 7.90134e-05f
C646 S12_2 S16_6 5.39258e-05f
C647 S12_2 S17_6 4.95117e-05f
C648 S12_2 S18_6 1.30176e-05f
C649 S12_2 S19_6 1.93688e-05f
C650 S12_2 S26_5 1.12952e-05f
C651 S12_2 S34_5 5.08646e-05f
C652 S12_2 S35_5 5.80015e-05f
C653 S12_2 S36_5 9.99934e-05f
C654 S12_2 S37_5 8.24072e-05f
C655 S12_2 S38_5 0.00032556f
C656 S12_2 S39 0.0002143f
C657 S12_2 S40_6 0.000178211f
C658 S12_2 S41_6 0.00017789f
C659 S12_2 S42_6 9.2391e-05f
C660 S12_2 S43_6 2.60867e-05f
C661 S12_2 S48_6 1.68207e-05f
C662 S12_2 S49_6 3.61801e-05f
C663 S12_2 S50_6 3.28446e-05f
C664 S12_2 VDD 0.00937597f
C665 S12_2 VSS_0 0.0278439f
C666 S12_3 S13_6 0.0130052f
C667 S12_3 S14_6 0.000219834f
C668 S12_3 S15_6 9.09906e-05f
C669 S12_3 S16_6 6.21001e-05f
C670 S12_3 S17_6 5.70169e-05f
C671 S12_3 S18_6 1.49908e-05f
C672 S12_3 S19_6 2.23048e-05f
C673 S12_3 S26_5 1.30074e-05f
C674 S12_3 S33_5 1.00442e-05f
C675 S12_3 S34_5 5.85749e-05f
C676 S12_3 S35_5 6.67936e-05f
C677 S12_3 S36_5 0.000115151f
C678 S12_3 S37_5 9.48988e-05f
C679 S12_3 S38_5 0.000374909f
C680 S12_3 S39_6 0.000246784f
C681 S12_3 S40_6 0.000205225f
C682 S12_3 S41_6 0.000204855f
C683 S12_3 S42_6 0.000106396f
C684 S12_3 S43_6 3.0041e-05f
C685 S12_3 S48_6 1.93705e-05f
C686 S12_3 S49_6 4.16644e-05f
C687 S12_3 S50_6 3.78233e-05f
C688 S12_3 VDD 0.0107972f
C689 S12_3 VSS_0 0.0320646f
C690 S12_4 S13_6 0.00513281f
C691 S12_4 S14_6 8.67628e-05f
C692 S12_4 S15_6 3.59116e-05f
C693 S12_4 S16_6 2.45093e-05f
C694 S12_4 S17_6 2.25031e-05f
C695 S12_4 S34_5 2.3118e-05f
C696 S12_4 S35_5 2.63617e-05f
C697 S12_4 S36_5 4.5447e-05f
C698 S12_4 S37_5 3.7454e-05f
C699 S12_4 S38_5 0.000147967f
C700 S12_4 S39_6 9.73992e-05f
C701 S12_4 S40_6 8.09969e-05f
C702 S12_4 S41_6 8.0851e-05f
C703 S12_4 S42_6 4.19917e-05f
C704 S12_4 S43_6 1.18564e-05f
C705 S12_4 S49_6 1.64438e-05f
C706 S12_4 S50_6 1.49279e-05f
C707 S12_4 VDD 0.00426138f
C708 S12_4 VSS_0 0.012655f
C709 S12_5 S13_7 0.00513281f
C710 S12_5 S14_7 8.67628e-05f
C711 S12_5 S15_7 3.59116e-05f
C712 S12_5 S16_7 2.45093e-05f
C713 S12_5 S17_7 2.25031e-05f
C714 S12_5 S34_5 2.3118e-05f
C715 S12_5 S35_5 2.63617e-05f
C716 S12_5 S36_5 4.5447e-05f
C717 S12_5 S37_5 3.7454e-05f
C718 S12_5 S38_5 0.000147967f
C719 S12_5 S39_6 9.73992e-05f
C720 S12_5 S40_6 8.09969e-05f
C721 S12_5 S41_6 8.0851e-05f
C722 S12_5 S42_6 4.19917e-05f
C723 S12_5 S43_6 1.18564e-05f
C724 S12_5 S49_6 1.64438e-05f
C725 S12_5 S50_6 1.49279e-05f
C726 S12_5 VDD 0.00426138f
C727 S12_5 VSS_0 0.012655f
C728 S12_6 S13_6 0.0111528f
C729 S12_6 S14_6 0.000188522f
C730 S12_6 S15_6 7.80302e-05f
C731 S12_6 S16_6 5.32548e-05f
C732 S12_6 S17_6 4.88956e-05f
C733 S12_6 S18_6 1.28556e-05f
C734 S12_6 S19_6 1.91278e-05f
C735 S12_6 S1_1 1.55981e-05f
C736 S12_6 S1_2 3.52152e-05f
C737 S12_6 S1_3 4.05532e-05f
C738 S12_6 S1_4 1.60053e-05f
C739 S12_6 S1_6 3.4777e-05f
C740 S12_6 S26_5 1.11547e-05f
C741 S12_6 S2_1 1.02123e-05f
C742 S12_6 S2_2 2.3056e-05f
C743 S12_6 S2_3 2.65509e-05f
C744 S12_6 S2_4 1.04789e-05f
C745 S12_6 S2_6 2.27691e-05f
C746 S12_6 S34_5 5.02317e-05f
C747 S12_6 S35_5 5.72798e-05f
C748 S12_6 S36_5 9.87492e-05f
C749 S12_6 S37_5 8.13818e-05f
C750 S12_6 S38_5 0.000321509f
C751 S12_6 S39_5 0.000211633f
C752 S12_6 S40_6 0.000175994f
C753 S12_6 S41_6 0.000175676f
C754 S12_6 S42_6 9.12413e-05f
C755 S12_6 S43_6 2.57621e-05f
C756 S12_6 S48_6 1.66114e-05f
C757 S12_6 S49_6 3.57299e-05f
C758 S12_6 S50_6 3.24359e-05f
C759 S12_6 S6_2 1.19349e-05f
C760 S12_6 S6_3 1.37441e-05f
C761 S12_6 S6_6 1.17864e-05f
C762 S12_6 S8_1 1.8164e-05f
C763 S12_6 S8_2 4.10081e-05f
C764 S12_6 S8_3 4.72243e-05f
C765 S12_6 S8_4 1.86382e-05f
C766 S12_6 S8_6 4.04978e-05f
C767 S12_6 S9_1 4.98886e-05f
C768 S12_6 S9_2 0.000112632f
C769 S12_6 S9_3 0.000129705f
C770 S12_6 S9_4 5.1191e-05f
C771 S12_6 S9_6 0.00011123f
C772 S12_6 VDD 0.0092593f
C773 S12_6 VSS_0 0.0274974f
C774 S12_7 S13_7 0.0111528f
C775 S12_7 S14_7 0.000188522f
C776 S12_7 S15_7 7.80302e-05f
C777 S12_7 S16_7 5.32548e-05f
C778 S12_7 S17_7 4.88956e-05f
C779 S12_7 S18_7 1.28556e-05f
C780 S12_7 S19_7 1.91278e-05f
C781 S12_7 S1_5 1.60053e-05f
C782 S12_7 S1_7 3.4777e-05f
C783 S12_7 S2 1.79962e-05f
C784 S12_7 S26_5 1.11547e-05f
C785 S12_7 S2_5 1.04789e-05f
C786 S12_7 S2_7 2.27691e-05f
C787 S12_7 S34_5 5.02317e-05f
C788 S12_7 S35_5 5.72798e-05f
C789 S12_7 S36_5 9.87492e-05f
C790 S12_7 S37_5 8.13818e-05f
C791 S12_7 S38_5 0.000321509f
C792 S12_7 S39_5 0.000211633f
C793 S12_7 S40_6 0.000175994f
C794 S12_7 S41_6 0.000175676f
C795 S12_7 S42_6 9.12413e-05f
C796 S12_7 S43_6 2.57621e-05f
C797 S12_7 S48_6 1.66114e-05f
C798 S12_7 S49_6 3.57299e-05f
C799 S12_7 S50_6 3.24359e-05f
C800 S12_7 S6_7 1.17864e-05f
C801 S12_7 S8 3.20086e-05f
C802 S12_7 S8_5 1.86382e-05f
C803 S12_7 S8_7 4.04978e-05f
C804 S12_7 S9 8.79137e-05f
C805 S12_7 S9_5 5.1191e-05f
C806 S12_7 S9_7 0.00011123f
C807 S12_7 VDD 0.0092593f
C808 S12_7 VSS_0 0.0274974f
C809 S13 S14_7 0.0088431f
C810 S13 S15_7 0.000154754f
C811 S13 S16_7 9.81299e-05f
C812 S13 S17_7 5.65764e-05f
C813 S13 S18_7 1.69138e-05f
C814 S13 S19_7 1.08002e-05f
C815 S13 S23_7 1.52646e-05f
C816 S13 S24_7 2.36127e-05f
C817 S13 S25_7 1.90567e-05f
C818 S13 S26_5 2.31435e-05f
C819 S13 S27_5 2.06982e-05f
C820 S13 S28_5 1.4448e-05f
C821 S13 S33_5 1.47946e-05f
C822 S13 S34_5 6.43487e-05f
C823 S13 S35_5 9.61555e-05f
C824 S13 S36_5 0.000105406f
C825 S13 S37_5 0.000280175f
C826 S13 S38_6 0.000174117f
C827 S13 S39_6 0.000117963f
C828 S13 S40_6 0.000114775f
C829 S13 S41_6 7.89856e-05f
C830 S13 S42_6 3.63597e-05f
C831 S13 S43_6 1.60944e-05f
C832 S13 VDD 0.00709504f
C833 S13 VSS_0 0.0217473f
C834 S13_1 S14_2 0.00501821f
C835 S13_1 S15_6 8.78187e-05f
C836 S13_1 S16_6 5.5686e-05f
C837 S13_1 S17_6 3.21055e-05f
C838 S13_1 S24_6 1.33995e-05f
C839 S13_1 S25_6 1.08141e-05f
C840 S13_1 S26_5 1.31333e-05f
C841 S13_1 S27_5 1.17456e-05f
C842 S13_1 S34_5 3.65161e-05f
C843 S13_1 S35_5 5.45656e-05f
C844 S13_1 S36_5 5.98149e-05f
C845 S13_1 S37_5 0.000158991f
C846 S13_1 S38_6 9.88065e-05f
C847 S13_1 S39_6 6.69406e-05f
C848 S13_1 S40_6 6.51318e-05f
C849 S13_1 S41_6 4.48221e-05f
C850 S13_1 S42_6 2.06331e-05f
C851 S13_1 VDD 0.00402623f
C852 S13_1 VSS_0 0.012341f
C853 S13_2 S14_6 0.0113294f
C854 S13_2 S15_6 0.000198265f
C855 S13_2 S16_6 0.00012572f
C856 S13_2 S17_6 7.24833e-05f
C857 S13_2 S18_6 2.16693e-05f
C858 S13_2 S19_6 1.38368e-05f
C859 S13_2 S23_6 1.95564e-05f
C860 S13_2 S24_6 3.02516e-05f
C861 S13_2 S25_6 2.44146e-05f
C862 S13_2 S26_5 2.96506e-05f
C863 S13_2 S27_5 2.65176e-05f
C864 S13_2 S28_5 1.85102e-05f
C865 S13_2 S33_5 1.89542e-05f
C866 S13_2 S34_5 8.2441e-05f
C867 S13_2 S35_5 0.000123191f
C868 S13_2 S36_5 0.000135042f
C869 S13_2 S37_5 0.000358948f
C870 S13_2 S38 0.000223072f
C871 S13_2 S39_6 0.000151129f
C872 S13_2 S40_6 0.000147046f
C873 S13_2 S41_6 0.000101193f
C874 S13_2 S42_6 4.65826e-05f
C875 S13_2 S43_6 2.06195e-05f
C876 S13_2 VDD 0.00908987f
C877 S13_2 VSS_0 0.0278617f
C878 S13_3 S14_6 0.0130468f
C879 S13_3 S15_6 0.000228319f
C880 S13_3 S16_6 0.000144777f
C881 S13_3 S17_6 8.34706e-05f
C882 S13_3 S18_6 2.4954e-05f
C883 S13_3 S19_6 1.59343e-05f
C884 S13_3 S23_6 2.25208e-05f
C885 S13_3 S24_6 3.48372e-05f
C886 S13_3 S25_6 2.81155e-05f
C887 S13_3 S26_5 3.41451e-05f
C888 S13_3 S27_5 3.05373e-05f
C889 S13_3 S28_5 2.1316e-05f
C890 S13_3 S33_5 2.18273e-05f
C891 S13_3 S34_5 9.49377e-05f
C892 S13_3 S35_5 0.000141864f
C893 S13_3 S36_5 0.000155512f
C894 S13_3 S37_5 0.000413359f
C895 S13_3 S38_6 0.000256886f
C896 S13_3 S39_6 0.000174038f
C897 S13_3 S40_6 0.000169335f
C898 S13_3 S41_6 0.000116532f
C899 S13_3 S42_6 5.36437e-05f
C900 S13_3 S43_6 2.37451e-05f
C901 S13_3 VDD 0.0104677f
C902 S13_3 VSS_0 0.0320851f
C903 S13_4 S14_6 0.00514922f
C904 S13_4 S15_6 9.01114e-05f
C905 S13_4 S16_6 5.71397e-05f
C906 S13_4 S17_6 3.29437e-05f
C907 S13_4 S24_6 1.37493e-05f
C908 S13_4 S25_6 1.10964e-05f
C909 S13_4 S26_5 1.34762e-05f
C910 S13_4 S27_5 1.20523e-05f
C911 S13_4 S34_5 3.74694e-05f
C912 S13_4 S35_5 5.59901e-05f
C913 S13_4 S36_5 6.13765e-05f
C914 S13_4 S37_5 0.000163142f
C915 S13_4 S38_6 0.000101386f
C916 S13_4 S39_6 6.86882e-05f
C917 S13_4 S40_6 6.68322e-05f
C918 S13_4 S41_6 4.59922e-05f
C919 S13_4 S42_6 2.11718e-05f
C920 S13_4 VDD 0.00413134f
C921 S13_4 VSS_0 0.0126632f
C922 S13_5 S14_7 0.00514922f
C923 S13_5 S15_7 9.01114e-05f
C924 S13_5 S16_7 5.71397e-05f
C925 S13_5 S17_7 3.29437e-05f
C926 S13_5 S24_7 1.37493e-05f
C927 S13_5 S25_7 1.10964e-05f
C928 S13_5 S26_5 1.34762e-05f
C929 S13_5 S27_5 1.20523e-05f
C930 S13_5 S34_5 3.74694e-05f
C931 S13_5 S35_5 5.59901e-05f
C932 S13_5 S36_5 6.13765e-05f
C933 S13_5 S37_5 0.000163142f
C934 S13_5 S38_6 0.000101386f
C935 S13_5 S39_6 6.86882e-05f
C936 S13_5 S40_6 6.68322e-05f
C937 S13_5 S41_6 4.59922e-05f
C938 S13_5 S42_6 2.11718e-05f
C939 S13_5 VDD 0.00413134f
C940 S13_5 VSS_0 0.0126632f
C941 S13_6 S14_6 0.0111884f
C942 S13_6 S15_6 0.000195798f
C943 S13_6 S16_6 0.000124156f
C944 S13_6 S17_6 7.15814e-05f
C945 S13_6 S18_6 2.13997e-05f
C946 S13_6 S19_6 1.36647e-05f
C947 S13_6 S23_6 1.93131e-05f
C948 S13_6 S24_6 2.98752e-05f
C949 S13_6 S25_6 2.41108e-05f
C950 S13_6 S26_5 2.92816e-05f
C951 S13_6 S27_5 2.61877e-05f
C952 S13_6 S28_5 1.82798e-05f
C953 S13_6 S33_5 1.87183e-05f
C954 S13_6 S34_5 8.14151e-05f
C955 S13_6 S35_5 0.000121658f
C956 S13_6 S36_5 0.000133362f
C957 S13_6 S37_5 0.000354482f
C958 S13_6 S38_5 0.000220296f
C959 S13_6 S39_6 0.000149249f
C960 S13_6 S40_6 0.000145216f
C961 S13_6 S41_6 9.99339e-05f
C962 S13_6 S42_6 4.60029e-05f
C963 S13_6 S43_6 2.03629e-05f
C964 S13_6 S8_1 1.63689e-05f
C965 S13_6 S8_2 3.69553e-05f
C966 S13_6 S8_3 4.25572e-05f
C967 S13_6 S8_4 1.67962e-05f
C968 S13_6 S8_6 3.64955e-05f
C969 S13_6 S9_1 2.35414e-05f
C970 S13_6 S9_2 5.31485e-05f
C971 S13_6 S9_3 6.1205e-05f
C972 S13_6 S9_4 2.4156e-05f
C973 S13_6 S9_6 5.24872e-05f
C974 S13_6 VDD 0.00897676f
C975 S13_6 VSS_0 0.0275151f
C976 S13_7 S14_7 0.0111884f
C977 S13_7 S15_7 0.000195798f
C978 S13_7 S16_7 0.000124156f
C979 S13_7 S17_7 7.15814e-05f
C980 S13_7 S18_7 2.13997e-05f
C981 S13_7 S19_7 1.36647e-05f
C982 S13_7 S23_7 1.93131e-05f
C983 S13_7 S24_7 2.98752e-05f
C984 S13_7 S25_7 2.41108e-05f
C985 S13_7 S26_5 2.92816e-05f
C986 S13_7 S27_5 2.61877e-05f
C987 S13_7 S28_5 1.82798e-05f
C988 S13_7 S33_5 1.87183e-05f
C989 S13_7 S34_5 8.14151e-05f
C990 S13_7 S35_5 0.000121658f
C991 S13_7 S36_5 0.000133362f
C992 S13_7 S37_5 0.000354482f
C993 S13_7 S38_5 0.000220296f
C994 S13_7 S39_6 0.000149249f
C995 S13_7 S40_6 0.000145216f
C996 S13_7 S41_6 9.99339e-05f
C997 S13_7 S42_6 4.60029e-05f
C998 S13_7 S43_6 2.03629e-05f
C999 S13_7 S8 2.88452e-05f
C1000 S13_7 S8_5 1.67962e-05f
C1001 S13_7 S8_7 3.64955e-05f
C1002 S13_7 S9 4.14847e-05f
C1003 S13_7 S9_5 2.4156e-05f
C1004 S13_7 S9_7 5.24872e-05f
C1005 S13_7 VDD 0.00897676f
C1006 S13_7 VSS_0 0.0275151f
C1007 S14 S15_7 0.00885058f
C1008 S14 S16_7 0.000147919f
C1009 S14 S17_7 7.99661e-05f
C1010 S14 S18_7 3.2904e-05f
C1011 S14 S23_7 2.05337e-05f
C1012 S14 S24_7 3.17457e-05f
C1013 S14 S25_7 2.60169e-05f
C1014 S14 S26_5 2.87692e-05f
C1015 S14 S27_5 2.6454e-05f
C1016 S14 S28_5 1.76953e-05f
C1017 S14 S33_5 1.0354e-05f
C1018 S14 S34_5 9.04696e-05f
C1019 S14 S35_5 7.88642e-05f
C1020 S14 S36_5 0.000280415f
C1021 S14 S37_6 0.00017905f
C1022 S14 S38_6 0.000130104f
C1023 S14 S39_6 0.000105373f
C1024 S14 S40_6 6.06844e-05f
C1025 S14 S41_6 3.32479e-05f
C1026 S14 S42_6 2.28418e-05f
C1027 S14 S43_6 1.07258e-05f
C1028 S14 VDD 0.00732352f
C1029 S14 VSS_0 0.021624f
C1030 S14_1 S15_2 0.00502245f
C1031 S14_1 S16_6 8.39397e-05f
C1032 S14_1 S17_6 4.53785e-05f
C1033 S14_1 S18_6 1.86721e-05f
C1034 S14_1 S23_6 1.16523e-05f
C1035 S14_1 S24_6 1.80148e-05f
C1036 S14_1 S25_6 1.47639e-05f
C1037 S14_1 S26_5 1.63257e-05f
C1038 S14_1 S27_5 1.50119e-05f
C1039 S14_1 S28_5 1.00416e-05f
C1040 S14_1 S34_5 5.1339e-05f
C1041 S14_1 S35_5 4.47532e-05f
C1042 S14_1 S36_5 0.000159128f
C1043 S14_1 S37_6 0.000101606f
C1044 S14_1 S38_6 7.38304e-05f
C1045 S14_1 S39_6 5.97965e-05f
C1046 S14_1 S40_6 3.44367e-05f
C1047 S14_1 S41_6 1.88672e-05f
C1048 S14_1 S42_6 1.29621e-05f
C1049 S14_1 VDD 0.00415589f
C1050 S14_1 VSS_0 0.012271f
C1051 S14_2 S15_6 0.011339f
C1052 S14_2 S16_6 0.000189507f
C1053 S14_2 S17_6 0.000102449f
C1054 S14_2 S18_6 4.21552e-05f
C1055 S14_2 S23_6 2.6307e-05f
C1056 S14_2 S24_6 4.06713e-05f
C1057 S14_2 S25_6 3.33318e-05f
C1058 S14_2 S26_5 3.68579e-05f
C1059 S14_2 S27_5 3.38918e-05f
C1060 S14_2 S28_5 2.26704e-05f
C1061 S14_2 S33_5 1.32651e-05f
C1062 S14_2 S34_5 0.000115906f
C1063 S14_2 S35_5 0.000101038f
C1064 S14_2 S36_5 0.000359257f
C1065 S14_2 S37 0.000229391f
C1066 S14_2 S38_6 0.000166684f
C1067 S14_2 S39_6 0.000135f
C1068 S14_2 S40_6 7.77463e-05f
C1069 S14_2 S41_6 4.25959e-05f
C1070 S14_2 S42_6 2.9264e-05f
C1071 S14_2 S43_6 1.37415e-05f
C1072 S14_2 VDD 0.00938259f
C1073 S14_2 VSS_0 0.0277038f
C1074 S14_3 S15_6 0.0130578f
C1075 S14_3 S16_6 0.000218234f
C1076 S14_3 S17_6 0.000117979f
C1077 S14_3 S18_6 4.85453e-05f
C1078 S14_3 S23_6 3.02947e-05f
C1079 S14_3 S24_6 4.68364e-05f
C1080 S14_3 S25_6 3.83843e-05f
C1081 S14_3 S26_5 4.24449e-05f
C1082 S14_3 S27_5 3.90292e-05f
C1083 S14_3 S28_5 2.61069e-05f
C1084 S14_3 S33_5 1.52759e-05f
C1085 S14_3 S34_5 0.000133475f
C1086 S14_3 S35_5 0.000116353f
C1087 S14_3 S36_5 0.000413714f
C1088 S14_3 S37_6 0.000264163f
C1089 S14_3 S38_6 0.000191951f
C1090 S14_3 S39_6 0.000155464f
C1091 S14_3 S40_6 8.95314e-05f
C1092 S14_3 S41_6 4.90527e-05f
C1093 S14_3 S42_6 3.36999e-05f
C1094 S14_3 S43_6 1.58244e-05f
C1095 S14_3 VDD 0.0108048f
C1096 S14_3 VSS_0 0.0319032f
C1097 S14_4 S15_6 0.00515357f
C1098 S14_4 S16_6 8.61311e-05f
C1099 S14_4 S17_6 4.65632e-05f
C1100 S14_4 S18_6 1.91595e-05f
C1101 S14_4 S23_6 1.19565e-05f
C1102 S14_4 S24_6 1.84851e-05f
C1103 S14_4 S25_6 1.51493e-05f
C1104 S14_4 S26_5 1.67519e-05f
C1105 S14_4 S27_5 1.54038e-05f
C1106 S14_4 S28_5 1.03037e-05f
C1107 S14_4 S34_5 5.26792e-05f
C1108 S14_4 S35_5 4.59216e-05f
C1109 S14_4 S36_5 0.000163282f
C1110 S14_4 S37_6 0.000104258f
C1111 S14_4 S38_6 7.57579e-05f
C1112 S14_4 S39_6 6.13576e-05f
C1113 S14_4 S40_6 3.53357e-05f
C1114 S14_4 S41_6 1.93598e-05f
C1115 S14_4 S42_6 1.33005e-05f
C1116 S14_4 VDD 0.00426439f
C1117 S14_4 VSS_0 0.0125914f
C1118 S14_5 S15_7 0.00515357f
C1119 S14_5 S16_7 8.61311e-05f
C1120 S14_5 S17_7 4.65632e-05f
C1121 S14_5 S18_7 1.91595e-05f
C1122 S14_5 S23_7 1.19565e-05f
C1123 S14_5 S24_7 1.84851e-05f
C1124 S14_5 S25_7 1.51493e-05f
C1125 S14_5 S26_5 1.67519e-05f
C1126 S14_5 S27_5 1.54038e-05f
C1127 S14_5 S28_5 1.03037e-05f
C1128 S14_5 S34_5 5.26792e-05f
C1129 S14_5 S35_5 4.59216e-05f
C1130 S14_5 S36_5 0.000163282f
C1131 S14_5 S37_6 0.000104258f
C1132 S14_5 S38_6 7.57579e-05f
C1133 S14_5 S39_6 6.13576e-05f
C1134 S14_5 S40_6 3.53357e-05f
C1135 S14_5 S41_6 1.93598e-05f
C1136 S14_5 S42_6 1.33005e-05f
C1137 S14_5 VDD 0.00426439f
C1138 S14_5 VSS_0 0.0125914f
C1139 S14_6 S15_6 0.0111979f
C1140 S14_6 S16_6 0.000187149f
C1141 S14_6 S17_6 0.000101174f
C1142 S14_6 S18_6 4.16307e-05f
C1143 S14_6 S23_6 2.59796e-05f
C1144 S14_6 S24_6 4.01652e-05f
C1145 S14_6 S25_6 3.2917e-05f
C1146 S14_6 S26_5 3.63993e-05f
C1147 S14_6 S27_5 3.347e-05f
C1148 S14_6 S28_5 2.23883e-05f
C1149 S14_6 S33_5 1.31e-05f
C1150 S14_6 S34_5 0.000114464f
C1151 S14_6 S35_5 9.97803e-05f
C1152 S14_6 S36_5 0.000354786f
C1153 S14_6 S37_5 0.000226537f
C1154 S14_6 S38_6 0.00016461f
C1155 S14_6 S39_6 0.00013332f
C1156 S14_6 S40_6 7.67789e-05f
C1157 S14_6 S41_6 4.20658e-05f
C1158 S14_6 S42_6 2.88999e-05f
C1159 S14_6 S43_6 1.35705e-05f
C1160 S14_6 S7_2 1.13891e-05f
C1161 S14_6 S7_3 1.31155e-05f
C1162 S14_6 S7_6 1.12474e-05f
C1163 S14_6 S8_1 1.02901e-05f
C1164 S14_6 S8_2 2.32316e-05f
C1165 S14_6 S8_3 2.67531e-05f
C1166 S14_6 S8_4 1.05587e-05f
C1167 S14_6 S8_6 2.29425e-05f
C1168 S14_6 S9_1 1.71445e-05f
C1169 S14_6 S9_2 3.87065e-05f
C1170 S14_6 S9_3 4.45738e-05f
C1171 S14_6 S9_4 1.75921e-05f
C1172 S14_6 S9_6 3.82249e-05f
C1173 S14_6 VDD 0.00926584f
C1174 S14_6 VSS_0 0.0273591f
C1175 S14_7 S15_7 0.0111979f
C1176 S14_7 S16_7 0.000187149f
C1177 S14_7 S17_7 0.000101174f
C1178 S14_7 S18_7 4.16307e-05f
C1179 S14_7 S23_7 2.59796e-05f
C1180 S14_7 S24_7 4.01652e-05f
C1181 S14_7 S25_7 3.2917e-05f
C1182 S14_7 S26_5 3.63993e-05f
C1183 S14_7 S27_5 3.347e-05f
C1184 S14_7 S28_5 2.23883e-05f
C1185 S14_7 S33_5 1.31e-05f
C1186 S14_7 S34_5 0.000114464f
C1187 S14_7 S35_5 9.97803e-05f
C1188 S14_7 S36_5 0.000354786f
C1189 S14_7 S37_5 0.000226537f
C1190 S14_7 S38_6 0.00016461f
C1191 S14_7 S39_6 0.00013332f
C1192 S14_7 S40_6 7.67789e-05f
C1193 S14_7 S41_6 4.20658e-05f
C1194 S14_7 S42_6 2.88999e-05f
C1195 S14_7 S43_6 1.35705e-05f
C1196 S14_7 S7_7 1.12474e-05f
C1197 S14_7 S8 1.81332e-05f
C1198 S14_7 S8_5 1.05587e-05f
C1199 S14_7 S8_7 2.29425e-05f
C1200 S14_7 S9 3.02121e-05f
C1201 S14_7 S9_5 1.75921e-05f
C1202 S14_7 S9_7 3.82249e-05f
C1203 S14_7 VDD 0.00926584f
C1204 S14_7 VSS_0 0.0273591f
C1205 S15 S16_7 0.00885169f
C1206 S15 S17_7 8.83357e-05f
C1207 S15 S18_7 2.68847e-05f
C1208 S15 S19_7 1.50187e-05f
C1209 S15 S23_7 1.2591e-05f
C1210 S15 S24_7 2.29386e-05f
C1211 S15 S25_7 2.2372e-05f
C1212 S15 S26_5 2.61115e-05f
C1213 S15 S27_5 1.6446e-05f
C1214 S15 S33_5 2.3977e-05f
C1215 S15 S34_5 7.59287e-05f
C1216 S15 S35_5 0.000259747f
C1217 S15 S36_6 0.000181729f
C1218 S15 S37_6 0.000142516f
C1219 S15 S38_6 0.000133133f
C1220 S15 S39_6 6.8368e-05f
C1221 S15 S40_6 3.19693e-05f
C1222 S15 S41_6 2.65291e-05f
C1223 S15 S42_6 1.74866e-05f
C1224 S15 VDD 0.00737957f
C1225 S15 VSS_0 0.0215318f
C1226 S15_1 S16_2 0.00502308f
C1227 S15_1 S17_6 5.0128e-05f
C1228 S15_1 S18_6 1.52563e-05f
C1229 S15_1 S24_6 1.3017e-05f
C1230 S15_1 S25_6 1.26955e-05f
C1231 S15_1 S26_5 1.48176e-05f
C1232 S15_1 S33_5 1.36063e-05f
C1233 S15_1 S34_5 4.30874e-05f
C1234 S15_1 S35_5 0.000147399f
C1235 S15_1 S36_6 0.000103126f
C1236 S15_1 S37_6 8.08741e-05f
C1237 S15_1 S38_6 7.55493e-05f
C1238 S15_1 S39_6 3.87969e-05f
C1239 S15_1 S40_6 1.81417e-05f
C1240 S15_1 S41_6 1.50545e-05f
C1241 S15_1 VDD 0.0041877f
C1242 S15_1 VSS_0 0.0122187f
C1243 S15_2 S16_6 0.0113404f
C1244 S15_2 S17_6 0.000113172f
C1245 S15_2 S18_6 3.44436e-05f
C1246 S15_2 S19_6 1.92413e-05f
C1247 S15_2 S23_6 1.61311e-05f
C1248 S15_2 S24_6 2.93881e-05f
C1249 S15_2 S25_6 2.86621e-05f
C1250 S15_2 S26_5 3.3453e-05f
C1251 S15_2 S27_5 2.10699e-05f
C1252 S15_2 S33_5 3.07183e-05f
C1253 S15_2 S34_5 9.72768e-05f
C1254 S15_2 S35_5 0.000332777f
C1255 S15_2 S36 0.000232824f
C1256 S15_2 S37_6 0.000182586f
C1257 S15_2 S38_6 0.000170565f
C1258 S15_2 S39_6 8.75903e-05f
C1259 S15_2 S40_6 4.09577e-05f
C1260 S15_2 S41_6 3.39879e-05f
C1261 S15_2 S42_6 2.24031e-05f
C1262 S15_2 S43_6 1.16114e-05f
C1263 S15_2 VDD 0.0094544f
C1264 S15_2 VSS_0 0.0275857f
C1265 S15_3 S16_6 0.0130594f
C1266 S15_3 S17_6 0.000130327f
C1267 S15_3 S18_6 3.96647e-05f
C1268 S15_3 S19_6 2.2158e-05f
C1269 S15_3 S23_6 1.85763e-05f
C1270 S15_3 S24_6 3.38428e-05f
C1271 S15_3 S25_6 3.30068e-05f
C1272 S15_3 S26_5 3.8524e-05f
C1273 S15_3 S27_5 2.42638e-05f
C1274 S15_3 S28_5 1.13581e-05f
C1275 S15_3 S33_5 3.53747e-05f
C1276 S15_3 S34_5 0.000112022f
C1277 S15_3 S35_5 0.000383221f
C1278 S15_3 S36_6 0.000268116f
C1279 S15_3 S37_6 0.000210263f
C1280 S15_3 S38_6 0.00019642f
C1281 S15_3 S39_6 0.000100868f
C1282 S15_3 S40_6 4.71662e-05f
C1283 S15_3 S41_6 3.914e-05f
C1284 S15_3 S42_6 2.57991e-05f
C1285 S15_3 S43_6 1.33715e-05f
C1286 S15_3 VDD 0.0108875f
C1287 S15_3 VSS_0 0.0317672f
C1288 S15_4 S16_6 0.00515422f
C1289 S15_4 S17_6 5.14367e-05f
C1290 S15_4 S18_6 1.56546e-05f
C1291 S15_4 S24_6 1.33569e-05f
C1292 S15_4 S25_6 1.30269e-05f
C1293 S15_4 S26_5 1.52044e-05f
C1294 S15_4 S33_5 1.39615e-05f
C1295 S15_4 S34_5 4.42123e-05f
C1296 S15_4 S35_5 0.000151247f
C1297 S15_4 S36_6 0.000105818f
C1298 S15_4 S37_6 8.29855e-05f
C1299 S15_4 S38_6 7.75217e-05f
C1300 S15_4 S39_6 3.98098e-05f
C1301 S15_4 S40_6 1.86153e-05f
C1302 S15_4 S41_6 1.54475e-05f
C1303 S15_4 S42_6 1.01822e-05f
C1304 S15_4 VDD 0.00429702f
C1305 S15_4 VSS_0 0.0125377f
C1306 S15_5 S16_7 0.00515422f
C1307 S15_5 S17_7 5.14367e-05f
C1308 S15_5 S18_7 1.56546e-05f
C1309 S15_5 S24_7 1.33569e-05f
C1310 S15_5 S25_7 1.30269e-05f
C1311 S15_5 S26_5 1.52044e-05f
C1312 S15_5 S33_5 1.39615e-05f
C1313 S15_5 S34_5 4.42123e-05f
C1314 S15_5 S35_5 0.000151247f
C1315 S15_5 S36_6 0.000105818f
C1316 S15_5 S37_6 8.29855e-05f
C1317 S15_5 S38_6 7.75217e-05f
C1318 S15_5 S39_6 3.98098e-05f
C1319 S15_5 S40_6 1.86153e-05f
C1320 S15_5 S41_6 1.54475e-05f
C1321 S15_5 S42_6 1.01822e-05f
C1322 S15_5 VDD 0.00429702f
C1323 S15_5 VSS_0 0.0125377f
C1324 S15_6 S16_6 0.0111993f
C1325 S15_6 S17_6 0.000111764f
C1326 S15_6 S18_6 3.4015e-05f
C1327 S15_6 S19_6 1.90019e-05f
C1328 S15_6 S23_6 1.59303e-05f
C1329 S15_6 S24_6 2.90224e-05f
C1330 S15_6 S25_6 2.83054e-05f
C1331 S15_6 S26_5 3.30368e-05f
C1332 S15_6 S27_5 2.08077e-05f
C1333 S15_6 S33_5 3.03361e-05f
C1334 S15_6 S34_5 9.60663e-05f
C1335 S15_6 S35_5 0.000328636f
C1336 S15_6 S36_5 0.000229927f
C1337 S15_6 S37_6 0.000180314f
C1338 S15_6 S38_6 0.000168442f
C1339 S15_6 S39_6 8.65004e-05f
C1340 S15_6 S40_6 4.04481e-05f
C1341 S15_6 S41_6 3.3565e-05f
C1342 S15_6 S42_6 2.21243e-05f
C1343 S15_6 S43_6 1.1467e-05f
C1344 S15_6 S7_2 1.04054e-05f
C1345 S15_6 S7_3 1.19827e-05f
C1346 S15_6 S7_6 1.02759e-05f
C1347 S15_6 S8_2 1.31606e-05f
C1348 S15_6 S8_3 1.51555e-05f
C1349 S15_6 S8_6 1.29968e-05f
C1350 S15_6 S9_1 1.09641e-05f
C1351 S15_6 S9_2 2.47533e-05f
C1352 S15_6 S9_3 2.85055e-05f
C1353 S15_6 S9_4 1.12504e-05f
C1354 S15_6 S9_6 2.44452e-05f
C1355 S15_6 VDD 0.00933675f
C1356 S15_6 VSS_0 0.0272424f
C1357 S15_7 S16_7 0.0111993f
C1358 S15_7 S17_7 0.000111764f
C1359 S15_7 S18_7 3.4015e-05f
C1360 S15_7 S19_7 1.90019e-05f
C1361 S15_7 S23_7 1.59303e-05f
C1362 S15_7 S24_7 2.90224e-05f
C1363 S15_7 S25_7 2.83054e-05f
C1364 S15_7 S26_5 3.30368e-05f
C1365 S15_7 S27_5 2.08077e-05f
C1366 S15_7 S33_5 3.03361e-05f
C1367 S15_7 S34_5 9.60663e-05f
C1368 S15_7 S35_5 0.000328636f
C1369 S15_7 S36_5 0.000229927f
C1370 S15_7 S37_6 0.000180314f
C1371 S15_7 S38_6 0.000168442f
C1372 S15_7 S39_6 8.65004e-05f
C1373 S15_7 S40_6 4.04481e-05f
C1374 S15_7 S41_6 3.3565e-05f
C1375 S15_7 S42_6 2.21243e-05f
C1376 S15_7 S43_6 1.1467e-05f
C1377 S15_7 S7_7 1.02759e-05f
C1378 S15_7 S8 1.02724e-05f
C1379 S15_7 S8_7 1.29968e-05f
C1380 S15_7 S9 1.9321e-05f
C1381 S15_7 S9_5 1.12504e-05f
C1382 S15_7 S9_7 2.44452e-05f
C1383 S15_7 VDD 0.00933675f
C1384 S15_7 VSS_0 0.0272424f
C1385 S16 S17_7 0.00883865f
C1386 S16 S18_7 6.17135e-05f
C1387 S16 S19_7 2.40664e-05f
C1388 S16 S25_7 1.23889e-05f
C1389 S16 S26_5 1.42099e-05f
C1390 S16 S34_5 0.000218252f
C1391 S16 S35_6 0.000145913f
C1392 S16 S36_6 0.00013138f
C1393 S16 S37_6 0.000135503f
C1394 S16 S38_6 8.22545e-05f
C1395 S16 S39_6 3.85128e-05f
C1396 S16 S40_6 2.57853e-05f
C1397 S16 S41_6 1.92804e-05f
C1398 S16 S42_6 1.29075e-05f
C1399 S16 VDD 0.00757565f
C1400 S16 VSS_0 0.0214377f
C1401 S16_1 S17_2 0.00501568f
C1402 S16_1 S18_6 3.50207e-05f
C1403 S16_1 S19_6 1.3657e-05f
C1404 S16_1 S34_5 0.000123852f
C1405 S16_1 S35_6 8.28014e-05f
C1406 S16_1 S36_6 7.45547e-05f
C1407 S16_1 S37_6 7.68942e-05f
C1408 S16_1 S38_6 4.66771e-05f
C1409 S16_1 S39_6 2.18549e-05f
C1410 S16_1 S40_6 1.46324e-05f
C1411 S16_1 S41_6 1.09411e-05f
C1412 S16_1 VDD 0.00429897f
C1413 S16_1 VSS_0 0.0121653f
C1414 S16_2 S17_6 0.0113237f
C1415 S16_2 S18_6 7.90648e-05f
C1416 S16_2 S19_6 3.08329e-05f
C1417 S16_2 S25_6 1.58721e-05f
C1418 S16_2 S26_5 1.82051e-05f
C1419 S16_2 S34_5 0.000279616f
C1420 S16_2 S35 0.000186938f
C1421 S16_2 S36_6 0.000168319f
C1422 S16_2 S37_6 0.000173601f
C1423 S16_2 S38_6 0.000105381f
C1424 S16_2 S39_6 4.9341e-05f
C1425 S16_2 S40_6 3.3035e-05f
C1426 S16_2 S41_6 2.47013e-05f
C1427 S16_2 S42_6 1.65366e-05f
C1428 S16_2 VDD 0.00970562f
C1429 S16_2 VSS_0 0.0274651f
C1430 S16_3 S17_6 0.0130402f
C1431 S16_3 S18_6 9.10497e-05f
C1432 S16_3 S19_6 3.55067e-05f
C1433 S16_3 S24_6 1.12061e-05f
C1434 S16_3 S25_6 1.82781e-05f
C1435 S16_3 S26_5 2.09647e-05f
C1436 S16_3 S34_5 0.000322001f
C1437 S16_3 S35_6 0.000215274f
C1438 S16_3 S36_6 0.000193834f
C1439 S16_3 S37_6 0.000199916f
C1440 S16_3 S38_6 0.000121355f
C1441 S16_3 S39_6 5.68203e-05f
C1442 S16_3 S40_6 3.80426e-05f
C1443 S16_3 S41_6 2.84456e-05f
C1444 S16_3 S42_6 1.90433e-05f
C1445 S16_3 S43_6 1.01347e-05f
C1446 S16_3 VDD 0.0111768f
C1447 S16_3 VSS_0 0.0316283f
C1448 S16_4 S17_6 0.00514663f
C1449 S16_4 S18_6 3.59349e-05f
C1450 S16_4 S19_6 1.40135e-05f
C1451 S16_4 S34_5 0.000127085f
C1452 S16_4 S35_6 8.49631e-05f
C1453 S16_4 S36_6 7.65011e-05f
C1454 S16_4 S37_6 7.89017e-05f
C1455 S16_4 S38_6 4.78957e-05f
C1456 S16_4 S39_6 2.24255e-05f
C1457 S16_4 S40_6 1.50144e-05f
C1458 S16_4 S41_6 1.12267e-05f
C1459 S16_4 VDD 0.0044112f
C1460 S16_4 VSS_0 0.0124829f
C1461 S16_5 S17_7 0.00514663f
C1462 S16_5 S18_7 3.59349e-05f
C1463 S16_5 S19_7 1.40135e-05f
C1464 S16_5 S34_5 0.000127085f
C1465 S16_5 S35_6 8.49631e-05f
C1466 S16_5 S36_6 7.65011e-05f
C1467 S16_5 S37_6 7.89017e-05f
C1468 S16_5 S38_6 4.78957e-05f
C1469 S16_5 S39_6 2.24255e-05f
C1470 S16_5 S40_6 1.50144e-05f
C1471 S16_5 S41_6 1.12267e-05f
C1472 S16_5 VDD 0.0044112f
C1473 S16_5 VSS_0 0.0124829f
C1474 S16_6 S17_6 0.0111828f
C1475 S16_6 S18_6 7.8081e-05f
C1476 S16_6 S19_6 3.04492e-05f
C1477 S16_6 S25_6 1.56746e-05f
C1478 S16_6 S26_5 1.79786e-05f
C1479 S16_6 S34_5 0.000276137f
C1480 S16_6 S35_5 0.000184611f
C1481 S16_6 S36_6 0.000166225f
C1482 S16_6 S37_6 0.000171441f
C1483 S16_6 S38_6 0.00010407f
C1484 S16_6 S39_6 4.8727e-05f
C1485 S16_6 S40_6 3.2624e-05f
C1486 S16_6 S41_6 2.43939e-05f
C1487 S16_6 S42_6 1.63308e-05f
C1488 S16_6 S7_3 1.07377e-05f
C1489 S16_6 S8_3 1.11901e-05f
C1490 S16_6 S9_2 1.66557e-05f
C1491 S16_6 S9_3 1.91804e-05f
C1492 S16_6 S9_6 1.64485e-05f
C1493 S16_6 VDD 0.00958484f
C1494 S16_6 VSS_0 0.0271233f
C1495 S16_7 S17_7 0.0111828f
C1496 S16_7 S18_7 7.8081e-05f
C1497 S16_7 S19_7 3.04492e-05f
C1498 S16_7 S25_7 1.56746e-05f
C1499 S16_7 S26_5 1.79786e-05f
C1500 S16_7 S34_5 0.000276137f
C1501 S16_7 S35_5 0.000184611f
C1502 S16_7 S36_6 0.000166225f
C1503 S16_7 S37_6 0.000171441f
C1504 S16_7 S38_6 0.00010407f
C1505 S16_7 S39_6 4.8727e-05f
C1506 S16_7 S40_6 3.2624e-05f
C1507 S16_7 S41_6 2.43939e-05f
C1508 S16_7 S42_6 1.63308e-05f
C1509 S16_7 S9 1.30005e-05f
C1510 S16_7 S9_7 1.64485e-05f
C1511 S16_7 VDD 0.00958484f
C1512 S16_7 VSS_0 0.0271233f
C1513 S17 S18_7 0.00880602f
C1514 S17 S19_7 6.84546e-05f
C1515 S17 S20_7 2.19075e-05f
C1516 S17 S33_5 0.000199375f
C1517 S17 S34_6 0.000113001f
C1518 S17 S35_6 7.86708e-05f
C1519 S17 S36_6 8.84967e-05f
C1520 S17 S37_6 6.51735e-05f
C1521 S17 S38_6 3.56053e-05f
C1522 S17 S39_6 2.73475e-05f
C1523 S17 S40_6 1.71969e-05f
C1524 S17 S41_6 1.30562e-05f
C1525 S17 VDD 0.00772015f
C1526 S17 VSS_0 0.0211685f
C1527 S17_1 S18_2 0.00499717f
C1528 S17_1 S19_6 3.88461e-05f
C1529 S17_1 S20_6 1.24319e-05f
C1530 S17_1 S33_5 0.00011314f
C1531 S17_1 S34_6 6.41249e-05f
C1532 S17_1 S35_6 4.46434e-05f
C1533 S17_1 S36_6 5.02194e-05f
C1534 S17_1 S37_6 3.69841e-05f
C1535 S17_1 S38_6 2.0205e-05f
C1536 S17_1 S39_6 1.55189e-05f
C1537 S17_1 VDD 0.00438097f
C1538 S17_1 VSS_0 0.0120125f
C1539 S17_2 S18_6 0.0112819f
C1540 S17_2 S19_6 8.77012e-05f
C1541 S17_2 S20_6 2.8067e-05f
C1542 S17_2 S33_5 0.000255431f
C1543 S17_2 S34 0.000144772f
C1544 S17_2 S35_6 0.00010079f
C1545 S17_2 S36_6 0.000113378f
C1546 S17_2 S37_6 8.34977e-05f
C1547 S17_2 S38_6 4.56161e-05f
C1548 S17_2 S39_6 3.50365e-05f
C1549 S17_2 S40_6 2.2032e-05f
C1550 S17_2 S41_6 1.6727e-05f
C1551 S17_2 VDD 0.00989074f
C1552 S17_2 VSS_0 0.0271202f
C1553 S17_3 S18_6 0.0129921f
C1554 S17_3 S19_6 0.000100995f
C1555 S17_3 S20_6 3.23215e-05f
C1556 S17_3 S33_5 0.000294151f
C1557 S17_3 S34_6 0.000166717f
C1558 S17_3 S35_6 0.000116068f
C1559 S17_3 S36_6 0.000130565f
C1560 S17_3 S37_6 9.61545e-05f
C1561 S17_3 S38_6 5.25307e-05f
C1562 S17_3 S39_6 4.03474e-05f
C1563 S17_3 S40_6 2.53717e-05f
C1564 S17_3 S41_6 1.92626e-05f
C1565 S17_3 S42_6 1.05707e-05f
C1566 S17_3 VDD 0.01139f
C1567 S17_3 VSS_0 0.0312312f
C1568 S17_4 S18_6 0.00512762f
C1569 S17_4 S19_6 3.98602e-05f
C1570 S17_4 S20_6 1.27565e-05f
C1571 S17_4 S33_5 0.000116094f
C1572 S17_4 S34_6 6.5799e-05f
C1573 S17_4 S35_6 4.58089e-05f
C1574 S17_4 S36_6 5.15305e-05f
C1575 S17_4 S37_6 3.79497e-05f
C1576 S17_4 S38_6 2.07325e-05f
C1577 S17_4 S39_6 1.59241e-05f
C1578 S17_4 S40_6 1.00135e-05f
C1579 S17_4 VDD 0.00449534f
C1580 S17_4 VSS_0 0.0123261f
C1581 S17_5 S18_7 0.00512762f
C1582 S17_5 S19_7 3.98602e-05f
C1583 S17_5 S20_7 1.27565e-05f
C1584 S17_5 S33_5 0.000116094f
C1585 S17_5 S34_6 6.5799e-05f
C1586 S17_5 S35_6 4.58089e-05f
C1587 S17_5 S36_6 5.15305e-05f
C1588 S17_5 S37_6 3.79497e-05f
C1589 S17_5 S38_6 2.07325e-05f
C1590 S17_5 S39_6 1.59241e-05f
C1591 S17_5 S40_6 1.00135e-05f
C1592 S17_5 VDD 0.00449534f
C1593 S17_5 VSS_0 0.0123261f
C1594 S17_6 S18_6 0.0111415f
C1595 S17_6 S19_6 8.66099e-05f
C1596 S17_6 S20_6 2.77178e-05f
C1597 S17_6 S33_5 0.000252253f
C1598 S17_6 S34_5 0.000142971f
C1599 S17_6 S35_6 9.95356e-05f
C1600 S17_6 S36_6 0.000111968f
C1601 S17_6 S37_6 8.24587e-05f
C1602 S17_6 S38_6 4.50485e-05f
C1603 S17_6 S39_6 3.46005e-05f
C1604 S17_6 S40_6 2.17578e-05f
C1605 S17_6 S41_6 1.65189e-05f
C1606 S17_6 VDD 0.00976767f
C1607 S17_6 VSS_0 0.0267827f
C1608 S17_7 S18_7 0.0111415f
C1609 S17_7 S19_7 8.66099e-05f
C1610 S17_7 S20_7 2.77178e-05f
C1611 S17_7 S33_5 0.000252253f
C1612 S17_7 S34_5 0.000142971f
C1613 S17_7 S35_6 9.95356e-05f
C1614 S17_7 S36_6 0.000111968f
C1615 S17_7 S37_6 8.24587e-05f
C1616 S17_7 S38_6 4.50485e-05f
C1617 S17_7 S39_6 3.46005e-05f
C1618 S17_7 S40_6 2.17578e-05f
C1619 S17_7 S41_6 1.65189e-05f
C1620 S17_7 VDD 0.00976767f
C1621 S17_7 VSS_0 0.0267827f
C1622 S18 S19_7 0.00868286f
C1623 S18 S20_7 7.2357e-05f
C1624 S18 S21_7 1.23379e-05f
C1625 S18 S32_5 0.000181426f
C1626 S18 S33_6 0.00010225f
C1627 S18 S34_6 5.86825e-05f
C1628 S18 S35_6 4.05496e-05f
C1629 S18 S36_6 2.6068e-05f
C1630 S18 VDD 0.00775958f
C1631 S18 VSS_0 0.0209141f
C1632 S18 VSS_1 1.64715e-05f
C1633 S18_1 S19_2 0.00492728f
C1634 S18_1 S20_6 4.10605e-05f
C1635 S18_1 S32_5 0.000102954f
C1636 S18_1 S33_6 5.80241e-05f
C1637 S18_1 S34_6 3.33007e-05f
C1638 S18_1 S35_6 2.30107e-05f
C1639 S18_1 S36_6 1.47928e-05f
C1640 S18_1 VDD 0.00440334f
C1641 S18_1 VSS_0 0.0118682f
C1642 S18_2 S19_6 0.0111241f
C1643 S18_2 S20_6 9.27008e-05f
C1644 S18_2 S21_6 1.58068e-05f
C1645 S18_2 S32_5 0.000232436f
C1646 S18_2 S33 0.000130999f
C1647 S18_2 S34_6 7.51816e-05f
C1648 S18_2 S35_6 5.19505e-05f
C1649 S18_2 S36_6 3.33972e-05f
C1650 S18_2 S37_6 1.24974e-05f
C1651 S18_2 S38_6 1.25783e-05f
C1652 S18_2 S39_6 1.17014e-05f
C1653 S18_2 S40_6 1.03551e-05f
C1654 S18_2 VDD 0.00994126f
C1655 S18_2 VSS_0 0.0267943f
C1656 S18_2 VSS_1 2.11027e-05f
C1657 S18_3 S19_6 0.0128104f
C1658 S18_3 S20_6 0.000106753f
C1659 S18_3 S21_6 1.82029e-05f
C1660 S18_3 S32_5 0.000267669f
C1661 S18_3 S33_6 0.000150856f
C1662 S18_3 S34_6 8.65779e-05f
C1663 S18_3 S35_6 5.98253e-05f
C1664 S18_3 S36_6 3.84597e-05f
C1665 S18_3 S37_6 1.43918e-05f
C1666 S18_3 S38_6 1.4485e-05f
C1667 S18_3 S39_6 1.34751e-05f
C1668 S18_3 S40_6 1.19247e-05f
C1669 S18_3 VDD 0.0114482f
C1670 S18_3 VSS_0 0.0308558f
C1671 S18_3 VSS_1 2.43015e-05f
C1672 S18_4 S19_6 0.00505592f
C1673 S18_4 S20_6 4.21325e-05f
C1674 S18_4 S32_5 0.000105642f
C1675 S18_4 S33_6 5.95389e-05f
C1676 S18_4 S34_6 3.417e-05f
C1677 S18_4 S35_6 2.36115e-05f
C1678 S18_4 S36_6 1.5179e-05f
C1679 S18_4 VDD 0.0045183f
C1680 S18_4 VSS_0 0.012178f
C1681 S18_5 S19_7 0.00505592f
C1682 S18_5 S20_7 4.21325e-05f
C1683 S18_5 S32_5 0.000105642f
C1684 S18_5 S33_6 5.95389e-05f
C1685 S18_5 S34_6 3.417e-05f
C1686 S18_5 S35_6 2.36115e-05f
C1687 S18_5 S36_6 1.5179e-05f
C1688 S18_5 VDD 0.0045183f
C1689 S18_5 VSS_0 0.012178f
C1690 S18_6 S19_6 0.0109857f
C1691 S18_6 S20_6 9.15473e-05f
C1692 S18_6 S21_6 1.56101e-05f
C1693 S18_6 S32_5 0.000229543f
C1694 S18_6 S33_5 0.000129369f
C1695 S18_6 S34_6 7.42461e-05f
C1696 S18_6 S35_6 5.1304e-05f
C1697 S18_6 S36_6 3.29816e-05f
C1698 S18_6 S37_6 1.23419e-05f
C1699 S18_6 S38_6 1.24218e-05f
C1700 S18_6 S39_6 1.15558e-05f
C1701 S18_6 S40_6 1.02262e-05f
C1702 S18_6 VDD 0.00981756f
C1703 S18_6 VSS_0 0.0264609f
C1704 S18_6 VSS_1 2.08401e-05f
C1705 S18_7 S19_7 0.0109857f
C1706 S18_7 S20_7 9.15473e-05f
C1707 S18_7 S21_7 1.56101e-05f
C1708 S18_7 S32_5 0.000229543f
C1709 S18_7 S33_5 0.000129369f
C1710 S18_7 S34_6 7.42461e-05f
C1711 S18_7 S35_6 5.1304e-05f
C1712 S18_7 S36_6 3.29816e-05f
C1713 S18_7 S37_6 1.23419e-05f
C1714 S18_7 S38_6 1.24218e-05f
C1715 S18_7 S39_6 1.15558e-05f
C1716 S18_7 S40_6 1.02262e-05f
C1717 S18_7 VDD 0.00981756f
C1718 S18_7 VSS_0 0.0264609f
C1719 S18_7 VSS_1 2.08401e-05f
C1720 S19 S20_7 0.00877872f
C1721 S19 S21_7 6.01921e-05f
C1722 S19 S31_5 0.000190132f
C1723 S19 S32_6 9.14658e-05f
C1724 S19 S33_6 6.1579e-05f
C1725 S19 S34_6 4.90764e-05f
C1726 S19 S35_6 1.46611e-05f
C1727 S19 S39_6 1.55453e-05f
C1728 S19 S40_6 1.65018e-05f
C1729 S19 S41_6 1.50123e-05f
C1730 S19 VDD 0.00779696f
C1731 S19 VSS_0 0.0201616f
C1732 S19 VSS_1 2.46061e-05f
C1733 S19_1 S20_2 0.00498167f
C1734 S19_1 S21_6 3.41573e-05f
C1735 S19_1 S31_5 0.000107895f
C1736 S19_1 S32_6 5.19042e-05f
C1737 S19_1 S33_6 3.49444e-05f
C1738 S19_1 S34_6 2.78495e-05f
C1739 S19_1 VDD 0.00442456f
C1740 S19_1 VSS_0 0.0114411f
C1741 S19_1 VSS_1 1.39633e-05f
C1742 S19_2 S20_6 0.0112469f
C1743 S19_2 S21_6 7.71157e-05f
C1744 S19_2 S31_5 0.00024359f
C1745 S19_2 S32 0.000117182f
C1746 S19_2 S33_6 7.88926e-05f
C1747 S19_2 S34_6 6.28747e-05f
C1748 S19_2 S35_6 1.87831e-05f
C1749 S19_2 S39_6 1.99159e-05f
C1750 S19_2 S40_6 2.11414e-05f
C1751 S19_2 S41_6 1.92331e-05f
C1752 S19_2 S42_6 1.13445e-05f
C1753 S19_2 VDD 0.00998915f
C1754 S19_2 VSS_0 0.0258302f
C1755 S19_2 VSS_1 3.15243e-05f
C1756 S19_3 S20_6 0.0129518f
C1757 S19_3 S21_6 8.88051e-05f
C1758 S19_3 S31_5 0.000280514f
C1759 S19_3 S32_6 0.000134945f
C1760 S19_3 S33_6 9.08514e-05f
C1761 S19_3 S34_6 7.24055e-05f
C1762 S19_3 S35_6 2.16304e-05f
C1763 S19_3 S39_6 2.29349e-05f
C1764 S19_3 S40_6 2.43461e-05f
C1765 S19_3 S41_6 2.21485e-05f
C1766 S19_3 S42_6 1.30641e-05f
C1767 S19_3 S43_6 1.1016e-05f
C1768 S19_3 VDD 0.0115033f
C1769 S19_3 VSS_0 0.0297456f
C1770 S19_3 VSS_1 3.63029e-05f
C1771 S19_4 S20_6 0.00511173f
C1772 S19_4 S21_6 3.50491e-05f
C1773 S19_4 S31_5 0.000110711f
C1774 S19_4 S32_6 5.32593e-05f
C1775 S19_4 S33_6 3.58567e-05f
C1776 S19_4 S34_6 2.85766e-05f
C1777 S19_4 VDD 0.00454007f
C1778 S19_4 VSS_0 0.0117398f
C1779 S19_4 VSS_1 1.43278e-05f
C1780 S19_5 S20_7 0.00511173f
C1781 S19_5 S21_7 3.50491e-05f
C1782 S19_5 S31_5 0.000110711f
C1783 S19_5 S32_6 5.32593e-05f
C1784 S19_5 S33_6 3.58567e-05f
C1785 S19_5 S34_6 2.85766e-05f
C1786 S19_5 VDD 0.00454007f
C1787 S19_5 VSS_0 0.0117398f
C1788 S19_5 VSS_1 1.43278e-05f
C1789 S19_6 S20_6 0.011107f
C1790 S19_6 S21_6 7.61561e-05f
C1791 S19_6 S31_5 0.000240559f
C1792 S19_6 S32_5 0.000115724f
C1793 S19_6 S33_6 7.79109e-05f
C1794 S19_6 S34_6 6.20924e-05f
C1795 S19_6 S35_6 1.85494e-05f
C1796 S19_6 S39_6 1.96681e-05f
C1797 S19_6 S40_6 2.08784e-05f
C1798 S19_6 S41_6 1.89938e-05f
C1799 S19_6 S42_6 1.12033e-05f
C1800 S19_6 S8_2 1.00897e-05f
C1801 S19_6 S8_3 1.16192e-05f
C1802 S19_6 S9_2 1.49797e-05f
C1803 S19_6 S9_3 1.72504e-05f
C1804 S19_6 S9_6 1.47933e-05f
C1805 S19_6 VDD 0.00986485f
C1806 S19_6 VSS_0 0.0255088f
C1807 S19_6 VSS_1 3.1132e-05f
C1808 S19_7 S20_7 0.011107f
C1809 S19_7 S21_7 7.61561e-05f
C1810 S19_7 S31_5 0.000240559f
C1811 S19_7 S32_5 0.000115724f
C1812 S19_7 S33_6 7.79109e-05f
C1813 S19_7 S34_6 6.20924e-05f
C1814 S19_7 S35_6 1.85494e-05f
C1815 S19_7 S39_6 1.96681e-05f
C1816 S19_7 S40_6 2.08784e-05f
C1817 S19_7 S41_6 1.89938e-05f
C1818 S19_7 S42_6 1.12033e-05f
C1819 S19_7 S9 1.16923e-05f
C1820 S19_7 S9_7 1.47933e-05f
C1821 S19_7 VDD 0.00986485f
C1822 S19_7 VSS_0 0.0255088f
C1823 S19_7 VSS_1 3.1132e-05f
C1824 S1_1 S2_2 0.00502213f
C1825 S1_1 S39_5 2.04389e-05f
C1826 S1_1 S3_6 6.66504e-05f
C1827 S1_1 S40_5 1.88141e-05f
C1828 S1_1 S41_5 1.16582e-05f
C1829 S1_1 S46_5 1.32937e-05f
C1830 S1_1 S47_5 3.45425e-05f
C1831 S1_1 S48_5 3.90361e-05f
C1832 S1_1 S49_5 0.000145576f
C1833 S1_1 S4_6 3.13956e-05f
C1834 S1_1 S50_6 8.72469e-05f
C1835 S1_1 VDD 0.0043497f
C1836 S1_1 VSS_0 0.0121345f
C1837 S1_2 S24_6 1.31917e-05f
C1838 S1_2 S25_6 1.78492e-05f
C1839 S1_2 S2_6 0.0113383f
C1840 S1_2 S38_5 1.94892e-05f
C1841 S1_2 S39_5 4.61441e-05f
C1842 S1_2 S3_6 0.000150474f
C1843 S1_2 S40_5 4.24759e-05f
C1844 S1_2 S41_5 2.63203e-05f
C1845 S1_2 S46_5 3.00127e-05f
C1846 S1_2 S47_5 7.79854e-05f
C1847 S1_2 S48_5 8.81304e-05f
C1848 S1_2 S49_5 0.000328661f
C1849 S1_2 S4_6 7.08806e-05f
C1850 S1_2 S50 0.000196974f
C1851 S1_2 S6_6 1.43103e-05f
C1852 S1_2 VDD 0.00982015f
C1853 S1_2 VSS_0 0.0273956f
C1854 S1_3 S24_6 1.51913e-05f
C1855 S1_3 S25_6 2.05549e-05f
C1856 S1_3 S2_6 0.013057f
C1857 S1_3 S38_5 2.24435e-05f
C1858 S1_3 S39_5 5.31388e-05f
C1859 S1_3 S3_6 0.000173283f
C1860 S1_3 S40_5 4.89145e-05f
C1861 S1_3 S41_5 3.03101e-05f
C1862 S1_3 S46_5 3.45621e-05f
C1863 S1_3 S47_5 8.98067e-05f
C1864 S1_3 S48_5 0.00010149f
C1865 S1_3 S49_5 0.00037848f
C1866 S1_3 S4_6 8.16249e-05f
C1867 S1_3 S50_6 0.000226832f
C1868 S1_3 S6_6 1.64796e-05f
C1869 S1_3 VDD 0.0113087f
C1870 S1_3 VSS_0 0.0315483f
C1871 S1_4 S2_6 0.00515324f
C1872 S1_4 S39_5 2.09725e-05f
C1873 S1_4 S3_6 6.83904e-05f
C1874 S1_4 S40_5 1.93053e-05f
C1875 S1_4 S41_5 1.19626e-05f
C1876 S1_4 S46_5 1.36407e-05f
C1877 S1_4 S47_5 3.54443e-05f
C1878 S1_4 S48_5 4.00552e-05f
C1879 S1_4 S49_5 0.000149376f
C1880 S1_4 S4_6 3.22152e-05f
C1881 S1_4 S50_6 8.95246e-05f
C1882 S1_4 VDD 0.00446326f
C1883 S1_4 VSS_0 0.0124513f
C1884 S1_5 S2_7 0.00515324f
C1885 S1_5 S39_5 2.09725e-05f
C1886 S1_5 S3_7 6.83904e-05f
C1887 S1_5 S40_5 1.93053e-05f
C1888 S1_5 S41_5 1.19626e-05f
C1889 S1_5 S46_5 1.36407e-05f
C1890 S1_5 S47_5 3.54443e-05f
C1891 S1_5 S48_5 4.00552e-05f
C1892 S1_5 S49_5 0.000149376f
C1893 S1_5 S4_7 3.22152e-05f
C1894 S1_5 S50_6 8.95246e-05f
C1895 S1_5 VDD 0.00446326f
C1896 S1_5 VSS_0 0.0124513f
C1897 S1_6 S24_6 1.30275e-05f
C1898 S1_6 S25_6 1.76271e-05f
C1899 S1_6 S2_6 0.0111972f
C1900 S1_6 S38_5 1.92467e-05f
C1901 S1_6 S39_5 4.55699e-05f
C1902 S1_6 S3_6 0.000148602f
C1903 S1_6 S40_5 4.19473e-05f
C1904 S1_6 S41_5 2.59928e-05f
C1905 S1_6 S46_5 2.96392e-05f
C1906 S1_6 S47_5 7.70149e-05f
C1907 S1_6 S48_5 8.70337e-05f
C1908 S1_6 S49_5 0.000324571f
C1909 S1_6 S4_6 6.99986e-05f
C1910 S1_6 S50_5 0.000194523f
C1911 S1_6 S6_6 1.41323e-05f
C1912 S1_6 VDD 0.00969795f
C1913 S1_6 VSS_0 0.0270547f
C1914 S1_7 S24_7 1.30275e-05f
C1915 S1_7 S25_7 1.76271e-05f
C1916 S1_7 S2_7 0.0111972f
C1917 S1_7 S38_5 1.92467e-05f
C1918 S1_7 S39_5 4.55699e-05f
C1919 S1_7 S3_7 0.000148602f
C1920 S1_7 S40_5 4.19473e-05f
C1921 S1_7 S41_5 2.59928e-05f
C1922 S1_7 S46_5 2.96392e-05f
C1923 S1_7 S47_5 7.70149e-05f
C1924 S1_7 S48_5 8.70337e-05f
C1925 S1_7 S49_5 0.000324571f
C1926 S1_7 S4_7 6.99986e-05f
C1927 S1_7 S50_5 0.000194523f
C1928 S1_7 S6_7 1.41323e-05f
C1929 S1_7 VDD 0.00969795f
C1930 S1_7 VSS_0 0.0270547f
C1931 S2 S38_5 1.14042e-05f
C1932 S2 S39_5 2.71426e-05f
C1933 S2 S3_7 0.00886752f
C1934 S2 S40_5 2.28792e-05f
C1935 S2 S41_5 1.10494e-05f
C1936 S2 S46_5 3.32378e-05f
C1937 S2 S47_5 4.46399e-05f
C1938 S2 S48_5 0.00025484f
C1939 S2 S49_6 0.000148524f
C1940 S2 S4_7 9.11708e-05f
C1941 S2 S50_6 0.000102792f
C1942 S2 S5_7 1.74024e-05f
C1943 S2 S6_7 1.00023e-05f
C1944 S2 VDD 0.007601f
C1945 S2 VSS_0 0.0214525f
C1946 S20 S21_7 0.00872399f
C1947 S20 S22_7 4.8213e-05f
C1948 S20 S23_7 1.81634e-05f
C1949 S20 S28_5 1.4682e-05f
C1950 S20 S30_5 0.000212438f
C1951 S20 S31_6 9.84025e-05f
C1952 S20 S32_6 2.54234e-05f
C1953 S20 S33_6 3.61841e-05f
C1954 S20 VDD 0.00783542f
C1955 S20 VSS_0 0.0207681f
C1956 S20 VSS_1 5.81634e-05f
C1957 S20_1 S21_2 0.00495062f
C1958 S20_1 S22_6 2.73595e-05f
C1959 S20_1 S23_6 1.03072e-05f
C1960 S20_1 S30_5 0.000120553f
C1961 S20_1 S31_6 5.58407e-05f
C1962 S20_1 S32_6 1.4427e-05f
C1963 S20_1 S33_6 2.05335e-05f
C1964 S20_1 VDD 0.00444638f
C1965 S20_1 VSS_0 0.0117853f
C1966 S20_1 VSS_1 3.30061e-05f
C1967 S20_2 S21_6 0.0111768f
C1968 S20_2 S22_6 6.17686e-05f
C1969 S20_2 S23_6 2.32702e-05f
C1970 S20_2 S25_6 1.26679e-05f
C1971 S20_2 S26_5 1.12198e-05f
C1972 S20_2 S28_5 1.881e-05f
C1973 S20_2 S30_5 0.000272167f
C1974 S20_2 S31 0.000126069f
C1975 S20_2 S32_6 3.25714e-05f
C1976 S20_2 S33_6 4.63576e-05f
C1977 S20_2 VDD 0.0100384f
C1978 S20_2 VSS_0 0.0266073f
C1979 S20_2 VSS_1 7.45165e-05f
C1980 S20_3 S21_6 0.012871f
C1981 S20_3 S22_6 7.11317e-05f
C1982 S20_3 S23_6 2.67976e-05f
C1983 S20_3 S25_6 1.45881e-05f
C1984 S20_3 S26_5 1.29206e-05f
C1985 S20_3 S28_5 2.16612e-05f
C1986 S20_3 S30_5 0.000313423f
C1987 S20_3 S31_6 0.000145179f
C1988 S20_3 S32_6 3.75087e-05f
C1989 S20_3 S33_6 5.33847e-05f
C1990 S20_3 S34_6 1.01589e-05f
C1991 S20_3 VDD 0.0115601f
C1992 S20_3 VSS_0 0.0306405f
C1993 S20_3 VSS_1 8.5812e-05f
C1994 S20_4 S21_6 0.00507986f
C1995 S20_4 S22_6 2.80738e-05f
C1996 S20_4 S23_6 1.05763e-05f
C1997 S20_4 S30_5 0.0001237f
C1998 S20_4 S31_6 5.72985e-05f
C1999 S20_4 S32_6 1.48037e-05f
C2000 S20_4 S33_6 2.10695e-05f
C2001 S20_4 VDD 0.00456246f
C2002 S20_4 VSS_0 0.012093f
C2003 S20_4 VSS_1 3.38677e-05f
C2004 S20_5 S21_7 0.00507986f
C2005 S20_5 S22_7 2.80738e-05f
C2006 S20_5 S23_7 1.05763e-05f
C2007 S20_5 S30_5 0.0001237f
C2008 S20_5 S31_6 5.72985e-05f
C2009 S20_5 S32_6 1.48037e-05f
C2010 S20_5 S33_6 2.10695e-05f
C2011 S20_5 VDD 0.00456246f
C2012 S20_5 VSS_0 0.012093f
C2013 S20_5 VSS_1 3.38677e-05f
C2014 S20_6 S21_6 0.0110377f
C2015 S20_6 S22_6 6.1e-05f
C2016 S20_6 S23_6 2.29807e-05f
C2017 S20_6 S25_6 1.25102e-05f
C2018 S20_6 S26_5 1.10802e-05f
C2019 S20_6 S28_5 1.85759e-05f
C2020 S20_6 S30_5 0.00026878f
C2021 S20_6 S31_5 0.000124501f
C2022 S20_6 S32_6 3.21661e-05f
C2023 S20_6 S33_6 4.57808e-05f
C2024 S20_6 VDD 0.00991351f
C2025 S20_6 VSS_0 0.0262762f
C2026 S20_6 VSS_1 7.35893e-05f
C2027 S20_7 S21_7 0.0110377f
C2028 S20_7 S22_7 6.1e-05f
C2029 S20_7 S23_7 2.29807e-05f
C2030 S20_7 S25_7 1.25102e-05f
C2031 S20_7 S26_5 1.10802e-05f
C2032 S20_7 S28_5 1.85759e-05f
C2033 S20_7 S30_5 0.00026878f
C2034 S20_7 S31_5 0.000124501f
C2035 S20_7 S32_6 3.21661e-05f
C2036 S20_7 S33_6 4.57808e-05f
C2037 S20_7 VDD 0.00991351f
C2038 S20_7 VSS_0 0.0262762f
C2039 S20_7 VSS_1 7.35893e-05f
C2040 S21 S22_7 0.00873815f
C2041 S21 S23_7 7.34385e-05f
C2042 S21 S24_7 5.56244e-05f
C2043 S21 S25_7 2.33313e-05f
C2044 S21 S26_5 4.85824e-05f
C2045 S21 S27_5 3.23336e-05f
C2046 S21 S29_5 0.000206772f
C2047 S21 S30_6 9.84714e-05f
C2048 S21 S31_6 4.28268e-05f
C2049 S21 S32_6 2.134e-05f
C2050 S21 VDD 0.00793632f
C2051 S21 VSS_0 0.0211045f
C2052 S21 VSS_1 3.54728e-05f
C2053 S21_1 S22_2 0.00495865f
C2054 S21_1 S23_6 4.16743e-05f
C2055 S21_1 S24_6 3.15653e-05f
C2056 S21_1 S25_6 1.32398e-05f
C2057 S21_1 S26_5 2.75691e-05f
C2058 S21_1 S27_5 1.83484e-05f
C2059 S21_1 S29_5 0.000117337f
C2060 S21_1 S30_6 5.58797e-05f
C2061 S21_1 S31_6 2.4303e-05f
C2062 S21_1 S32_6 1.21098e-05f
C2063 S21_1 VDD 0.00450364f
C2064 S21_1 VSS_0 0.0119762f
C2065 S21_1 VSS_1 2.01298e-05f
C2066 S21_2 S22_6 0.011195f
C2067 S21_2 S23_6 9.40864e-05f
C2068 S21_2 S24_6 7.12637e-05f
C2069 S21_2 S25_6 2.98911e-05f
C2070 S21_2 S26_5 6.22417e-05f
C2071 S21_2 S27_5 4.14245e-05f
C2072 S21_2 S28_5 1.20862e-05f
C2073 S21_2 S29_5 0.000264908f
C2074 S21_2 S30 0.000126158f
C2075 S21_2 S31_6 5.48679e-05f
C2076 S21_2 S32_6 2.73399e-05f
C2077 S21_2 VDD 0.0101677f
C2078 S21_2 VSS_0 0.0270382f
C2079 S21_2 VSS_1 4.54463e-05f
C2080 S21_3 S22_6 0.0128919f
C2081 S21_3 S23_6 0.000108348f
C2082 S21_3 S24_6 8.20661e-05f
C2083 S21_3 S25_6 3.44221e-05f
C2084 S21_3 S26_5 7.16766e-05f
C2085 S21_3 S27_5 4.77038e-05f
C2086 S21_3 S28_5 1.39183e-05f
C2087 S21_3 S29_5 0.000305064f
C2088 S21_3 S30_6 0.000145281f
C2089 S21_3 S31_6 6.3185e-05f
C2090 S21_3 S32_6 3.14842e-05f
C2091 S21_3 VDD 0.0117089f
C2092 S21_3 VSS_0 0.0311367f
C2093 S21_3 VSS_1 5.23352e-05f
C2094 S21_4 S22_6 0.00508811f
C2095 S21_4 S23_6 4.27623e-05f
C2096 S21_4 S24_6 3.23893e-05f
C2097 S21_4 S25_6 1.35855e-05f
C2098 S21_4 S26_5 2.82889e-05f
C2099 S21_4 S27_5 1.88274e-05f
C2100 S21_4 S29_5 0.000120401f
C2101 S21_4 S30_6 5.73386e-05f
C2102 S21_4 S31_6 2.49375e-05f
C2103 S21_4 S32_6 1.2426e-05f
C2104 S21_4 VDD 0.00462121f
C2105 S21_4 VSS_0 0.0122888f
C2106 S21_4 VSS_1 2.06553e-05f
C2107 S21_5 S22_7 0.00508811f
C2108 S21_5 S23_7 4.27623e-05f
C2109 S21_5 S24_7 3.23893e-05f
C2110 S21_5 S25_7 1.35855e-05f
C2111 S21_5 S26_5 2.82889e-05f
C2112 S21_5 S27_5 1.88274e-05f
C2113 S21_5 S29_5 0.000120401f
C2114 S21_5 S30_6 5.73386e-05f
C2115 S21_5 S31_6 2.49375e-05f
C2116 S21_5 S32_6 1.2426e-05f
C2117 S21_5 VDD 0.00462121f
C2118 S21_5 VSS_0 0.0122888f
C2119 S21_5 VSS_1 2.06553e-05f
C2120 S21_6 S22_6 0.0110557f
C2121 S21_6 S23_6 9.29157e-05f
C2122 S21_6 S24_6 7.03769e-05f
C2123 S21_6 S25_6 2.95191e-05f
C2124 S21_6 S26_5 6.14672e-05f
C2125 S21_6 S27_5 4.09091e-05f
C2126 S21_6 S28_5 1.19359e-05f
C2127 S21_6 S29_5 0.000261612f
C2128 S21_6 S30_5 0.000124588f
C2129 S21_6 S31_6 5.41852e-05f
C2130 S21_6 S32_6 2.69997e-05f
C2131 S21_6 VDD 0.0100412f
C2132 S21_6 VSS_0 0.0267017f
C2133 S21_6 VSS_1 4.48808e-05f
C2134 S21_7 S22_7 0.0110557f
C2135 S21_7 S23_7 9.29157e-05f
C2136 S21_7 S24_7 7.03769e-05f
C2137 S21_7 S25_7 2.95191e-05f
C2138 S21_7 S26_5 6.14672e-05f
C2139 S21_7 S27_5 4.09091e-05f
C2140 S21_7 S28_5 1.19359e-05f
C2141 S21_7 S29_5 0.000261612f
C2142 S21_7 S30_5 0.000124588f
C2143 S21_7 S31_6 5.41852e-05f
C2144 S21_7 S32_6 2.69997e-05f
C2145 S21_7 VDD 0.0100412f
C2146 S21_7 VSS_0 0.0267017f
C2147 S21_7 VSS_1 4.48808e-05f
C2148 S22 S23_7 0.00871643f
C2149 S22 S24_7 9.4713e-05f
C2150 S22 S25_7 5.45196e-05f
C2151 S22 S26_5 5.79043e-05f
C2152 S22 S27_5 4.36184e-05f
C2153 S22 S28_5 0.000244983f
C2154 S22 S29_6 0.000113766f
C2155 S22 S30_6 5.17159e-05f
C2156 S22 S31_6 1.81619e-05f
C2157 S22 S36_6 1.61765e-05f
C2158 S22 S37_6 1.93381e-05f
C2159 S22 VDD 0.00774498f
C2160 S22 VSS_0 0.0213479f
C2161 S22_1 S23_2 0.00494633f
C2162 S22_1 S24_6 5.37469e-05f
C2163 S22_1 S25_6 3.09384e-05f
C2164 S22_1 S26_5 3.2859e-05f
C2165 S22_1 S27_5 2.47522e-05f
C2166 S22_1 S28_5 0.000139021f
C2167 S22_1 S29_6 6.4559e-05f
C2168 S22_1 S30_6 2.93473e-05f
C2169 S22_1 S31_6 1.03064e-05f
C2170 S22_1 S37_6 1.09738e-05f
C2171 S22_1 VDD 0.00439506f
C2172 S22_1 VSS_0 0.0121143f
C2173 S22_2 S23_6 0.0111671f
C2174 S22_2 S24_6 0.000121342f
C2175 S22_2 S25_6 6.98483e-05f
C2176 S22_2 S26_5 7.41846e-05f
C2177 S22_2 S27_5 5.58821e-05f
C2178 S22_2 S28_5 0.000313862f
C2179 S22_2 S29 0.000145752f
C2180 S22_2 S30_6 6.62563e-05f
C2181 S22_2 S31_6 2.32683e-05f
C2182 S22_2 S36_6 2.07247e-05f
C2183 S22_2 S37_6 2.47751e-05f
C2184 S22_2 S38_6 1.11749e-05f
C2185 S22_2 VDD 0.00992255f
C2186 S22_2 VSS_0 0.02735f
C2187 S22_3 S23_6 0.0128599f
C2188 S22_3 S24_6 0.000139736f
C2189 S22_3 S25_6 8.04362e-05f
C2190 S22_3 S26_5 8.54298e-05f
C2191 S22_3 S27_5 6.43529e-05f
C2192 S22_3 S28_5 0.000361439f
C2193 S22_3 S29_6 0.000167846f
C2194 S22_3 S30_6 7.62996e-05f
C2195 S22_3 S31_6 2.67954e-05f
C2196 S22_3 S35_6 1.13158e-05f
C2197 S22_3 S36_6 2.38662e-05f
C2198 S22_3 S37_6 2.85306e-05f
C2199 S22_3 S38_6 1.28688e-05f
C2200 S22_3 VDD 0.0114267f
C2201 S22_3 VSS_0 0.0314958f
C2202 S22_4 S23_6 0.00507546f
C2203 S22_4 S24_6 5.51501e-05f
C2204 S22_4 S25_6 3.17461e-05f
C2205 S22_4 S26_5 3.37169e-05f
C2206 S22_4 S27_5 2.53984e-05f
C2207 S22_4 S28_5 0.00014265f
C2208 S22_4 S29_6 6.62444e-05f
C2209 S22_4 S30_6 3.01134e-05f
C2210 S22_4 S31_6 1.05754e-05f
C2211 S22_4 S37_6 1.12603e-05f
C2212 S22_4 VDD 0.0045098f
C2213 S22_4 VSS_0 0.0124306f
C2214 S22_5 S23_7 0.00507546f
C2215 S22_5 S24_7 5.51501e-05f
C2216 S22_5 S25_7 3.17461e-05f
C2217 S22_5 S26_5 3.37169e-05f
C2218 S22_5 S27_5 2.53984e-05f
C2219 S22_5 S28_5 0.00014265f
C2220 S22_5 S29_6 6.62444e-05f
C2221 S22_5 S30_6 3.01134e-05f
C2222 S22_5 S31_6 1.05754e-05f
C2223 S22_5 S37_6 1.12603e-05f
C2224 S22_5 VDD 0.0045098f
C2225 S22_5 VSS_0 0.0124306f
C2226 S22_6 S23_6 0.0110282f
C2227 S22_6 S24_6 0.000119833f
C2228 S22_6 S25_6 6.89792e-05f
C2229 S22_6 S26_5 7.32615e-05f
C2230 S22_6 S27_5 5.51868e-05f
C2231 S22_6 S28_5 0.000309957f
C2232 S22_6 S29_5 0.000143939f
C2233 S22_6 S30_6 6.54318e-05f
C2234 S22_6 S31_6 2.29788e-05f
C2235 S22_6 S36_6 2.04668e-05f
C2236 S22_6 S37_6 2.44669e-05f
C2237 S22_6 S38_6 1.10358e-05f
C2238 S22_6 VDD 0.00979908f
C2239 S22_6 VSS_0 0.0270097f
C2240 S22_7 S23_7 0.0110282f
C2241 S22_7 S24_7 0.000119833f
C2242 S22_7 S25_7 6.89792e-05f
C2243 S22_7 S26_5 7.32615e-05f
C2244 S22_7 S27_5 5.51868e-05f
C2245 S22_7 S28_5 0.000309957f
C2246 S22_7 S29_5 0.000143939f
C2247 S22_7 S30_6 6.54318e-05f
C2248 S22_7 S31_6 2.29788e-05f
C2249 S22_7 S36_6 2.04668e-05f
C2250 S22_7 S37_6 2.44669e-05f
C2251 S22_7 S38_6 1.10358e-05f
C2252 S22_7 VDD 0.00979908f
C2253 S22_7 VSS_0 0.0270097f
C2254 S23 S24_7 0.00878819f
C2255 S23 S25_7 0.000105481f
C2256 S23 S26_5 5.17331e-05f
C2257 S23 S27_5 0.00026043f
C2258 S23 S28_6 0.000162391f
C2259 S23 S29_6 9.70146e-05f
C2260 S23 S30_6 7.51805e-05f
C2261 S23 S35_6 2.15095e-05f
C2262 S23 S36_6 3.69693e-05f
C2263 S23 S37_6 4.05376e-05f
C2264 S23 S38_6 2.41322e-05f
C2265 S23 VDD 0.00760724f
C2266 S23 VSS_0 0.021521f
C2267 S23_1 S24_2 0.00498705f
C2268 S23_1 S25_6 5.98575e-05f
C2269 S23_1 S26_5 2.93571e-05f
C2270 S23_1 S27_5 0.000147787f
C2271 S23_1 S28_6 9.21521e-05f
C2272 S23_1 S29_6 5.50531e-05f
C2273 S23_1 S30_6 4.26628e-05f
C2274 S23_1 S35_6 1.22061e-05f
C2275 S23_1 S36_6 2.0979e-05f
C2276 S23_1 S37_6 2.30039e-05f
C2277 S23_1 S38_6 1.36943e-05f
C2278 S23_1 VDD 0.00431689f
C2279 S23_1 VSS_0 0.0122125f
C2280 S23_2 S24_6 0.0112591f
C2281 S23_2 S25_6 0.000135138f
C2282 S23_2 S26_5 6.62784e-05f
C2283 S23_2 S27_5 0.000333653f
C2284 S23_2 S28 0.000208048f
C2285 S23_2 S29_6 0.000124291f
C2286 S23_2 S30_6 9.63182e-05f
C2287 S23_2 S35_6 2.75571e-05f
C2288 S23_2 S36_6 4.73636e-05f
C2289 S23_2 S37_6 5.19351e-05f
C2290 S23_2 S38_6 3.09172e-05f
C2291 S23_2 VDD 0.00974608f
C2292 S23_2 VSS_0 0.0275718f
C2293 S23_3 S24_6 0.0129658f
C2294 S23_3 S25_6 0.000155623f
C2295 S23_3 S26_5 7.63251e-05f
C2296 S23_3 S27_5 0.000384229f
C2297 S23_3 S28_6 0.000239585f
C2298 S23_3 S29_6 0.000143132f
C2299 S23_3 S30_6 0.000110918f
C2300 S23_3 S35_6 3.17344e-05f
C2301 S23_3 S36_6 5.45431e-05f
C2302 S23_3 S37_6 5.98076e-05f
C2303 S23_3 S38_6 3.56037e-05f
C2304 S23_3 VDD 0.0112234f
C2305 S23_3 VSS_0 0.0317512f
C2306 S23_4 S24_6 0.00511724f
C2307 S23_4 S25_6 6.14202e-05f
C2308 S23_4 S26_5 3.01235e-05f
C2309 S23_4 S27_5 0.000151645f
C2310 S23_4 S28_6 9.45578e-05f
C2311 S23_4 S29_6 5.64903e-05f
C2312 S23_4 S30_6 4.37766e-05f
C2313 S23_4 S35_6 1.25247e-05f
C2314 S23_4 S36_6 2.15267e-05f
C2315 S23_4 S37_6 2.36045e-05f
C2316 S23_4 S38_6 1.40518e-05f
C2317 S23_4 VDD 0.00442959f
C2318 S23_4 VSS_0 0.0125314f
C2319 S23_5 S24_7 0.00511724f
C2320 S23_5 S25_7 6.14202e-05f
C2321 S23_5 S26_5 3.01235e-05f
C2322 S23_5 S27_5 0.000151645f
C2323 S23_5 S28_6 9.45578e-05f
C2324 S23_5 S29_6 5.64903e-05f
C2325 S23_5 S30_6 4.37766e-05f
C2326 S23_5 S35_6 1.25247e-05f
C2327 S23_5 S36_6 2.15267e-05f
C2328 S23_5 S37_6 2.36045e-05f
C2329 S23_5 S38_6 1.40518e-05f
C2330 S23_5 VDD 0.00442959f
C2331 S23_5 VSS_0 0.0125314f
C2332 S23_6 S24_6 0.011119f
C2333 S23_6 S25_6 0.000133456f
C2334 S23_6 S26_5 6.54536e-05f
C2335 S23_6 S27_5 0.000329501f
C2336 S23_6 S28_5 0.000205459f
C2337 S23_6 S29_6 0.000122745f
C2338 S23_6 S30_6 9.51197e-05f
C2339 S23_6 S35_6 2.72142e-05f
C2340 S23_6 S36_6 4.67742e-05f
C2341 S23_6 S37_6 5.12889e-05f
C2342 S23_6 S38_6 3.05325e-05f
C2343 S23_6 VDD 0.00962481f
C2344 S23_6 VSS_0 0.0272287f
C2345 S23_7 S24_7 0.011119f
C2346 S23_7 S25_7 0.000133456f
C2347 S23_7 S26_5 6.54536e-05f
C2348 S23_7 S27_5 0.000329501f
C2349 S23_7 S28_5 0.000205459f
C2350 S23_7 S29_6 0.000122745f
C2351 S23_7 S30_6 9.51197e-05f
C2352 S23_7 S35_6 2.72142e-05f
C2353 S23_7 S36_6 4.67742e-05f
C2354 S23_7 S37_6 5.12889e-05f
C2355 S23_7 S38_6 3.05325e-05f
C2356 S23_7 VDD 0.00962481f
C2357 S23_7 VSS_0 0.0272287f
C2358 S24 S25_7 0.00876268f
C2359 S24 S26_5 0.000222637f
C2360 S24 S27_6 0.000163387f
C2361 S24 S28_6 0.000138927f
C2362 S24 S29_6 0.000103752f
C2363 S24 S30_6 4.39992e-05f
C2364 S24 S35_6 3.08294e-05f
C2365 S24 S36_6 4.67676e-05f
C2366 S24 S37_6 5.18096e-05f
C2367 S24 S38_6 2.8256e-05f
C2368 S24 VDD 0.00763469f
C2369 S24 VSS_0 0.0215535f
C2370 S24_1 S25_2 0.00497257f
C2371 S24_1 S26_6 0.00012634f
C2372 S24_1 S27_6 9.27178e-05f
C2373 S24_1 S28_6 7.88371e-05f
C2374 S24_1 S29_6 5.88765e-05f
C2375 S24_1 S30_6 2.49683e-05f
C2376 S24_1 S35_6 1.74948e-05f
C2377 S24_1 S36_6 2.65393e-05f
C2378 S24_1 S37_6 2.94005e-05f
C2379 S24_1 S38_6 1.60345e-05f
C2380 S24_1 VDD 0.00433247f
C2381 S24_1 VSS_0 0.012231f
C2382 S24_2 S25_6 0.0112264f
C2383 S24_2 S26_5 0.000285233f
C2384 S24_2 S27 0.000209325f
C2385 S24_2 S28_6 0.000177988f
C2386 S24_2 S29_6 0.000132923f
C2387 S24_2 S30_6 5.637e-05f
C2388 S24_2 S34_6 1.17267e-05f
C2389 S24_2 S35_6 3.94974e-05f
C2390 S24_2 S36_6 5.99168e-05f
C2391 S24_2 S37_6 6.63763e-05f
C2392 S24_2 S38_6 3.62005e-05f
C2393 S24_2 VDD 0.00978126f
C2394 S24_2 VSS_0 0.0276135f
C2395 S24_3 S25_6 0.0129281f
C2396 S24_3 S26_5 0.00032847f
C2397 S24_3 S27_6 0.000241056f
C2398 S24_3 S28_6 0.000204968f
C2399 S24_3 S29_6 0.000153072f
C2400 S24_3 S30_6 6.49148e-05f
C2401 S24_3 S34_6 1.35043e-05f
C2402 S24_3 S35_6 4.54845e-05f
C2403 S24_3 S36_6 6.89992e-05f
C2404 S24_3 S37_6 7.64379e-05f
C2405 S24_3 S38_6 4.16879e-05f
C2406 S24_3 VDD 0.0112639f
C2407 S24_3 VSS_0 0.0317992f
C2408 S24_4 S25_6 0.00510239f
C2409 S24_4 S26_6 0.000129638f
C2410 S24_4 S27_6 9.51383e-05f
C2411 S24_4 S28_6 8.08953e-05f
C2412 S24_4 S29_6 6.04136e-05f
C2413 S24_4 S30_6 2.56202e-05f
C2414 S24_4 S35_6 1.79515e-05f
C2415 S24_4 S36_6 2.72322e-05f
C2416 S24_4 S37_6 3.0168e-05f
C2417 S24_4 S38_6 1.64531e-05f
C2418 S24_4 VDD 0.00444558f
C2419 S24_4 VSS_0 0.0125503f
C2420 S24_5 S25_7 0.00510239f
C2421 S24_5 S26_5 0.000129638f
C2422 S24_5 S27_6 9.51383e-05f
C2423 S24_5 S28_6 8.08953e-05f
C2424 S24_5 S29_6 6.04136e-05f
C2425 S24_5 S30_6 2.56202e-05f
C2426 S24_5 S35_6 1.79515e-05f
C2427 S24_5 S36_6 2.72322e-05f
C2428 S24_5 S37_6 3.0168e-05f
C2429 S24_5 S38_6 1.64531e-05f
C2430 S24_5 VDD 0.00444558f
C2431 S24_5 VSS_0 0.0125503f
C2432 S24_6 S25_6 0.0110867f
C2433 S24_6 S26_5 0.000281684f
C2434 S24_6 S27_5 0.000206721f
C2435 S24_6 S28_6 0.000175773f
C2436 S24_6 S29_6 0.000131269f
C2437 S24_6 S30_6 5.56686e-05f
C2438 S24_6 S34_6 1.15808e-05f
C2439 S24_6 S35_6 3.90059e-05f
C2440 S24_6 S36_6 5.91712e-05f
C2441 S24_6 S37_6 6.55504e-05f
C2442 S24_6 S38_6 3.575e-05f
C2443 S24_6 VDD 0.00965954f
C2444 S24_6 VSS_0 0.0272699f
C2445 S24_7 S25_7 0.0110867f
C2446 S24_7 S26_5 0.000281684f
C2447 S24_7 S27_5 0.000206721f
C2448 S24_7 S28_6 0.000175773f
C2449 S24_7 S29_6 0.000131269f
C2450 S24_7 S30_6 5.56686e-05f
C2451 S24_7 S34_6 1.15808e-05f
C2452 S24_7 S35_6 3.90059e-05f
C2453 S24_7 S36_6 5.91712e-05f
C2454 S24_7 S37_6 6.55504e-05f
C2455 S24_7 S38_6 3.575e-05f
C2456 S24_7 VDD 0.00965954f
C2457 S24_7 VSS_0 0.0272699f
C2458 S25 S26_7 0.0088116f
C2459 S25 S27_6 6.68674e-05f
C2460 S25 S28_6 8.8934e-05f
C2461 S25 S29_6 6.46777e-05f
C2462 S25 S30_6 1.79061e-05f
C2463 S25 S34_6 1.21624e-05f
C2464 S25 S35_6 2.59622e-05f
C2465 S25 S36_6 3.85082e-05f
C2466 S25 S37_6 3.89818e-05f
C2467 S25 S38_6 2.39942e-05f
C2468 S25 VDD 0.00787394f
C2469 S25 VSS_0 0.0213281f
C2470 S25_1 S26_2 0.00500033f
C2471 S25_1 S27_6 3.79453e-05f
C2472 S25_1 S28_6 5.04675e-05f
C2473 S25_1 S29_6 3.67028e-05f
C2474 S25_1 S30_6 1.01612e-05f
C2475 S25_1 S35_6 1.47328e-05f
C2476 S25_1 S36_6 2.18523e-05f
C2477 S25_1 S37_6 2.21211e-05f
C2478 S25_1 S38_6 1.3616e-05f
C2479 S25_1 VDD 0.00446824f
C2480 S25_1 VSS_0 0.0121031f
C2481 S25_2 S26_6 0.0112891f
C2482 S25_2 S27_6 8.56678e-05f
C2483 S25_2 S28_6 0.000113939f
C2484 S25_2 S29_6 8.28624e-05f
C2485 S25_2 S30_6 2.29405e-05f
C2486 S25_2 S34_6 1.55819e-05f
C2487 S25_2 S35_6 3.32617e-05f
C2488 S25_2 S36_6 4.93352e-05f
C2489 S25_2 S37_6 4.99419e-05f
C2490 S25_2 S38_6 3.07404e-05f
C2491 S25_2 VDD 0.0100878f
C2492 S25_2 VSS_0 0.0273248f
C2493 S25_3 S26_6 0.0130003f
C2494 S25_3 S27_6 9.86536e-05f
C2495 S25_3 S28_6 0.00013121f
C2496 S25_3 S29_6 9.5423e-05f
C2497 S25_3 S30_6 2.64179e-05f
C2498 S25_3 S34_6 1.79439e-05f
C2499 S25_3 S35_6 3.83037e-05f
C2500 S25_3 S36_6 5.68136e-05f
C2501 S25_3 S37_6 5.75123e-05f
C2502 S25_3 S38_6 3.54001e-05f
C2503 S25_3 S50_6 1.14543e-05f
C2504 S25_3 VDD 0.0116169f
C2505 S25_3 VSS_0 0.0314667f
C2506 S25_4 S26_6 0.00513087f
C2507 S25_4 S27_6 3.8936e-05f
C2508 S25_4 S28_6 5.17851e-05f
C2509 S25_4 S29_6 3.7661e-05f
C2510 S25_4 S30_6 1.04265e-05f
C2511 S25_4 S35_6 1.51174e-05f
C2512 S25_4 S36_6 2.24228e-05f
C2513 S25_4 S37_6 2.26986e-05f
C2514 S25_4 S38_6 1.39715e-05f
C2515 S25_4 VDD 0.00458489f
C2516 S25_4 VSS_0 0.0124191f
C2517 S25_5 S26_7 0.00513087f
C2518 S25_5 S27_6 3.8936e-05f
C2519 S25_5 S28_6 5.17851e-05f
C2520 S25_5 S29_6 3.7661e-05f
C2521 S25_5 S30_6 1.04265e-05f
C2522 S25_5 S35_6 1.51174e-05f
C2523 S25_5 S36_6 2.24228e-05f
C2524 S25_5 S37_6 2.26986e-05f
C2525 S25_5 S38_6 1.39715e-05f
C2526 S25_5 VDD 0.00458489f
C2527 S25_5 VSS_0 0.0124191f
C2528 S25_6 S26_6 0.0111486f
C2529 S25_6 S27_6 8.46018e-05f
C2530 S25_6 S28_6 0.000112521f
C2531 S25_6 S29_6 8.18313e-05f
C2532 S25_6 S2_2 1.19744e-05f
C2533 S25_6 S2_3 1.37896e-05f
C2534 S25_6 S2_6 1.18254e-05f
C2535 S25_6 S30_6 2.26551e-05f
C2536 S25_6 S34_6 1.5388e-05f
C2537 S25_6 S35_6 3.28478e-05f
C2538 S25_6 S36_6 4.87213e-05f
C2539 S25_6 S37_6 4.93204e-05f
C2540 S25_6 S38_6 3.03579e-05f
C2541 S25_6 VDD 0.00996225f
C2542 S25_6 VSS_0 0.0269847f
C2543 S25_7 S26_5 0.0111486f
C2544 S25_7 S27_6 8.46018e-05f
C2545 S25_7 S28_6 0.000112521f
C2546 S25_7 S29_6 8.18313e-05f
C2547 S25_7 S2_7 1.18254e-05f
C2548 S25_7 S30_6 2.26551e-05f
C2549 S25_7 S34_6 1.5388e-05f
C2550 S25_7 S35_6 3.28478e-05f
C2551 S25_7 S36_6 4.87213e-05f
C2552 S25_7 S37_6 4.93204e-05f
C2553 S25_7 S38_6 3.03579e-05f
C2554 S25_7 VDD 0.00996225f
C2555 S25_7 VSS_0 0.0269847f
C2556 S26 S27_6 0.00278797f
C2557 S26 S28_6 1.86544e-05f
C2558 S26 S29_6 1.97736e-05f
C2559 S26 S30_6 1.1249e-05f
C2560 S26 S36_6 1.23117e-05f
C2561 S26 S37_6 1.28553e-05f
C2562 S26 VDD 0.00267838f
C2563 S26 VSS_0 0.00596279f
C2564 S26 VSS_1 0.00185499f
C2565 S26_1 S27_3 0.00352144f
C2566 S26_1 S28_6 2.35621e-05f
C2567 S26_1 S29_6 2.49756e-05f
C2568 S26_1 S30_6 1.42084e-05f
C2569 S26_1 S35_6 1.07477e-05f
C2570 S26_1 S36_6 1.55506e-05f
C2571 S26_1 S37_6 1.62373e-05f
C2572 S26_1 S38_6 1.05472e-05f
C2573 S26_1 VDD 0.00338302f
C2574 S26_1 VSS_0 0.0075315f
C2575 S26_1 VSS_1 0.00234301f
C2576 S26_2 S27_6 0.0173034f
C2577 S26_2 S28_6 0.000115778f
C2578 S26_2 S29_6 0.000122724f
C2579 S26_2 S30_6 6.98165e-05f
C2580 S26_2 S34_6 2.80885e-05f
C2581 S26_2 S35_6 5.28114e-05f
C2582 S26_2 S36_6 7.64117e-05f
C2583 S26_2 S37_6 7.97857e-05f
C2584 S26_2 S38_6 5.18264e-05f
C2585 S26_2 S39_6 1.38759e-05f
C2586 S26_2 S45_6 1.22001e-05f
C2587 S26_2 S48_6 2.00169e-05f
C2588 S26_2 S49_6 1.24755e-05f
C2589 S26_2 VDD 0.0166232f
C2590 S26_2 VSS_0 0.0370078f
C2591 S26_2 VSS_1 0.0115129f
C2592 S26_3 S27_6 0.0158645f
C2593 S26_3 S28_6 0.00010615f
C2594 S26_3 S29_6 0.000112518f
C2595 S26_3 S30_6 6.40106e-05f
C2596 S26_3 S34_6 2.57527e-05f
C2597 S26_3 S35_6 4.84196e-05f
C2598 S26_3 S36_6 7.00573e-05f
C2599 S26_3 S37_6 7.31507e-05f
C2600 S26_3 S38_6 4.75165e-05f
C2601 S26_3 S39_6 1.2722e-05f
C2602 S26_3 S45_6 1.11855e-05f
C2603 S26_3 S48_6 1.83523e-05f
C2604 S26_3 S49_6 1.1438e-05f
C2605 S26_3 VDD 0.0152409f
C2606 S26_3 VSS_0 0.0339302f
C2607 S26_3 VSS_1 0.0105555f
C2608 S26_4 S27_7 0.00361337f
C2609 S26_4 S28_7 2.41772e-05f
C2610 S26_4 S29_7 2.56277e-05f
C2611 S26_4 S30_7 1.45794e-05f
C2612 S26_4 S35_7 1.10283e-05f
C2613 S26_4 S36_7 1.59566e-05f
C2614 S26_4 S37_7 1.66612e-05f
C2615 S26_4 S38_7 1.08226e-05f
C2616 S26_4 VDD 0.00347134f
C2617 S26_4 VSS_0 0.00772812f
C2618 S26_4 VSS_1 0.00240418f
C2619 S26_5 S27_6 0.00361337f
C2620 S26_5 S28_6 2.41772e-05f
C2621 S26_5 S29_6 2.56277e-05f
C2622 S26_5 S3 1.11313e-05f
C2623 S26_5 S30_6 1.45794e-05f
C2624 S26_5 S35_6 1.10283e-05f
C2625 S26_5 S36_6 1.59566e-05f
C2626 S26_5 S37_6 1.66612e-05f
C2627 S26_5 S38_6 1.08226e-05f
C2628 S26_5 S3_2 1.4261e-05f
C2629 S26_5 S3_3 1.64228e-05f
C2630 S26_5 S3_6 1.40836e-05f
C2631 S26_5 S3_7 1.40836e-05f
C2632 S26_5 VDD 0.00347134f
C2633 S26_5 VSS_0 0.00772812f
C2634 S26_5 VSS_1 0.00240418f
C2635 S26_6 S27_6 0.00785129f
C2636 S26_6 S28_6 5.25333e-05f
C2637 S26_6 S29_6 5.56849e-05f
C2638 S26_6 S30_6 3.16787e-05f
C2639 S26_6 S34_6 1.2745e-05f
C2640 S26_6 S35_6 2.39628e-05f
C2641 S26_6 S36_6 3.46712e-05f
C2642 S26_6 S37_6 3.62021e-05f
C2643 S26_6 S38_6 2.35158e-05f
C2644 S26_6 VDD 0.00754267f
C2645 S26_6 VSS_0 0.016792f
C2646 S26_6 VSS_1 0.0052239f
C2647 S26_7 S27_6 0.0163591f
C2648 S26_7 S28_6 0.000109459f
C2649 S26_7 S29_6 0.000116026f
C2650 S26_7 S30_6 6.60064e-05f
C2651 S26_7 S34_6 2.65556e-05f
C2652 S26_7 S35_6 4.99293e-05f
C2653 S26_7 S36_6 7.22417e-05f
C2654 S26_7 S37_6 7.54315e-05f
C2655 S26_7 S38_6 4.8998e-05f
C2656 S26_7 S39_6 1.31187e-05f
C2657 S26_7 S45_6 1.15343e-05f
C2658 S26_7 S48_6 1.89245e-05f
C2659 S26_7 S49_6 1.17946e-05f
C2660 S26_7 VDD 0.0157161f
C2661 S26_7 VSS_0 0.0349881f
C2662 S26_7 VSS_1 0.0108846f
C2663 S27 VDD 0.00772081f
C2664 S27 VSS_0 0.0134122f
C2665 S27 VSS_1 0.0078473f
C2666 S27_1 S28_1 0.00506734f
C2667 S27_1 S28_2 0.0131745f
C2668 S27_1 S28_3 0.0114403f
C2669 S27_1 S29_1 3.8893e-05f
C2670 S27_1 S29_2 0.000101117f
C2671 S27_1 S29_3 8.78072e-05f
C2672 S27_1 S30_1 2.7081e-05f
C2673 S27_1 S30_2 7.04075e-05f
C2674 S27_1 S30_3 6.11397e-05f
C2675 S27_1 S35_1 1.46611e-05f
C2676 S27_1 S35_2 3.81171e-05f
C2677 S27_1 S35_3 3.30997e-05f
C2678 S27_1 S36_1 2.62788e-05f
C2679 S27_1 S36_2 6.83218e-05f
C2680 S27_1 S36_3 5.93286e-05f
C2681 S27_1 S37_1 2.78435e-05f
C2682 S27_1 S37_2 7.23901e-05f
C2683 S27_1 S37_3 6.28613e-05f
C2684 S27_1 S38_1 1.59113e-05f
C2685 S27_1 S38_2 4.13674e-05f
C2686 S27_1 S38_3 3.59222e-05f
C2687 S27_1 VDD 0.00438134f
C2688 S27_1 VSS_0 0.00761102f
C2689 S27_1 VSS_1 0.00445312f
C2690 S27_2 VDD 0.011391f
C2691 S27_2 VSS_0 0.0197878f
C2692 S27_2 VSS_1 0.0115776f
C2693 S27_3 VDD 0.00989158f
C2694 S27_3 VSS_0 0.0171831f
C2695 S27_3 VSS_1 0.0100536f
C2696 S27_4 S28_4 0.00519964f
C2697 S27_4 S28_7 0.011298f
C2698 S27_4 S29_4 3.99083e-05f
C2699 S27_4 S29_7 8.67145e-05f
C2700 S27_4 S30_4 2.7788e-05f
C2701 S27_4 S30_7 6.03789e-05f
C2702 S27_4 S35_4 1.50438e-05f
C2703 S27_4 S35_7 3.26879e-05f
C2704 S27_4 S36_4 2.69648e-05f
C2705 S27_4 S36_7 5.85903e-05f
C2706 S27_4 S37_4 2.85705e-05f
C2707 S27_4 S37_7 6.20791e-05f
C2708 S27_4 S38_4 1.63266e-05f
C2709 S27_4 S38_7 3.54752e-05f
C2710 S27_4 VDD 0.00449572f
C2711 S27_4 VSS_0 0.00780972f
C2712 S27_4 VSS_1 0.00456938f
C2713 S27_5 S28 0.00892968f
C2714 S27_5 S28_5 0.00519964f
C2715 S27_5 S28_6 0.011298f
C2716 S27_5 S29 6.85373e-05f
C2717 S27_5 S29_5 3.99083e-05f
C2718 S27_5 S29_6 8.67145e-05f
C2719 S27_5 S30 4.77222e-05f
C2720 S27_5 S30_5 2.7788e-05f
C2721 S27_5 S30_6 6.03789e-05f
C2722 S27_5 S35 2.58358e-05f
C2723 S27_5 S35_5 1.50438e-05f
C2724 S27_5 S35_6 3.26879e-05f
C2725 S27_5 S36 4.63085e-05f
C2726 S27_5 S36_5 2.69648e-05f
C2727 S27_5 S36_6 5.85903e-05f
C2728 S27_5 S37 4.9066e-05f
C2729 S27_5 S37_5 2.85705e-05f
C2730 S27_5 S37_6 6.20791e-05f
C2731 S27_5 S38 2.80388e-05f
C2732 S27_5 S38_5 1.63266e-05f
C2733 S27_5 S38_6 3.54752e-05f
C2734 S27_5 VDD 0.00449572f
C2735 S27_5 VSS_0 0.00780972f
C2736 S27_5 VSS_1 0.00456938f
C2737 S27_6 VDD 0.0097685f
C2738 S27_6 VSS_0 0.0169693f
C2739 S27_6 VSS_1 0.00992855f
C2740 S27_7 VDD 0.0097685f
C2741 S27_7 VSS_0 0.0169693f
C2742 S27_7 VSS_1 0.00992855f
C2743 S28 VDD 0.00763545f
C2744 S28 VSS_0 0.0134974f
C2745 S28 VSS_1 0.00783569f
C2746 S28_1 S29_1 0.00504537f
C2747 S28_1 S29_2 0.0131174f
C2748 S28_1 S29_3 0.0113907f
C2749 S28_1 S30_1 2.11789e-05f
C2750 S28_1 S30_2 5.50628e-05f
C2751 S28_1 S30_3 4.78148e-05f
C2752 S28_1 S35_1 1.06469e-05f
C2753 S28_1 S35_2 2.76807e-05f
C2754 S28_1 S35_3 2.4037e-05f
C2755 S28_1 S36_1 1.90996e-05f
C2756 S28_1 S36_2 4.96569e-05f
C2757 S28_1 S36_3 4.31205e-05f
C2758 S28_1 S37_1 2.47801e-05f
C2759 S28_1 S37_2 6.44253e-05f
C2760 S28_1 S37_3 5.5945e-05f
C2761 S28_1 S38_1 1.29075e-05f
C2762 S28_1 S38_2 3.35581e-05f
C2763 S28_1 S38_3 2.91408e-05f
C2764 S28_1 VDD 0.0043329f
C2765 S28_1 VSS_0 0.00765938f
C2766 S28_1 VSS_1 0.00444654f
C2767 S28_2 VDD 0.011265f
C2768 S28_2 VSS_0 0.0199135f
C2769 S28_2 VSS_1 0.0115605f
C2770 S28_3 VDD 0.00978222f
C2771 S28_3 VSS_0 0.0172923f
C2772 S28_3 VSS_1 0.0100388f
C2773 S28_4 S29_4 0.00517709f
C2774 S28_4 S29_7 0.011249f
C2775 S28_4 S30_4 2.17318e-05f
C2776 S28_4 S30_7 4.72199e-05f
C2777 S28_4 S35_4 1.09248e-05f
C2778 S28_4 S35_7 2.37379e-05f
C2779 S28_4 S36_4 1.95983e-05f
C2780 S28_4 S36_7 4.2584e-05f
C2781 S28_4 S37_4 2.5427e-05f
C2782 S28_4 S37_7 5.52488e-05f
C2783 S28_4 S38_4 1.32445e-05f
C2784 S28_4 S38_7 2.87782e-05f
C2785 S28_4 VDD 0.00444602f
C2786 S28_4 VSS_0 0.00785934f
C2787 S28_4 VSS_1 0.00456262f
C2788 S28_5 S29 0.00889096f
C2789 S28_5 S29_5 0.00517709f
C2790 S28_5 S29_6 0.011249f
C2791 S28_5 S30 3.73215e-05f
C2792 S28_5 S30_5 2.17318e-05f
C2793 S28_5 S30_6 4.72199e-05f
C2794 S28_5 S35 1.87619e-05f
C2795 S28_5 S35_5 1.09248e-05f
C2796 S28_5 S35_6 2.37379e-05f
C2797 S28_5 S36 3.36574e-05f
C2798 S28_5 S36_5 1.95983e-05f
C2799 S28_5 S36_6 4.2584e-05f
C2800 S28_5 S37 4.36675e-05f
C2801 S28_5 S37_5 2.5427e-05f
C2802 S28_5 S37_6 5.52488e-05f
C2803 S28_5 S38 2.27457e-05f
C2804 S28_5 S38_5 1.32445e-05f
C2805 S28_5 S38_6 2.87782e-05f
C2806 S28_5 VDD 0.00444602f
C2807 S28_5 VSS_0 0.00785934f
C2808 S28_5 VSS_1 0.00456262f
C2809 S28_6 VDD 0.0096605f
C2810 S28_6 VSS_0 0.0170771f
C2811 S28_6 VSS_1 0.00991386f
C2812 S28_7 VDD 0.0096605f
C2813 S28_7 VSS_0 0.0170771f
C2814 S28_7 VSS_1 0.00991386f
C2815 S29 VDD 0.00781506f
C2816 S29 VSS_0 0.013274f
C2817 S29 VSS_1 0.00794984f
C2818 S29_1 S30_1 0.00498407f
C2819 S29_1 S30_2 0.012958f
C2820 S29_1 S30_3 0.0112524f
C2821 S29_1 S31_1 2.23084e-05f
C2822 S29_1 S31_2 5.79994e-05f
C2823 S29_1 S31_3 5.03649e-05f
C2824 S29_1 S36_2 2.21294e-05f
C2825 S29_1 S36_3 1.92165e-05f
C2826 S29_1 S37_1 1.16437e-05f
C2827 S29_1 S37_2 3.02723e-05f
C2828 S29_1 S37_3 2.62876e-05f
C2829 S29_1 S38_2 1.63464e-05f
C2830 S29_1 S38_3 1.41947e-05f
C2831 S29_1 VDD 0.00443482f
C2832 S29_1 VSS_0 0.00753259f
C2833 S29_1 VSS_1 0.00451131f
C2834 S29_2 VDD 0.01153f
C2835 S29_2 VSS_0 0.0195839f
C2836 S29_2 VSS_1 0.0117289f
C2837 S29_3 VDD 0.0100123f
C2838 S29_3 VSS_0 0.017006f
C2839 S29_3 VSS_1 0.010185f
C2840 S29_4 S30_4 0.00511419f
C2841 S29_4 S30_7 0.0111123f
C2842 S29_4 S31_4 2.28908e-05f
C2843 S29_4 S31_7 4.97381e-05f
C2844 S29_4 S36_7 1.89774e-05f
C2845 S29_4 S37_4 1.19477e-05f
C2846 S29_4 S37_7 2.59605e-05f
C2847 S29_4 S38_7 1.40181e-05f
C2848 S29_4 VDD 0.0045506f
C2849 S29_4 VSS_0 0.00772924f
C2850 S29_4 VSS_1 0.00462909f
C2851 S29_5 S30 0.00878294f
C2852 S29_5 S30_5 0.00511419f
C2853 S29_5 S30_6 0.0111123f
C2854 S29_5 S31 3.93119e-05f
C2855 S29_5 S31_5 2.28908e-05f
C2856 S29_5 S31_6 4.97381e-05f
C2857 S29_5 S36 1.49993e-05f
C2858 S29_5 S36_6 1.89774e-05f
C2859 S29_5 S37 2.05186e-05f
C2860 S29_5 S37_5 1.19477e-05f
C2861 S29_5 S37_6 2.59605e-05f
C2862 S29_5 S38 1.10796e-05f
C2863 S29_5 S38_6 1.40181e-05f
C2864 S29_5 VDD 0.0045506f
C2865 S29_5 VSS_0 0.00772924f
C2866 S29_5 VSS_1 0.00462909f
C2867 S29_6 VDD 0.00988775f
C2868 S29_6 VSS_0 0.0167944f
C2869 S29_6 VSS_1 0.0100583f
C2870 S29_7 VDD 0.00988775f
C2871 S29_7 VSS_0 0.0167944f
C2872 S29_7 VSS_1 0.0100583f
C2873 S2_1 S39_5 1.54027e-05f
C2874 S2_1 S3_2 0.00503207f
C2875 S2_1 S40_5 1.29833e-05f
C2876 S2_1 S46_5 1.88615e-05f
C2877 S2_1 S47_5 2.53319e-05f
C2878 S2_1 S48_5 0.000144614f
C2879 S2_1 S49_6 8.42832e-05f
C2880 S2_1 S4_6 5.17368e-05f
C2881 S2_1 S50_6 5.83318e-05f
C2882 S2_1 VDD 0.00431335f
C2883 S2_1 VSS_0 0.0121737f
C2884 S2_2 S38_5 1.46106e-05f
C2885 S2_2 S39_5 3.4774e-05f
C2886 S2_2 S3_6 0.0113607f
C2887 S2_2 S40_5 2.93118e-05f
C2888 S2_2 S41_5 1.4156e-05f
C2889 S2_2 S46_5 4.25829e-05f
C2890 S2_2 S47_5 5.71908e-05f
C2891 S2_2 S48_5 0.00032649f
C2892 S2_2 S49 0.000190283f
C2893 S2_2 S4_6 0.000116804f
C2894 S2_2 S50_6 0.000131693f
C2895 S2_2 S5_6 2.22953e-05f
C2896 S2_2 S6_6 1.28146e-05f
C2897 S2_2 VDD 0.0097381f
C2898 S2_2 VSS_0 0.027484f
C2899 S2_3 S38_5 1.68253e-05f
C2900 S2_3 S39_5 4.00452e-05f
C2901 S2_3 S3_6 0.0130828f
C2902 S2_3 S40_5 3.3755e-05f
C2903 S2_3 S41_5 1.63019e-05f
C2904 S2_3 S46_5 4.90378e-05f
C2905 S2_3 S47_5 6.586e-05f
C2906 S2_3 S48_5 0.000375981f
C2907 S2_3 S49_6 0.000219127f
C2908 S2_3 S4_6 0.00013451f
C2909 S2_3 S50_6 0.000151656f
C2910 S2_3 S5_6 2.56749e-05f
C2911 S2_3 S6_6 1.4757e-05f
C2912 S2_3 VDD 0.0112142f
C2913 S2_3 VSS_0 0.0316501f
C2914 S2_4 S39_5 1.58048e-05f
C2915 S2_4 S3_6 0.00516344f
C2916 S2_4 S40_5 1.33222e-05f
C2917 S2_4 S46_5 1.93539e-05f
C2918 S2_4 S47_5 2.59932e-05f
C2919 S2_4 S48_5 0.00014839f
C2920 S2_4 S49_6 8.64836e-05f
C2921 S2_4 S4_6 5.30875e-05f
C2922 S2_4 S50_6 5.98546e-05f
C2923 S2_4 S5_6 1.01332e-05f
C2924 S2_4 VDD 0.00442596f
C2925 S2_4 VSS_0 0.0124915f
C2926 S2_5 S39_5 1.58048e-05f
C2927 S2_5 S3_7 0.00516344f
C2928 S2_5 S40_5 1.33222e-05f
C2929 S2_5 S46_5 1.93539e-05f
C2930 S2_5 S47_5 2.59932e-05f
C2931 S2_5 S48_5 0.00014839f
C2932 S2_5 S49_6 8.64836e-05f
C2933 S2_5 S4_7 5.30875e-05f
C2934 S2_5 S50_6 5.98546e-05f
C2935 S2_5 S5_7 1.01332e-05f
C2936 S2_5 VDD 0.00442596f
C2937 S2_5 VSS_0 0.0124915f
C2938 S2_6 S38_5 1.44288e-05f
C2939 S2_6 S39_5 3.43413e-05f
C2940 S2_6 S3_6 0.0112193f
C2941 S2_6 S40_5 2.89471e-05f
C2942 S2_6 S41_5 1.39799e-05f
C2943 S2_6 S46_5 4.2053e-05f
C2944 S2_6 S47_5 5.64792e-05f
C2945 S2_6 S48_5 0.000322428f
C2946 S2_6 S49_5 0.000187915f
C2947 S2_6 S4_6 0.000115351f
C2948 S2_6 S50_6 0.000130055f
C2949 S2_6 S5_6 2.20179e-05f
C2950 S2_6 S6_6 1.26551e-05f
C2951 S2_6 VDD 0.00961692f
C2952 S2_6 VSS_0 0.027142f
C2953 S2_7 S38_5 1.44288e-05f
C2954 S2_7 S39_5 3.43413e-05f
C2955 S2_7 S3_7 0.0112193f
C2956 S2_7 S40_5 2.89471e-05f
C2957 S2_7 S41_5 1.39799e-05f
C2958 S2_7 S46_5 4.2053e-05f
C2959 S2_7 S47_5 5.64792e-05f
C2960 S2_7 S48_5 0.000322428f
C2961 S2_7 S49_5 0.000187915f
C2962 S2_7 S4_7 0.000115351f
C2963 S2_7 S50_6 0.000130055f
C2964 S2_7 S5_7 2.20179e-05f
C2965 S2_7 S6_7 1.26551e-05f
C2966 S2_7 VDD 0.00961692f
C2967 S2_7 VSS_0 0.027142f
C2968 S3 S39_5 1.20266e-05f
C2969 S3 S47_5 0.000216251f
C2970 S3 S48_6 0.000112143f
C2971 S3 S49_6 9.60149e-05f
C2972 S3 S4_7 0.0087849f
C2973 S3 S50_6 8.28544e-05f
C2974 S3 S5_7 7.56788e-05f
C2975 S3 S6_7 1.05897e-05f
C2976 S3 VDD 0.00769103f
C2977 S3 VSS_0 0.0213469f
C2978 S30 VDD 0.00802107f
C2979 S30 VSS_0 0.0131666f
C2980 S30 VSS_1 0.00807532f
C2981 S30_1 S31_1 0.00499173f
C2982 S30_1 S31_2 0.0129779f
C2983 S30_1 S31_3 0.0112696f
C2984 S30_1 S32_1 1.11966e-05f
C2985 S30_1 S32_2 2.91098e-05f
C2986 S30_1 S32_3 2.52781e-05f
C2987 S30_1 VDD 0.00455173f
C2988 S30_1 VSS_0 0.00747168f
C2989 S30_1 VSS_1 0.00458252f
C2990 S30_2 VDD 0.011834f
C2991 S30_2 VSS_0 0.0194255f
C2992 S30_2 VSS_1 0.011914f
C2993 S30_3 VDD 0.0102763f
C2994 S30_3 VSS_0 0.0168685f
C2995 S30_3 VSS_1 0.0103458f
C2996 S30_4 S31_4 0.00512205f
C2997 S30_4 S31_7 0.0111294f
C2998 S30_4 S32_4 1.14889e-05f
C2999 S30_4 S32_7 2.49635e-05f
C3000 S30_4 VDD 0.00467056f
C3001 S30_4 VSS_0 0.00766674f
C3002 S30_4 VSS_1 0.00470215f
C3003 S30_5 S31 0.00879644f
C3004 S30_5 S31_5 0.00512205f
C3005 S30_5 S31_6 0.0111294f
C3006 S30_5 S32 1.97306e-05f
C3007 S30_5 S32_5 1.14889e-05f
C3008 S30_5 S32_6 2.49635e-05f
C3009 S30_5 VDD 0.00467056f
C3010 S30_5 VSS_0 0.00766674f
C3011 S30_5 VSS_1 0.00470215f
C3012 S30_6 VDD 0.0101484f
C3013 S30_6 VSS_0 0.0166586f
C3014 S30_6 VSS_1 0.010217f
C3015 S30_7 VDD 0.0101484f
C3016 S30_7 VSS_0 0.0166586f
C3017 S30_7 VSS_1 0.010217f
C3018 S31 VDD 0.00827447f
C3019 S31 VSS_0 0.0132401f
C3020 S31 VSS_1 0.00824384f
C3021 S31_1 S32_1 0.00502813f
C3022 S31_1 S32_2 0.0130726f
C3023 S31_1 S32_3 0.0113518f
C3024 S31_1 S33_1 2.28825e-05f
C3025 S31_1 S33_2 5.9492e-05f
C3026 S31_1 S33_3 5.1661e-05f
C3027 S31_1 VDD 0.00469553f
C3028 S31_1 VSS_0 0.00751338f
C3029 S31_1 VSS_1 0.00467815f
C3030 S31_2 VDD 0.0122078f
C3031 S31_2 VSS_0 0.0195339f
C3032 S31_2 VSS_1 0.0121627f
C3033 S31_3 VDD 0.0106009f
C3034 S31_3 VSS_0 0.0169627f
C3035 S31_3 VSS_1 0.0105617f
C3036 S31_4 S32_4 0.0051594f
C3037 S31_4 S32_7 0.0112106f
C3038 S31_4 S33_4 2.34799e-05f
C3039 S31_4 S33_7 5.10182e-05f
C3040 S31_4 VDD 0.00481811f
C3041 S31_4 VSS_0 0.00770953f
C3042 S31_4 VSS_1 0.00480028f
C3043 S31_5 S32 0.00886059f
C3044 S31_5 S32_5 0.0051594f
C3045 S31_5 S32_6 0.0112106f
C3046 S31_5 S33 4.03237e-05f
C3047 S31_5 S33_5 2.34799e-05f
C3048 S31_5 S33_6 5.10182e-05f
C3049 S31_5 VDD 0.00481811f
C3050 S31_5 VSS_0 0.00770953f
C3051 S31_5 VSS_1 0.00480028f
C3052 S31_6 VDD 0.010469f
C3053 S31_6 VSS_0 0.0167516f
C3054 S31_6 VSS_1 0.0104303f
C3055 S31_7 VDD 0.010469f
C3056 S31_7 VSS_0 0.0167516f
C3057 S31_7 VSS_1 0.0104303f
C3058 S32 VDD 0.00832125f
C3059 S32 VSS_0 0.0132859f
C3060 S32 VSS_1 0.0081609f
C3061 S32_1 S33_1 0.00502782f
C3062 S32_1 S33_2 0.0130718f
C3063 S32_1 S33_3 0.0113511f
C3064 S32_1 S34_1 1.88248e-05f
C3065 S32_1 S34_2 4.89424e-05f
C3066 S32_1 S34_3 4.25001e-05f
C3067 S32_1 VDD 0.00472208f
C3068 S32_1 VSS_0 0.00753935f
C3069 S32_1 VSS_1 0.00463108f
C3070 S32_2 VDD 0.0122769f
C3071 S32_2 VSS_0 0.0196015f
C3072 S32_2 VSS_1 0.0120403f
C3073 S32_3 VDD 0.0106609f
C3074 S32_3 VSS_0 0.0170213f
C3075 S32_3 VSS_1 0.0104554f
C3076 S32_4 S33_4 0.00515908f
C3077 S32_4 S33_7 0.0112099f
C3078 S32_4 S34_4 1.93163e-05f
C3079 S32_4 S34_7 4.19712e-05f
C3080 S32_4 VDD 0.00484536f
C3081 S32_4 VSS_0 0.00773618f
C3082 S32_4 VSS_1 0.00475198f
C3083 S32_5 S33 0.00886004f
C3084 S32_5 S33_5 0.00515908f
C3085 S32_5 S33_6 0.0112099f
C3086 S32_5 S34 3.31731e-05f
C3087 S32_5 S34_5 1.93163e-05f
C3088 S32_5 S34_6 4.19712e-05f
C3089 S32_5 VDD 0.00484536f
C3090 S32_5 VSS_0 0.00773618f
C3091 S32_5 VSS_1 0.00475198f
C3092 S32_6 VDD 0.0105282f
C3093 S32_6 VSS_0 0.0168095f
C3094 S32_6 VSS_1 0.0103253f
C3095 S32_7 VDD 0.0105282f
C3096 S32_7 VSS_0 0.0168095f
C3097 S32_7 VSS_1 0.0103253f
C3098 S33 VDD 0.00809328f
C3099 S33 VSS_0 0.0131721f
C3100 S33 VSS_1 0.00809118f
C3101 S33_1 S34_1 0.00498554f
C3102 S33_1 S34_2 0.0129618f
C3103 S33_1 S34_3 0.0112557f
C3104 S33_1 S35_2 2.22003e-05f
C3105 S33_1 S35_3 1.9278e-05f
C3106 S33_1 S36_1 1.33894e-05f
C3107 S33_1 S36_2 3.4811e-05f
C3108 S33_1 S36_3 3.02288e-05f
C3109 S33_1 S38_2 1.29226e-05f
C3110 S33_1 S38_3 1.12216e-05f
C3111 S33_1 S39_2 1.18028e-05f
C3112 S33_1 S39_3 1.02492e-05f
C3113 S33_1 VDD 0.00459271f
C3114 S33_1 VSS_0 0.00747478f
C3115 S33_1 VSS_1 0.00459151f
C3116 S33_2 VDD 0.0119405f
C3117 S33_2 VSS_0 0.0194336f
C3118 S33_2 VSS_1 0.0119374f
C3119 S33_3 VDD 0.0103688f
C3120 S33_3 VSS_0 0.0168755f
C3121 S33_3 VSS_1 0.0103661f
C3122 S33_4 S34_4 0.0051157f
C3123 S33_4 S34_7 0.0111156f
C3124 S33_4 S35_7 1.90382e-05f
C3125 S33_4 S36_4 1.3739e-05f
C3126 S33_4 S36_7 2.98527e-05f
C3127 S33_4 S38_7 1.1082e-05f
C3128 S33_4 S39_7 1.01217e-05f
C3129 S33_4 VDD 0.00471261f
C3130 S33_4 VSS_0 0.00766993f
C3131 S33_4 VSS_1 0.00471138f
C3132 S33_5 S34 0.00878553f
C3133 S33_5 S34_5 0.0051157f
C3134 S33_5 S34_6 0.0111156f
C3135 S33_5 S35 1.50473e-05f
C3136 S33_5 S35_6 1.90382e-05f
C3137 S33_5 S36 2.35949e-05f
C3138 S33_5 S36_5 1.3739e-05f
C3139 S33_5 S36_6 2.98527e-05f
C3140 S33_5 S38_6 1.1082e-05f
C3141 S33_5 S39_6 1.01217e-05f
C3142 S33_5 VDD 0.00471261f
C3143 S33_5 VSS_0 0.00766993f
C3144 S33_5 VSS_1 0.00471138f
C3145 S33_6 VDD 0.0102398f
C3146 S33_6 VSS_0 0.0166655f
C3147 S33_6 VSS_1 0.0102371f
C3148 S33_7 VDD 0.0102398f
C3149 S33_7 VSS_0 0.0166655f
C3150 S33_7 VSS_1 0.0102371f
C3151 S34 VDD 0.00769717f
C3152 S34 VSS_0 0.0131416f
C3153 S34 VSS_1 0.00796499f
C3154 S34_1 S35_1 0.00501848f
C3155 S34_1 S35_2 0.0130475f
C3156 S34_1 S35_3 0.01133f
C3157 S34_1 S36_1 5.45889e-05f
C3158 S34_1 S36_2 0.000141925f
C3159 S34_1 S36_3 0.000123243f
C3160 S34_1 S37_1 5.32821e-05f
C3161 S34_1 S37_2 0.000138527f
C3162 S34_1 S37_3 0.000120293f
C3163 S34_1 S38_1 2.80015e-05f
C3164 S34_1 S38_2 7.28007e-05f
C3165 S34_1 S38_3 6.32179e-05f
C3166 S34_1 S39_1 1.74274e-05f
C3167 S34_1 S39_2 4.53093e-05f
C3168 S34_1 S39_3 3.93452e-05f
C3169 S34_1 S40_2 2.18312e-05f
C3170 S34_1 S40_3 1.89575e-05f
C3171 S34_1 S41_2 1.223e-05f
C3172 S34_1 S41_3 1.06201e-05f
C3173 S34_1 VDD 0.00436793f
C3174 S34_1 VSS_0 0.00745751f
C3175 S34_1 VSS_1 0.00451991f
C3176 S34_2 VDD 0.0113561f
C3177 S34_2 VSS_0 0.0193887f
C3178 S34_2 VSS_1 0.0117513f
C3179 S34_3 VDD 0.0098613f
C3180 S34_3 VSS_0 0.0168365f
C3181 S34_3 VSS_1 0.0102044f
C3182 S34_4 S35_4 0.0051495f
C3183 S34_4 S35_7 0.011189f
C3184 S34_4 S36_4 5.60141e-05f
C3185 S34_4 S36_7 0.00012171f
C3186 S34_4 S37_4 5.46731e-05f
C3187 S34_4 S37_7 0.000118796f
C3188 S34_4 S38_4 2.87325e-05f
C3189 S34_4 S38_7 6.24313e-05f
C3190 S34_4 S39_4 1.78824e-05f
C3191 S34_4 S39_7 3.88556e-05f
C3192 S34_4 S40_7 1.87216e-05f
C3193 S34_4 S41_7 1.0488e-05f
C3194 S34_4 VDD 0.00448196f
C3195 S34_4 VSS_0 0.0076522f
C3196 S34_4 VSS_1 0.00463791f
C3197 S34_5 S35 0.00884358f
C3198 S34_5 S35_5 0.0051495f
C3199 S34_5 S35_6 0.011189f
C3200 S34_5 S36 9.61967e-05f
C3201 S34_5 S36_5 5.60141e-05f
C3202 S34_5 S36_6 0.00012171f
C3203 S34_5 S37 9.38939e-05f
C3204 S34_5 S37_5 5.46731e-05f
C3205 S34_5 S37_6 0.000118796f
C3206 S34_5 S38 4.93443e-05f
C3207 S34_5 S38_5 2.87325e-05f
C3208 S34_5 S38_6 6.24313e-05f
C3209 S34_5 S39 3.07106e-05f
C3210 S34_5 S39_5 1.78824e-05f
C3211 S34_5 S39_6 3.88556e-05f
C3212 S34_5 S40 1.47972e-05f
C3213 S34_5 S40_6 1.87216e-05f
C3214 S34_5 S41_6 1.0488e-05f
C3215 S34_5 VDD 0.00448196f
C3216 S34_5 VSS_0 0.0076522f
C3217 S34_5 VSS_1 0.00463791f
C3218 S34_6 VDD 0.00973859f
C3219 S34_6 VSS_0 0.016627f
C3220 S34_6 VSS_1 0.0100774f
C3221 S34_7 VDD 0.00973859f
C3222 S34_7 VSS_0 0.016627f
C3223 S34_7 VSS_1 0.0100774f
C3224 S35 VDD 0.00744765f
C3225 S35 VSS_0 0.0133026f
C3226 S35 VSS_1 0.00782856f
C3227 S35_1 S36_1 0.00507458f
C3228 S35_1 S36_2 0.0131933f
C3229 S35_1 S36_3 0.0114567f
C3230 S35_1 S37_1 6.68132e-05f
C3231 S35_1 S37_2 0.000173707f
C3232 S35_1 S37_3 0.000150842f
C3233 S35_1 S38_1 5.04508e-05f
C3234 S35_1 S38_2 0.000131166f
C3235 S35_1 S38_3 0.000113901f
C3236 S35_1 S39_1 2.00034e-05f
C3237 S35_1 S39_2 5.20066e-05f
C3238 S35_1 S39_3 4.5161e-05f
C3239 S35_1 S40_1 1.66915e-05f
C3240 S35_1 S40_2 4.3396e-05f
C3241 S35_1 S40_3 3.76838e-05f
C3242 S35_1 S41_1 1.08207e-05f
C3243 S35_1 S41_2 2.81326e-05f
C3244 S35_1 S41_3 2.44295e-05f
C3245 S35_1 S42_2 1.40824e-05f
C3246 S35_1 S42_3 1.22288e-05f
C3247 S35_1 VDD 0.00422633f
C3248 S35_1 VSS_0 0.00754885f
C3249 S35_1 VSS_1 0.00444249f
C3250 S35_2 VDD 0.010988f
C3251 S35_2 VSS_0 0.0196261f
C3252 S35_2 VSS_1 0.01155f
C3253 S35_3 VDD 0.00954162f
C3254 S35_3 VSS_0 0.0170427f
C3255 S35_3 VSS_1 0.0100296f
C3256 S35_4 S36_4 0.00520706f
C3257 S35_4 S36_7 0.0113141f
C3258 S35_4 S37_4 6.85574e-05f
C3259 S35_4 S37_7 0.000148965f
C3260 S35_4 S38_4 5.1768e-05f
C3261 S35_4 S38_7 0.000112484f
C3262 S35_4 S39_4 2.05257e-05f
C3263 S35_4 S39_7 4.4599e-05f
C3264 S35_4 S40_4 1.71273e-05f
C3265 S35_4 S40_7 3.72149e-05f
C3266 S35_4 S41_4 1.11032e-05f
C3267 S35_4 S41_7 2.41255e-05f
C3268 S35_4 S42_7 1.20766e-05f
C3269 S35_4 VDD 0.00433667f
C3270 S35_4 VSS_0 0.00774592f
C3271 S35_4 VSS_1 0.00455847f
C3272 S35_5 S36 0.00894243f
C3273 S35_5 S36_5 0.00520706f
C3274 S35_5 S36_6 0.0113141f
C3275 S35_5 S37 0.000117738f
C3276 S35_5 S37_5 6.85574e-05f
C3277 S35_5 S37_6 0.000148965f
C3278 S35_5 S38 8.89046e-05f
C3279 S35_5 S38_5 5.1768e-05f
C3280 S35_5 S38_6 0.000112484f
C3281 S35_5 S39 3.52501e-05f
C3282 S35_5 S39_5 2.05257e-05f
C3283 S35_5 S39_6 4.4599e-05f
C3284 S35_5 S40 2.94138e-05f
C3285 S35_5 S40_5 1.71273e-05f
C3286 S35_5 S40_6 3.72149e-05f
C3287 S35_5 S41 1.90683e-05f
C3288 S35_5 S41_5 1.11032e-05f
C3289 S35_5 S41_6 2.41255e-05f
C3290 S35_5 S42_6 1.20766e-05f
C3291 S35_5 S9 1.07259e-05f
C3292 S35_5 S9_2 1.37416e-05f
C3293 S35_5 S9_3 1.58247e-05f
C3294 S35_5 S9_6 1.35706e-05f
C3295 S35_5 S9_7 1.35706e-05f
C3296 S35_5 VDD 0.00433667f
C3297 S35_5 VSS_0 0.00774592f
C3298 S35_5 VSS_1 0.00455847f
C3299 S35_6 VDD 0.00942289f
C3300 S35_6 VSS_0 0.0168307f
C3301 S35_6 VSS_1 0.00990483f
C3302 S35_7 VDD 0.00942289f
C3303 S35_7 VSS_0 0.0168307f
C3304 S35_7 VSS_1 0.00990483f
C3305 S36 VDD 0.00729045f
C3306 S36 VSS_0 0.0135366f
C3307 S36 VSS_1 0.00781809f
C3308 S36_1 S37_1 0.00506767f
C3309 S36_1 S37_2 0.0131754f
C3310 S36_1 S37_3 0.0114411f
C3311 S36_1 S38_1 5.6911e-05f
C3312 S36_1 S38_2 0.000147962f
C3313 S36_1 S38_3 0.000128486f
C3314 S36_1 S39_1 3.87283e-05f
C3315 S36_1 S39_2 0.000100689f
C3316 S36_1 S39_3 8.74353e-05f
C3317 S36_1 S40_1 1.97938e-05f
C3318 S36_1 S40_2 5.14616e-05f
C3319 S36_1 S40_3 4.46877e-05f
C3320 S36_1 S41_1 1.74647e-05f
C3321 S36_1 S41_2 4.54062e-05f
C3322 S36_1 S41_3 3.94294e-05f
C3323 S36_1 S42_2 2.25828e-05f
C3324 S36_1 S42_3 1.96102e-05f
C3325 S36_1 VDD 0.00413712f
C3326 S36_1 VSS_0 0.00768166f
C3327 S36_1 VSS_1 0.00443655f
C3328 S36_2 VDD 0.010756f
C3329 S36_2 VSS_0 0.0199714f
C3330 S36_2 VSS_1 0.0115345f
C3331 S36_3 VDD 0.00934022f
C3332 S36_3 VSS_0 0.0173426f
C3333 S36_3 VSS_1 0.0100162f
C3334 S36_4 S37_4 0.00519997f
C3335 S36_4 S37_7 0.0112987f
C3336 S36_4 S38_4 5.83968e-05f
C3337 S36_4 S38_7 0.000126887f
C3338 S36_4 S39_4 3.97393e-05f
C3339 S36_4 S39_7 8.63473e-05f
C3340 S36_4 S40_4 2.03105e-05f
C3341 S36_4 S40_7 4.41316e-05f
C3342 S36_4 S41_4 1.79206e-05f
C3343 S36_4 S41_7 3.89388e-05f
C3344 S36_4 S42_7 1.93662e-05f
C3345 S36_4 VDD 0.00424513f
C3346 S36_4 VSS_0 0.0078822f
C3347 S36_4 VSS_1 0.00455237f
C3348 S36_5 S37 0.00893026f
C3349 S36_5 S37_5 0.00519997f
C3350 S36_5 S37_6 0.0112987f
C3351 S36_5 S38 0.000100289f
C3352 S36_5 S38_5 5.83968e-05f
C3353 S36_5 S38_6 0.000126887f
C3354 S36_5 S39 6.8247e-05f
C3355 S36_5 S39_5 3.97393e-05f
C3356 S36_5 S39_6 8.63473e-05f
C3357 S36_5 S40 3.48807e-05f
C3358 S36_5 S40_5 2.03105e-05f
C3359 S36_5 S40_6 4.41316e-05f
C3360 S36_5 S41 3.07763e-05f
C3361 S36_5 S41_5 1.79206e-05f
C3362 S36_5 S41_6 3.89388e-05f
C3363 S36_5 S42 1.53066e-05f
C3364 S36_5 S42_6 1.93662e-05f
C3365 S36_5 S7_3 1.01253e-05f
C3366 S36_5 S8_2 1.19111e-05f
C3367 S36_5 S8_3 1.37166e-05f
C3368 S36_5 S8_6 1.17629e-05f
C3369 S36_5 S8_7 1.17629e-05f
C3370 S36_5 S9 1.41726e-05f
C3371 S36_5 S9_2 1.81573e-05f
C3372 S36_5 S9_3 2.09097e-05f
C3373 S36_5 S9_6 1.79314e-05f
C3374 S36_5 S9_7 1.79314e-05f
C3375 S36_5 VDD 0.00424513f
C3376 S36_5 VSS_0 0.0078822f
C3377 S36_5 VSS_1 0.00455237f
C3378 S36_6 VDD 0.009224f
C3379 S36_6 VSS_0 0.0171268f
C3380 S36_6 VSS_1 0.00989159f
C3381 S36_7 VDD 0.009224f
C3382 S36_7 VSS_0 0.0171268f
C3383 S36_7 VSS_1 0.00989159f
C3384 S37 VDD 0.00723564f
C3385 S37 VSS_0 0.0136983f
C3386 S37 VSS_1 0.00777667f
C3387 S37_1 S38_1 0.005053f
C3388 S37_1 S38_2 0.0131372f
C3389 S37_1 S38_3 0.011408f
C3390 S37_1 S39_1 5.39477e-05f
C3391 S37_1 S39_2 0.000140258f
C3392 S37_1 S39_3 0.000121796f
C3393 S37_1 S40_1 4.03967e-05f
C3394 S37_1 S40_2 0.000105027f
C3395 S37_1 S40_3 9.1202e-05f
C3396 S37_1 S41_1 2.52262e-05f
C3397 S37_1 S41_2 6.55853e-05f
C3398 S37_1 S41_3 5.69522e-05f
C3399 S37_1 S42_1 1.65942e-05f
C3400 S37_1 S42_2 4.3143e-05f
C3401 S37_1 S42_3 3.7464e-05f
C3402 S37_1 S43_2 2.04685e-05f
C3403 S37_1 S43_3 1.77742e-05f
C3404 S37_1 VDD 0.00410602f
C3405 S37_1 VSS_0 0.0077734f
C3406 S37_1 VSS_1 0.00441304f
C3407 S37_2 VDD 0.0106752f
C3408 S37_2 VSS_0 0.02021f
C3409 S37_2 VSS_1 0.0114734f
C3410 S37_3 VDD 0.00927001f
C3411 S37_3 VSS_0 0.0175497f
C3412 S37_3 VSS_1 0.00996315f
C3413 S37_4 S38_4 0.00518491f
C3414 S37_4 S38_7 0.011266f
C3415 S37_4 S39_4 5.53561e-05f
C3416 S37_4 S39_7 0.00012028f
C3417 S37_4 S40_4 4.14513e-05f
C3418 S37_4 S40_7 9.00672e-05f
C3419 S37_4 S41_4 2.58848e-05f
C3420 S37_4 S41_7 5.62435e-05f
C3421 S37_4 S42_4 1.70274e-05f
C3422 S37_4 S42_7 3.69979e-05f
C3423 S37_4 S43_7 1.75531e-05f
C3424 S37_4 VDD 0.00421322f
C3425 S37_4 VSS_0 0.00797634f
C3426 S37_4 VSS_1 0.00452825f
C3427 S37_5 S38 0.0089044f
C3428 S37_5 S38_5 0.00518491f
C3429 S37_5 S38_6 0.011266f
C3430 S37_5 S39 9.50668e-05f
C3431 S37_5 S39_5 5.53561e-05f
C3432 S37_5 S39_6 0.00012028f
C3433 S37_5 S40 7.11871e-05f
C3434 S37_5 S40_5 4.14513e-05f
C3435 S37_5 S40_6 9.00672e-05f
C3436 S37_5 S41 4.44537e-05f
C3437 S37_5 S41_5 2.58848e-05f
C3438 S37_5 S41_6 5.62435e-05f
C3439 S37_5 S42 2.92423e-05f
C3440 S37_5 S42_5 1.70274e-05f
C3441 S37_5 S42_6 3.69979e-05f
C3442 S37_5 S43 1.38735e-05f
C3443 S37_5 S43_6 1.75531e-05f
C3444 S37_5 S7_2 1.05951e-05f
C3445 S37_5 S7_3 1.22011e-05f
C3446 S37_5 S7_6 1.04632e-05f
C3447 S37_5 S7_7 1.04632e-05f
C3448 S37_5 S8 1.14942e-05f
C3449 S37_5 S8_2 1.47259e-05f
C3450 S37_5 S8_3 1.69581e-05f
C3451 S37_5 S8_6 1.45426e-05f
C3452 S37_5 S8_7 1.45426e-05f
C3453 S37_5 S9 3.59191e-05f
C3454 S37_5 S9_1 2.03831e-05f
C3455 S37_5 S9_2 4.60181e-05f
C3456 S37_5 S9_3 5.29937e-05f
C3457 S37_5 S9_4 2.09152e-05f
C3458 S37_5 S9_5 2.09152e-05f
C3459 S37_5 S9_6 4.54455e-05f
C3460 S37_5 S9_7 4.54455e-05f
C3461 S37_5 VDD 0.00421322f
C3462 S37_5 VSS_0 0.00797634f
C3463 S37_5 VSS_1 0.00452825f
C3464 S37_6 VDD 0.00915466f
C3465 S37_6 VSS_0 0.0173313f
C3466 S37_6 VSS_1 0.00983917f
C3467 S37_7 VDD 0.00915466f
C3468 S37_7 VSS_0 0.0173313f
C3469 S37_7 VSS_1 0.00983917f
C3470 S38 VDD 0.00711774f
C3471 S38 VSS_0 0.0136135f
C3472 S38 VSS_1 0.00778045f
C3473 S38_1 S39_1 0.00503556f
C3474 S38_1 S39_2 0.0130919f
C3475 S38_1 S39_3 0.0113686f
C3476 S38_1 S40_1 6.07272e-05f
C3477 S38_1 S40_2 0.000157884f
C3478 S38_1 S40_3 0.000137101f
C3479 S38_1 S41_1 4.48436e-05f
C3480 S38_1 S41_2 0.000116588f
C3481 S38_1 S41_3 0.000101242f
C3482 S38_1 S42_1 2.96127e-05f
C3483 S38_1 S42_2 7.69897e-05f
C3484 S38_1 S42_3 6.68555e-05f
C3485 S38_1 S43_1 1.12316e-05f
C3486 S38_1 S43_2 2.92009e-05f
C3487 S38_1 S43_3 2.53572e-05f
C3488 S38_1 S48_2 1.29257e-05f
C3489 S38_1 S48_3 1.12243e-05f
C3490 S38_1 S49_2 2.48629e-05f
C3491 S38_1 S49_3 2.15901e-05f
C3492 S38_1 S50_2 2.41289e-05f
C3493 S38_1 S50_3 2.09528e-05f
C3494 S38_1 VDD 0.00403912f
C3495 S38_1 VSS_0 0.0077253f
C3496 S38_1 VSS_1 0.00441519f
C3497 S38_2 VDD 0.0105013f
C3498 S38_2 VSS_0 0.0200849f
C3499 S38_2 VSS_1 0.011479f
C3500 S38_3 VDD 0.00911896f
C3501 S38_3 VSS_0 0.0174411f
C3502 S38_3 VSS_1 0.009968f
C3503 S38_4 S39_4 0.00516702f
C3504 S38_4 S39_7 0.0112271f
C3505 S38_4 S40_4 6.23125e-05f
C3506 S38_4 S40_7 0.000135395f
C3507 S38_4 S41_4 4.60144e-05f
C3508 S38_4 S41_7 9.9982e-05f
C3509 S38_4 S42_4 3.03858e-05f
C3510 S38_4 S42_7 6.60236e-05f
C3511 S38_4 S43_4 1.15248e-05f
C3512 S38_4 S43_7 2.50416e-05f
C3513 S38_4 S48_7 1.10846e-05f
C3514 S38_4 S49_7 2.13215e-05f
C3515 S38_4 S50_7 2.0692e-05f
C3516 S38_4 VDD 0.00414457f
C3517 S38_4 VSS_0 0.00792698f
C3518 S38_4 VSS_1 0.00453045f
C3519 S38_5 S39 0.00887367f
C3520 S38_5 S39_5 0.00516702f
C3521 S38_5 S39_6 0.0112271f
C3522 S38_5 S40 0.000107014f
C3523 S38_5 S40_5 6.23125e-05f
C3524 S38_5 S40_6 0.000135395f
C3525 S38_5 S41 7.90236e-05f
C3526 S38_5 S41_5 4.60144e-05f
C3527 S38_5 S41_6 9.9982e-05f
C3528 S38_5 S42 5.21836e-05f
C3529 S38_5 S42_5 3.03858e-05f
C3530 S38_5 S42_6 6.60236e-05f
C3531 S38_5 S43 1.97924e-05f
C3532 S38_5 S43_5 1.15248e-05f
C3533 S38_5 S43_6 2.50416e-05f
C3534 S38_5 S48_6 1.10846e-05f
C3535 S38_5 S49 1.6852e-05f
C3536 S38_5 S49_6 2.13215e-05f
C3537 S38_5 S50 1.63545e-05f
C3538 S38_5 S50_6 2.0692e-05f
C3539 S38_5 S8 3.10352e-05f
C3540 S38_5 S8_1 1.76116e-05f
C3541 S38_5 S8_2 3.9761e-05f
C3542 S38_5 S8_3 4.57881e-05f
C3543 S38_5 S8_4 1.80714e-05f
C3544 S38_5 S8_5 1.80714e-05f
C3545 S38_5 S8_6 3.92662e-05f
C3546 S38_5 S8_7 3.92662e-05f
C3547 S38_5 S9 5.45305e-05f
C3548 S38_5 S9_1 3.09445e-05f
C3549 S38_5 S9_2 6.98622e-05f
C3550 S38_5 S9_3 8.04522e-05f
C3551 S38_5 S9_4 3.17524e-05f
C3552 S38_5 S9_5 3.17524e-05f
C3553 S38_5 S9_6 6.89929e-05f
C3554 S38_5 S9_7 6.89929e-05f
C3555 S38_5 VDD 0.00414457f
C3556 S38_5 VSS_0 0.00792698f
C3557 S38_5 VSS_1 0.00453045f
C3558 S38_6 VDD 0.00900549f
C3559 S38_6 VSS_0 0.0172241f
C3560 S38_6 VSS_1 0.00984396f
C3561 S38_7 VDD 0.00900549f
C3562 S38_7 VSS_0 0.0172241f
C3563 S38_7 VSS_1 0.00984396f
C3564 S39 VDD 0.00731913f
C3565 S39 VSS_0 0.0135247f
C3566 S39 VSS_1 0.00775997f
C3567 S39_1 S40_1 0.00506015f
C3568 S39_1 S40_2 0.0131558f
C3569 S39_1 S40_3 0.0114241f
C3570 S39_1 S41_1 6.11659e-05f
C3571 S39_1 S41_2 0.000159024f
C3572 S39_1 S41_3 0.000138092f
C3573 S39_1 S42_1 4.93985e-05f
C3574 S39_1 S42_2 0.000128431f
C3575 S39_1 S42_3 0.000111525f
C3576 S39_1 S43_1 1.15009e-05f
C3577 S39_1 S43_2 2.99011e-05f
C3578 S39_1 S43_3 2.59652e-05f
C3579 S39_1 S48_1 1.30682e-05f
C3580 S39_1 S48_2 3.39759e-05f
C3581 S39_1 S48_3 2.95036e-05f
C3582 S39_1 S49_1 2.20668e-05f
C3583 S39_1 S49_2 5.73711e-05f
C3584 S39_1 S49_3 4.98193e-05f
C3585 S39_1 S50_1 1.87369e-05f
C3586 S39_1 S50_2 4.87138e-05f
C3587 S39_1 S50_3 4.23016e-05f
C3588 S39_1 VDD 0.0041534f
C3589 S39_1 VSS_0 0.00767489f
C3590 S39_1 VSS_1 0.00440357f
C3591 S39_2 VDD 0.0107984f
C3592 S39_2 VSS_0 0.0199539f
C3593 S39_2 VSS_1 0.0114488f
C3594 S39_3 VDD 0.00937698f
C3595 S39_3 VSS_0 0.0173273f
C3596 S39_3 VSS_1 0.00994176f
C3597 S39_4 S40_4 0.00519225f
C3598 S39_4 S40_7 0.0112819f
C3599 S39_4 S41_4 6.27627e-05f
C3600 S39_4 S41_7 0.000136373f
C3601 S39_4 S42_4 5.06882e-05f
C3602 S39_4 S42_7 0.000110137f
C3603 S39_4 S43_4 1.18012e-05f
C3604 S39_4 S43_7 2.56421e-05f
C3605 S39_4 S48_4 1.34094e-05f
C3606 S39_4 S48_7 2.91365e-05f
C3607 S39_4 S49_4 2.26429e-05f
C3608 S39_4 S49_7 4.91994e-05f
C3609 S39_4 S50_4 1.92261e-05f
C3610 S39_4 S50_7 4.17752e-05f
C3611 S39_4 VDD 0.00426183f
C3612 S39_4 VSS_0 0.00787526f
C3613 S39_4 VSS_1 0.00451853f
C3614 S39_5 S3_2 1.54079e-05f
C3615 S39_5 S3_3 1.77435e-05f
C3616 S39_5 S3_6 1.52162e-05f
C3617 S39_5 S3_7 1.52162e-05f
C3618 S39_5 S40 0.008917f
C3619 S39_5 S40_5 0.00519225f
C3620 S39_5 S40_6 0.0112819f
C3621 S39_5 S41 0.000107787f
C3622 S39_5 S41_5 6.27627e-05f
C3623 S39_5 S41_6 0.000136373f
C3624 S39_5 S42 8.70502e-05f
C3625 S39_5 S42_5 5.06882e-05f
C3626 S39_5 S42_6 0.000110137f
C3627 S39_5 S43 2.0267e-05f
C3628 S39_5 S43_5 1.18012e-05f
C3629 S39_5 S43_6 2.56421e-05f
C3630 S39_5 S48 2.30289e-05f
C3631 S39_5 S48_5 1.34094e-05f
C3632 S39_5 S48_6 2.91365e-05f
C3633 S39_5 S49 3.88861e-05f
C3634 S39_5 S49_5 2.26429e-05f
C3635 S39_5 S49_6 4.91994e-05f
C3636 S39_5 S50 3.30182e-05f
C3637 S39_5 S50_5 1.92261e-05f
C3638 S39_5 S50_6 4.17752e-05f
C3639 S39_5 S6_2 1.01845e-05f
C3640 S39_5 S6_3 1.17283e-05f
C3641 S39_5 S6_6 1.00578e-05f
C3642 S39_5 S6_7 1.00578e-05f
C3643 S39_5 S8 2.97858e-05f
C3644 S39_5 S8_1 1.69026e-05f
C3645 S39_5 S8_2 3.81604e-05f
C3646 S39_5 S8_3 4.39449e-05f
C3647 S39_5 S8_4 1.73439e-05f
C3648 S39_5 S8_5 1.73439e-05f
C3649 S39_5 S8_6 3.76855e-05f
C3650 S39_5 S8_7 3.76855e-05f
C3651 S39_5 S9 7.88529e-05f
C3652 S39_5 S9_1 4.47468e-05f
C3653 S39_5 S9_2 0.000101023f
C3654 S39_5 S9_3 0.000116337f
C3655 S39_5 S9_4 4.5915e-05f
C3656 S39_5 S9_5 4.5915e-05f
C3657 S39_5 S9_6 9.97661e-05f
C3658 S39_5 S9_7 9.97661e-05f
C3659 S39_5 VDD 0.00426183f
C3660 S39_5 VSS_0 0.00787526f
C3661 S39_5 VSS_1 0.00451853f
C3662 S39_6 VDD 0.0092603f
C3663 S39_6 VSS_0 0.0171117f
C3664 S39_6 VSS_1 0.00981806f
C3665 S39_7 VDD 0.0092603f
C3666 S39_7 VSS_0 0.0171117f
C3667 S39_7 VSS_1 0.00981806f
C3668 S3_1 S47_5 0.000122716f
C3669 S3_1 S48_6 6.36382e-05f
C3670 S3_1 S49_6 5.44857e-05f
C3671 S3_1 S4_2 0.00498518f
C3672 S3_1 S50_6 4.70175e-05f
C3673 S3_1 S5_6 4.29456e-05f
C3674 S3_1 VDD 0.00436444f
C3675 S3_1 VSS_0 0.0121137f
C3676 S3_2 S40_5 1.12922e-05f
C3677 S3_2 S47_5 0.000277052f
C3678 S3_2 S48 0.000143673f
C3679 S3_2 S49_6 0.00012301f
C3680 S3_2 S4_6 0.0112549f
C3681 S3_2 S50_6 0.00010615f
C3682 S3_2 S5_6 9.69566e-05f
C3683 S3_2 S6_6 1.35671e-05f
C3684 S3_2 VDD 0.00985343f
C3685 S3_2 VSS_0 0.0273487f
C3686 S3_3 S40_5 1.30039e-05f
C3687 S3_3 S47_5 0.000319048f
C3688 S3_3 S48_6 0.000165452f
C3689 S3_3 S49_6 0.000141657f
C3690 S3_3 S4_6 0.0129609f
C3691 S3_3 S50_6 0.00012224f
C3692 S3_3 S5_6 0.000111654f
C3693 S3_3 S6_6 1.56237e-05f
C3694 S3_3 VDD 0.011347f
C3695 S3_3 VSS_0 0.0314944f
C3696 S3_4 S47_5 0.00012592f
C3697 S3_4 S48_6 6.52996e-05f
C3698 S3_4 S49_6 5.59082e-05f
C3699 S3_4 S4_6 0.00511533f
C3700 S3_4 S50_6 4.8245e-05f
C3701 S3_4 S5_6 4.40668e-05f
C3702 S3_4 VDD 0.00447838f
C3703 S3_4 VSS_0 0.01243f
C3704 S3_5 S47_5 0.00012592f
C3705 S3_5 S48_6 6.52996e-05f
C3706 S3_5 S49_6 5.59082e-05f
C3707 S3_5 S4_7 0.00511533f
C3708 S3_5 S50_6 4.8245e-05f
C3709 S3_5 S5_7 4.40668e-05f
C3710 S3_5 VDD 0.00447838f
C3711 S3_5 VSS_0 0.01243f
C3712 S3_6 S40_5 1.11516e-05f
C3713 S3_6 S47_5 0.000273604f
C3714 S3_6 S48_5 0.000141886f
C3715 S3_6 S49_6 0.00012148f
C3716 S3_6 S4_6 0.0111148f
C3717 S3_6 S50_6 0.000104829f
C3718 S3_6 S5_6 9.57501e-05f
C3719 S3_6 S6_6 1.33983e-05f
C3720 S3_6 VDD 0.00973082f
C3721 S3_6 VSS_0 0.0270084f
C3722 S3_7 S40_5 1.11516e-05f
C3723 S3_7 S47_5 0.000273604f
C3724 S3_7 S48_5 0.000141886f
C3725 S3_7 S49_6 0.00012148f
C3726 S3_7 S4_7 0.0111148f
C3727 S3_7 S50_6 0.000104829f
C3728 S3_7 S5_7 9.57501e-05f
C3729 S3_7 S6_7 1.33983e-05f
C3730 S3_7 VDD 0.00973082f
C3731 S3_7 VSS_0 0.0270084f
C3732 S4 S46_5 0.000226215f
C3733 S4 S47_6 0.000104244f
C3734 S4 S48_6 6.69138e-05f
C3735 S4 S49_6 7.09562e-05f
C3736 S4 S50_6 4.61772e-05f
C3737 S4 S5_7 0.00880067f
C3738 S4 S6_7 5.78821e-05f
C3739 S4 VDD 0.00787053f
C3740 S4 VSS_0 0.0210713f
C3741 S4 VSS_1 3.90925e-05f
C3742 S40 VDD 0.00737809f
C3743 S40 VSS_0 0.0135386f
C3744 S40 VSS_1 0.00781983f
C3745 S40_1 S41_1 0.00505506f
C3746 S40_1 S41_2 0.0131426f
C3747 S40_1 S41_3 0.0114126f
C3748 S40_1 S42_1 4.15899e-05f
C3749 S40_1 S42_2 0.000108129f
C3750 S40_1 S42_3 9.38958e-05f
C3751 S40_1 S43_1 2.68725e-05f
C3752 S40_1 S43_2 6.98655e-05f
C3753 S40_1 S43_3 6.06691e-05f
C3754 S40_1 S48_1 1.07644e-05f
C3755 S40_1 S48_2 2.79863e-05f
C3756 S40_1 S48_3 2.43025e-05f
C3757 S40_1 S49_1 1.92204e-05f
C3758 S40_1 S49_2 4.99708e-05f
C3759 S40_1 S49_3 4.33931e-05f
C3760 S40_1 S50_1 1.82296e-05f
C3761 S40_1 S50_2 4.73948e-05f
C3762 S40_1 S50_3 4.11562e-05f
C3763 S40_1 VDD 0.00418686f
C3764 S40_1 VSS_0 0.00768276f
C3765 S40_1 VSS_1 0.00443753f
C3766 S40_2 VDD 0.0108854f
C3767 S40_2 VSS_0 0.0199743f
C3768 S40_2 VSS_1 0.0115371f
C3769 S40_3 VDD 0.00945251f
C3770 S40_3 VSS_0 0.0173451f
C3771 S40_3 VSS_1 0.0100184f
C3772 S40_4 S41_4 0.00518703f
C3773 S40_4 S41_7 0.0112706f
C3774 S40_4 S42_4 4.26756e-05f
C3775 S40_4 S42_7 9.27274e-05f
C3776 S40_4 S43_4 2.75741e-05f
C3777 S40_4 S43_7 5.99142e-05f
C3778 S40_4 S48_4 1.10455e-05f
C3779 S40_4 S48_7 2.40001e-05f
C3780 S40_4 S49_4 1.97222e-05f
C3781 S40_4 S49_7 4.28531e-05f
C3782 S40_4 S50_4 1.87055e-05f
C3783 S40_4 S50_7 4.06441e-05f
C3784 S40_4 VDD 0.00429616f
C3785 S40_4 VSS_0 0.00788333f
C3786 S40_4 VSS_1 0.00455338f
C3787 S40_5 S41 0.00890804f
C3788 S40_5 S41_5 0.00518703f
C3789 S40_5 S41_6 0.0112706f
C3790 S40_5 S42 7.32897e-05f
C3791 S40_5 S42_5 4.26756e-05f
C3792 S40_5 S42_6 9.27274e-05f
C3793 S40_5 S43 4.73548e-05f
C3794 S40_5 S43_5 2.75741e-05f
C3795 S40_5 S43_6 5.99142e-05f
C3796 S40_5 S48 1.89691e-05f
C3797 S40_5 S48_5 1.10455e-05f
C3798 S40_5 S48_6 2.40001e-05f
C3799 S40_5 S49 3.38702e-05f
C3800 S40_5 S49_5 1.97222e-05f
C3801 S40_5 S49_6 4.28531e-05f
C3802 S40_5 S50 3.21242e-05f
C3803 S40_5 S50_5 1.87055e-05f
C3804 S40_5 S50_6 4.06441e-05f
C3805 S40_5 S6 2.54602e-05f
C3806 S40_5 S6_1 1.44479e-05f
C3807 S40_5 S6_2 3.26186e-05f
C3808 S40_5 S6_3 3.7563e-05f
C3809 S40_5 S6_4 1.48251e-05f
C3810 S40_5 S6_5 1.48251e-05f
C3811 S40_5 S6_6 3.22127e-05f
C3812 S40_5 S6_7 3.22127e-05f
C3813 S40_5 S8 3.92902e-05f
C3814 S40_5 S8_1 2.22961e-05f
C3815 S40_5 S8_2 5.03371e-05f
C3816 S40_5 S8_3 5.79673e-05f
C3817 S40_5 S8_4 2.28782e-05f
C3818 S40_5 S8_5 2.28782e-05f
C3819 S40_5 S8_6 4.97107e-05f
C3820 S40_5 S8_7 4.97107e-05f
C3821 S40_5 S9 5.77459e-05f
C3822 S40_5 S9_1 3.27692e-05f
C3823 S40_5 S9_2 7.39817e-05f
C3824 S40_5 S9_3 8.51961e-05f
C3825 S40_5 S9_4 3.36247e-05f
C3826 S40_5 S9_5 3.36247e-05f
C3827 S40_5 S9_6 7.30611e-05f
C3828 S40_5 S9_7 7.30611e-05f
C3829 S40_5 VDD 0.00429616f
C3830 S40_5 VSS_0 0.00788333f
C3831 S40_5 VSS_1 0.00455338f
C3832 S40_6 VDD 0.00933489f
C3833 S40_6 VSS_0 0.0171292f
C3834 S40_6 VSS_1 0.00989378f
C3835 S40_7 VDD 0.00933489f
C3836 S40_7 VSS_0 0.0171292f
C3837 S40_7 VSS_1 0.00989378f
C3838 S41 VDD 0.00754876f
C3839 S41 VSS_0 0.0133672f
C3840 S41 VSS_1 0.00783864f
C3841 S41_1 S42_1 0.00505852f
C3842 S41_1 S42_2 0.0131516f
C3843 S41_1 S42_3 0.0114204f
C3844 S41_1 S43_1 3.9222e-05f
C3845 S41_1 S43_2 0.000101973f
C3846 S41_1 S43_3 8.85499e-05f
C3847 S41_1 S49_1 1.14437e-05f
C3848 S41_1 S49_2 2.97523e-05f
C3849 S41_1 S49_3 2.5836e-05f
C3850 S41_1 S50_1 1.26716e-05f
C3851 S41_1 S50_2 3.29446e-05f
C3852 S41_1 S50_3 2.86081e-05f
C3853 S41_1 VDD 0.00428371f
C3854 S41_1 VSS_0 0.00758554f
C3855 S41_1 VSS_1 0.00444821f
C3856 S41_2 VDD 0.0111372f
C3857 S41_2 VSS_0 0.0197215f
C3858 S41_2 VSS_1 0.0115648f
C3859 S41_3 VDD 0.00967116f
C3860 S41_3 VSS_0 0.0171256f
C3861 S41_3 VSS_1 0.0100426f
C3862 S41_4 S42_4 0.00519058f
C3863 S41_4 S42_7 0.0112783f
C3864 S41_4 S43_4 4.02459e-05f
C3865 S41_4 S43_7 8.74481e-05f
C3866 S41_4 S49_4 1.17425e-05f
C3867 S41_4 S49_7 2.55145e-05f
C3868 S41_4 S50_4 1.30024e-05f
C3869 S41_4 S50_7 2.82521e-05f
C3870 S41_4 VDD 0.00439554f
C3871 S41_4 VSS_0 0.00778357f
C3872 S41_4 VSS_1 0.00456434f
C3873 S41_5 S42 0.00891413f
C3874 S41_5 S42_5 0.00519058f
C3875 S41_5 S42_6 0.0112783f
C3876 S41_5 S43 6.9117e-05f
C3877 S41_5 S43_5 4.02459e-05f
C3878 S41_5 S43_6 8.74481e-05f
C3879 S41_5 S49 2.01661e-05f
C3880 S41_5 S49_5 1.17425e-05f
C3881 S41_5 S49_6 2.55145e-05f
C3882 S41_5 S50 2.23298e-05f
C3883 S41_5 S50_5 1.30024e-05f
C3884 S41_5 S50_6 2.82521e-05f
C3885 S41_5 S6_2 1.19466e-05f
C3886 S41_5 S6_3 1.37575e-05f
C3887 S41_5 S6_6 1.17979e-05f
C3888 S41_5 S6_7 1.17979e-05f
C3889 S41_5 S8 1.99902e-05f
C3890 S41_5 S8_1 1.13439e-05f
C3891 S41_5 S8_2 2.56106e-05f
C3892 S41_5 S8_3 2.94928e-05f
C3893 S41_5 S8_4 1.164e-05f
C3894 S41_5 S8_5 1.164e-05f
C3895 S41_5 S8_6 2.5292e-05f
C3896 S41_5 S8_7 2.5292e-05f
C3897 S41_5 S9 0.000231421f
C3898 S41_5 S9_1 0.000131325f
C3899 S41_5 S9_2 0.000296487f
C3900 S41_5 S9_3 0.00034143f
C3901 S41_5 S9_4 0.000134753f
C3902 S41_5 S9_5 0.000134753f
C3903 S41_5 S9_6 0.000292798f
C3904 S41_5 S9_7 0.000292798f
C3905 S41_5 VDD 0.00439554f
C3906 S41_5 VSS_0 0.00778357f
C3907 S41_5 VSS_1 0.00456434f
C3908 S41_6 VDD 0.00955082f
C3909 S41_6 VSS_0 0.0169125f
C3910 S41_6 VSS_1 0.00991759f
C3911 S41_7 VDD 0.00955082f
C3912 S41_7 VSS_0 0.0169125f
C3913 S41_7 VSS_1 0.00991759f
C3914 S42 S9_2 0.000149733f
C3915 S42 VDD 0.00768249f
C3916 S42 VSS_0 0.0131949f
C3917 S42 VSS_1 0.00794583f
C3918 S42_1 S43_1 0.00497045f
C3919 S42_1 S43_2 0.0129226f
C3920 S42_1 S43_3 0.0112216f
C3921 S42_1 S44_2 1.6319e-05f
C3922 S42_1 S44_3 1.41709e-05f
C3923 S42_1 VDD 0.0043596f
C3924 S42_1 VSS_0 0.00748775f
C3925 S42_1 VSS_1 0.00450903f
C3926 S42_2 VDD 0.0113345f
C3927 S42_2 VSS_0 0.0194673f
C3928 S42_2 VSS_1 0.011723f
C3929 S42_3 VDD 0.00984249f
C3930 S42_3 VSS_0 0.0169048f
C3931 S42_3 VSS_1 0.0101799f
C3932 S42_4 S43_4 0.00510022f
C3933 S42_4 S43_7 0.011082f
C3934 S42_4 S44_7 1.39945e-05f
C3935 S42_4 VDD 0.00447341f
C3936 S42_4 VSS_0 0.00768323f
C3937 S42_4 VSS_1 0.00462675f
C3938 S42_5 S43 0.00875895f
C3939 S42_5 S43_5 0.00510022f
C3940 S42_5 S43_6 0.011082f
C3941 S42_5 S44 1.1061e-05f
C3942 S42_5 S44_6 1.39945e-05f
C3943 S42_5 S6_2 1.10848e-05f
C3944 S42_5 S6_3 1.27651e-05f
C3945 S42_5 S6_6 1.09468e-05f
C3946 S42_5 S6_7 1.09468e-05f
C3947 S42_5 S8 0.000217238f
C3948 S42_5 S8_1 0.000123276f
C3949 S42_5 S8_2 0.000278316f
C3950 S42_5 S8_3 0.000320504f
C3951 S42_5 S8_4 0.000126495f
C3952 S42_5 S8_5 0.000126495f
C3953 S42_5 S8_6 0.000274853f
C3954 S42_5 S8_7 0.000274853f
C3955 S42_5 S9_6 0.00014787f
C3956 S42_5 S9_7 0.00014787f
C3957 S42_5 VDD 0.00447341f
C3958 S42_5 VSS_0 0.00768323f
C3959 S42_5 VSS_1 0.00462675f
C3960 S42_6 S9 0.000116873f
C3961 S42_6 S9_1 6.63222e-05f
C3962 S42_6 S9_3 0.00017243f
C3963 S42_6 S9_4 6.80537e-05f
C3964 S42_6 S9_5 6.80537e-05f
C3965 S42_6 VDD 0.00972002f
C3966 S42_6 VSS_0 0.0166944f
C3967 S42_6 VSS_1 0.0100532f
C3968 S42_7 VDD 0.00972002f
C3969 S42_7 VSS_0 0.0166944f
C3970 S42_7 VSS_1 0.0100532f
C3971 S43 S8_2 0.000130094f
C3972 S43 VDD 0.00786695f
C3973 S43 VSS_0 0.0131496f
C3974 S43 VSS_1 0.00797437f
C3975 S43_1 S44_1 0.0050033f
C3976 S43_1 S44_2 0.013008f
C3977 S43_1 S44_3 0.0112958f
C3978 S43_1 S45_1 2.73764e-05f
C3979 S43_1 S45_2 7.11754e-05f
C3980 S43_1 S45_3 6.18065e-05f
C3981 S43_1 VDD 0.00446427f
C3982 S43_1 VSS_0 0.00746201f
C3983 S43_1 VSS_1 0.00452523f
C3984 S43_2 VDD 0.0116066f
C3985 S43_2 VSS_0 0.0194004f
C3986 S43_2 VSS_1 0.0117651f
C3987 S43_3 VDD 0.0100788f
C3988 S43_3 VSS_0 0.0168467f
C3989 S43_3 VSS_1 0.0102164f
C3990 S43_4 S44_4 0.00513392f
C3991 S43_4 S44_7 0.0111552f
C3992 S43_4 S45_4 2.80911e-05f
C3993 S43_4 S45_7 6.10375e-05f
C3994 S43_4 VDD 0.00458082f
C3995 S43_4 VSS_0 0.00765682f
C3996 S43_4 VSS_1 0.00464337f
C3997 S43_5 S44 0.00881683f
C3998 S43_5 S44_5 0.00513392f
C3999 S43_5 S44_6 0.0111552f
C4000 S43_5 S45 4.82427e-05f
C4001 S43_5 S45_5 2.80911e-05f
C4002 S43_5 S45_6 6.10375e-05f
C4003 S43_5 S5_2 1.20188e-05f
C4004 S43_5 S5_3 1.38407e-05f
C4005 S43_5 S5_6 1.18693e-05f
C4006 S43_5 S5_7 1.18693e-05f
C4007 S43_5 S7 0.000194194f
C4008 S43_5 S7_1 0.000110199f
C4009 S43_5 S7_2 0.000248793f
C4010 S43_5 S7_3 0.000286506f
C4011 S43_5 S7_4 0.000113076f
C4012 S43_5 S7_5 0.000113076f
C4013 S43_5 S7_6 0.000245697f
C4014 S43_5 S7_7 0.000245697f
C4015 S43_5 S8_6 0.000128475f
C4016 S43_5 S8_7 0.000128475f
C4017 S43_5 VDD 0.00458082f
C4018 S43_5 VSS_0 0.00765682f
C4019 S43_5 VSS_1 0.00464337f
C4020 S43_6 S8 0.000101544f
C4021 S43_6 S8_1 5.76232e-05f
C4022 S43_6 S8_3 0.000149814f
C4023 S43_6 S8_4 5.91275e-05f
C4024 S43_6 S8_5 5.91275e-05f
C4025 S43_6 S9 6.88216e-05f
C4026 S43_6 S9_1 3.90543e-05f
C4027 S43_6 S9_2 8.81714e-05f
C4028 S43_6 S9_3 0.000101537f
C4029 S43_6 S9_4 4.00739e-05f
C4030 S43_6 S9_5 4.00739e-05f
C4031 S43_6 S9_6 8.70743e-05f
C4032 S43_6 S9_7 8.70743e-05f
C4033 S43_6 VDD 0.0099534f
C4034 S43_6 VSS_0 0.0166371f
C4035 S43_6 VSS_1 0.0100893f
C4036 S43_7 VDD 0.0099534f
C4037 S43_7 VSS_0 0.0166371f
C4038 S43_7 VSS_1 0.0100893f
C4039 S44 S7_2 0.000108473f
C4040 S44 VDD 0.008247f
C4041 S44 VSS_0 0.0133251f
C4042 S44 VSS_1 0.00816092f
C4043 S44_1 S45_1 0.0050194f
C4044 S44_1 S45_2 0.0130499f
C4045 S44_1 S45_3 0.0113321f
C4046 S44_1 S46_2 1.66866e-05f
C4047 S44_1 S46_3 1.44902e-05f
C4048 S44_1 VDD 0.00467994f
C4049 S44_1 VSS_0 0.00756165f
C4050 S44_1 VSS_1 0.00463109f
C4051 S44_2 VDD 0.0121673f
C4052 S44_2 VSS_0 0.0196594f
C4053 S44_2 VSS_1 0.0120403f
C4054 S44_3 VDD 0.0105657f
C4055 S44_3 VSS_0 0.0170716f
C4056 S44_3 VSS_1 0.0104554f
C4057 S44_4 S45_4 0.00515044f
C4058 S44_4 S45_7 0.0111911f
C4059 S44_4 S46_7 1.43099e-05f
C4060 S44_4 VDD 0.00480212f
C4061 S44_4 VSS_0 0.00775906f
C4062 S44_4 VSS_1 0.00475199f
C4063 S44_5 S45 0.0088452f
C4064 S44_5 S45_5 0.00515044f
C4065 S44_5 S45_6 0.0111911f
C4066 S44_5 S46 1.13102e-05f
C4067 S44_5 S46_6 1.43099e-05f
C4068 S44_5 S6 0.000196073f
C4069 S44_5 S6_1 0.000111266f
C4070 S44_5 S6_2 0.000251201f
C4071 S44_5 S6_3 0.000289279f
C4072 S44_5 S6_4 0.000114171f
C4073 S44_5 S6_5 0.000114171f
C4074 S44_5 S6_6 0.000248075f
C4075 S44_5 S6_7 0.000248075f
C4076 S44_5 S7_6 0.000107123f
C4077 S44_5 S7_7 0.000107123f
C4078 S44_5 VDD 0.00480212f
C4079 S44_5 VSS_0 0.00775906f
C4080 S44_5 VSS_1 0.00475199f
C4081 S44_6 S7 8.46675e-05f
C4082 S44_6 S7_1 4.80464e-05f
C4083 S44_6 S7_3 0.000124915f
C4084 S44_6 S7_4 4.93007e-05f
C4085 S44_6 S7_5 4.93007e-05f
C4086 S44_6 S8 5.42546e-05f
C4087 S44_6 S8_1 3.07879e-05f
C4088 S44_6 S8_2 6.95088e-05f
C4089 S44_6 S8_3 8.00452e-05f
C4090 S44_6 S8_4 3.15917e-05f
C4091 S44_6 S8_5 3.15917e-05f
C4092 S44_6 S8_6 6.86438e-05f
C4093 S44_6 S8_7 6.86438e-05f
C4094 S44_6 S9 1.45291e-05f
C4095 S44_6 S9_2 1.86141e-05f
C4096 S44_6 S9_3 2.14357e-05f
C4097 S44_6 S9_6 1.83825e-05f
C4098 S44_6 S9_7 1.83825e-05f
C4099 S44_6 VDD 0.0104342f
C4100 S44_6 VSS_0 0.0168592f
C4101 S44_6 VSS_1 0.0103253f
C4102 S44_7 VDD 0.0104342f
C4103 S44_7 VSS_0 0.0168592f
C4104 S44_7 VSS_1 0.0103253f
C4105 S45 S6_2 9.18591e-05f
C4106 S45 VDD 0.00836541f
C4107 S45 VSS_0 0.0132669f
C4108 S45 VSS_1 0.00817881f
C4109 S45_1 S46_1 0.00504741f
C4110 S45_1 S46_2 0.0131227f
C4111 S45_1 S46_3 0.0113953f
C4112 S45_1 S47_1 1.66783e-05f
C4113 S45_1 S47_2 4.33616e-05f
C4114 S45_1 S47_3 3.76539e-05f
C4115 S45_1 VDD 0.00474713f
C4116 S45_1 VSS_0 0.0075286f
C4117 S45_1 VSS_1 0.00464124f
C4118 S45_2 VDD 0.012342f
C4119 S45_2 VSS_0 0.0195735f
C4120 S45_2 VSS_1 0.0120667f
C4121 S45_3 VDD 0.0107174f
C4122 S45_3 VSS_0 0.016997f
C4123 S45_3 VSS_1 0.0104784f
C4124 S45_4 S46_4 0.00517918f
C4125 S45_4 S46_7 0.0112535f
C4126 S45_4 S47_4 1.71137e-05f
C4127 S45_4 S47_7 3.71854e-05f
C4128 S45_4 VDD 0.00487106f
C4129 S45_4 VSS_0 0.00772514f
C4130 S45_4 VSS_1 0.00476241f
C4131 S45_5 S46 0.00889455f
C4132 S45_5 S46_5 0.00517918f
C4133 S45_5 S46_6 0.0112535f
C4134 S45_5 S47 2.93905e-05f
C4135 S45_5 S47_5 1.71137e-05f
C4136 S45_5 S47_6 3.71854e-05f
C4137 S45_5 S5 0.000211302f
C4138 S45_5 S5_1 0.000119908f
C4139 S45_5 S5_2 0.000270711f
C4140 S45_5 S5_3 0.000311747f
C4141 S45_5 S5_4 0.000123038f
C4142 S45_5 S5_5 0.000123038f
C4143 S45_5 S5_6 0.000267343f
C4144 S45_5 S5_7 0.000267343f
C4145 S45_5 S6_6 9.0716e-05f
C4146 S45_5 S6_7 9.0716e-05f
C4147 S45_5 VDD 0.00487106f
C4148 S45_5 VSS_0 0.00772514f
C4149 S45_5 VSS_1 0.00476241f
C4150 S45_6 S6 7.16999e-05f
C4151 S45_6 S6_1 4.06877e-05f
C4152 S45_6 S6_3 0.000105783f
C4153 S45_6 S6_4 4.17499e-05f
C4154 S45_6 S6_5 4.17499e-05f
C4155 S45_6 S7 4.00218e-05f
C4156 S45_6 S7_1 2.27112e-05f
C4157 S45_6 S7_2 5.12742e-05f
C4158 S45_6 S7_3 5.90466e-05f
C4159 S45_6 S7_4 2.33041e-05f
C4160 S45_6 S7_5 2.33041e-05f
C4161 S45_6 S7_6 5.06362e-05f
C4162 S45_6 S7_7 5.06362e-05f
C4163 S45_6 S8 3.30099e-05f
C4164 S45_6 S8_1 1.87322e-05f
C4165 S45_6 S8_2 4.2291e-05f
C4166 S45_6 S8_3 4.87016e-05f
C4167 S45_6 S8_4 1.92212e-05f
C4168 S45_6 S8_5 1.92212e-05f
C4169 S45_6 S8_6 4.17647e-05f
C4170 S45_6 S8_7 4.17647e-05f
C4171 S45_6 VDD 0.0105841f
C4172 S45_6 VSS_0 0.0167855f
C4173 S45_6 VSS_1 0.010348f
C4174 S45_7 VDD 0.0105841f
C4175 S45_7 VSS_0 0.0167855f
C4176 S45_7 VSS_1 0.010348f
C4177 S46 S5_2 0.000120078f
C4178 S46 VDD 0.00802382f
C4179 S46 VSS_0 0.0131629f
C4180 S46 VSS_1 0.00801719f
C4181 S46_1 S47_1 0.00500029f
C4182 S46_1 S47_2 0.0130002f
C4183 S46_1 S47_3 0.011289f
C4184 S46_1 S48_1 3.18909e-05f
C4185 S46_1 S48_2 8.29126e-05f
C4186 S46_1 S48_3 7.19988e-05f
C4187 S46_1 S49_1 2.6274e-05f
C4188 S46_1 S49_2 6.83095e-05f
C4189 S46_1 S49_3 5.93179e-05f
C4190 S46_1 S50_1 1.9336e-05f
C4191 S46_1 S50_2 5.02714e-05f
C4192 S46_1 S50_3 4.36542e-05f
C4193 S46_1 VDD 0.00455329f
C4194 S46_1 VSS_0 0.00746955f
C4195 S46_1 VSS_1 0.00454953f
C4196 S46_2 VDD 0.011838f
C4197 S46_2 VSS_0 0.01942f
C4198 S46_2 VSS_1 0.0118283f
C4199 S46_3 VDD 0.0102798f
C4200 S46_3 VSS_0 0.0168637f
C4201 S46_3 VSS_1 0.0102713f
C4202 S46_4 S47_4 0.00513083f
C4203 S46_4 S47_7 0.0111485f
C4204 S46_4 S48_4 3.27234e-05f
C4205 S46_4 S48_7 7.11029e-05f
C4206 S46_4 S49_4 2.696e-05f
C4207 S46_4 S49_7 5.85798e-05f
C4208 S46_4 S50_4 1.98408e-05f
C4209 S46_4 S50_7 4.31109e-05f
C4210 S46_4 VDD 0.00467216f
C4211 S46_4 VSS_0 0.00766456f
C4212 S46_4 VSS_1 0.0046683f
C4213 S46_5 S47 0.00881153f
C4214 S46_5 S47_5 0.00513083f
C4215 S46_5 S47_6 0.0111485f
C4216 S46_5 S48 5.61981e-05f
C4217 S46_5 S48_5 3.27234e-05f
C4218 S46_5 S48_6 7.11029e-05f
C4219 S46_5 S49 4.63002e-05f
C4220 S46_5 S49_5 2.696e-05f
C4221 S46_5 S49_6 5.85798e-05f
C4222 S46_5 S4_1 0.000128371f
C4223 S46_5 S4_2 0.000289818f
C4224 S46_5 S4_3 0.000333749f
C4225 S46_5 S4_4 0.000131722f
C4226 S46_5 S4_5 0.000131722f
C4227 S46_5 S4_6 0.000286211f
C4228 S46_5 S4_7 0.000286211f
C4229 S46_5 S50 3.40739e-05f
C4230 S46_5 S50_5 1.98408e-05f
C4231 S46_5 S50_6 4.31109e-05f
C4232 S46_5 S5_6 0.000118584f
C4233 S46_5 S5_7 0.000118584f
C4234 S46_5 VDD 0.00467216f
C4235 S46_5 VSS_0 0.00766456f
C4236 S46_5 VSS_1 0.0046683f
C4237 S46_6 S5 9.37261e-05f
C4238 S46_6 S5_1 5.31869e-05f
C4239 S46_6 S5_3 0.00013828f
C4240 S46_6 S5_4 5.45755e-05f
C4241 S46_6 S5_5 5.45755e-05f
C4242 S46_6 S6 2.38936e-05f
C4243 S46_6 S6_1 1.35589e-05f
C4244 S46_6 S6_2 3.06115e-05f
C4245 S46_6 S6_3 3.52517e-05f
C4246 S46_6 S6_4 1.39129e-05f
C4247 S46_6 S6_5 1.39129e-05f
C4248 S46_6 S6_6 3.02305e-05f
C4249 S46_6 S6_7 3.02305e-05f
C4250 S46_6 S7 1.87338e-05f
C4251 S46_6 S7_1 1.06309e-05f
C4252 S46_6 S7_2 2.40009e-05f
C4253 S46_6 S7_3 2.76391e-05f
C4254 S46_6 S7_4 1.09084e-05f
C4255 S46_6 S7_5 1.09084e-05f
C4256 S46_6 S7_6 2.37023e-05f
C4257 S46_6 S7_7 2.37023e-05f
C4258 S46_6 VDD 0.0101519f
C4259 S46_6 VSS_0 0.0166539f
C4260 S46_6 VSS_1 0.0101435f
C4261 S46_7 VDD 0.0101519f
C4262 S46_7 VSS_0 0.0166539f
C4263 S46_7 VSS_1 0.0101435f
C4264 S47 S4_2 0.000133553f
C4265 S47 VDD 0.0078158f
C4266 S47 VSS_0 0.0132417f
C4267 S47 VSS_1 0.00802936f
C4268 S47_1 S48_1 0.00501195f
C4269 S47_1 S48_2 0.0130305f
C4270 S47_1 S48_3 0.0113153f
C4271 S47_1 S49_1 5.11216e-05f
C4272 S47_1 S49_2 0.00013291f
C4273 S47_1 S49_3 0.000115415f
C4274 S47_1 S50_1 4.0915e-05f
C4275 S47_1 S50_2 0.000106374f
C4276 S47_1 S50_3 9.23722e-05f
C4277 S47_1 VDD 0.00443525f
C4278 S47_1 VSS_0 0.00751429f
C4279 S47_1 VSS_1 0.00455644f
C4280 S47_2 VDD 0.0115311f
C4281 S47_2 VSS_0 0.0195363f
C4282 S47_2 VSS_1 0.0118462f
C4283 S47_3 VDD 0.0100133f
C4284 S47_3 VSS_0 0.0169647f
C4285 S47_3 VSS_1 0.0102869f
C4286 S47_4 S48_4 0.0051428f
C4287 S47_4 S48_7 0.0111745f
C4288 S47_4 S49_4 5.24562e-05f
C4289 S47_4 S49_7 0.000113979f
C4290 S47_4 S50_4 4.19832e-05f
C4291 S47_4 S50_7 9.12228e-05f
C4292 S47_4 VDD 0.00455104f
C4293 S47_4 VSS_0 0.00771046f
C4294 S47_4 VSS_1 0.00467539f
C4295 S47_5 S48 0.00883207f
C4296 S47_5 S48_5 0.0051428f
C4297 S47_5 S48_6 0.0111745f
C4298 S47_5 S49 9.00866e-05f
C4299 S47_5 S49_5 5.24562e-05f
C4300 S47_5 S49_6 0.000113979f
C4301 S47_5 S4_6 0.000131891f
C4302 S47_5 S4_7 0.000131891f
C4303 S47_5 S50 7.21005e-05f
C4304 S47_5 S50_5 4.19832e-05f
C4305 S47_5 S50_6 9.12228e-05f
C4306 S47_5 VDD 0.00455104f
C4307 S47_5 VSS_0 0.00771046f
C4308 S47_5 VSS_1 0.00467539f
C4309 S47_6 S4_1 5.91555e-05f
C4310 S47_6 S4_3 0.000153798f
C4311 S47_6 S4_4 6.06999e-05f
C4312 S47_6 S4_5 6.06999e-05f
C4313 S47_6 S5 3.79088e-05f
C4314 S47_6 S5_1 2.15122e-05f
C4315 S47_6 S5_2 4.85673e-05f
C4316 S47_6 S5_3 5.59293e-05f
C4317 S47_6 S5_4 2.20738e-05f
C4318 S47_6 S5_5 2.20738e-05f
C4319 S47_6 S5_6 4.79629e-05f
C4320 S47_6 S5_7 4.79629e-05f
C4321 S47_6 S6 3.77324e-05f
C4322 S47_6 S6_1 2.14121e-05f
C4323 S47_6 S6_2 4.83412e-05f
C4324 S47_6 S6_3 5.56689e-05f
C4325 S47_6 S6_4 2.19711e-05f
C4326 S47_6 S6_5 2.19711e-05f
C4327 S47_6 S6_6 4.77397e-05f
C4328 S47_6 S6_7 4.77397e-05f
C4329 S47_6 VDD 0.00988869f
C4330 S47_6 VSS_0 0.0167536f
C4331 S47_6 VSS_1 0.0101589f
C4332 S47_7 VDD 0.00988869f
C4333 S47_7 VSS_0 0.0167536f
C4334 S47_7 VSS_1 0.0101589f
C4335 S48 VDD 0.00762685f
C4336 S48 VSS_0 0.0132963f
C4337 S48 VSS_1 0.00795397f
C4338 S48_1 S49_1 0.00503678f
C4339 S48_1 S49_2 0.0130951f
C4340 S48_1 S49_3 0.0113713f
C4341 S48_1 S50_1 4.90581e-05f
C4342 S48_1 S50_2 0.000127545f
C4343 S48_1 S50_3 0.000110757f
C4344 S48_1 VDD 0.00432802f
C4345 S48_1 VSS_0 0.0075453f
C4346 S48_1 VSS_1 0.00451365f
C4347 S48_2 VDD 0.0112524f
C4348 S48_2 VSS_0 0.0196169f
C4349 S48_2 VSS_1 0.011735f
C4350 S48_3 VDD 0.00977122f
C4351 S48_3 VSS_0 0.0170347f
C4352 S48_3 VSS_1 0.0101903f
C4353 S48_4 S49_4 0.00516827f
C4354 S48_4 S49_7 0.0112298f
C4355 S48_4 S50_4 5.03388e-05f
C4356 S48_4 S50_7 0.000109378f
C4357 S48_4 VDD 0.00444101f
C4358 S48_4 VSS_0 0.00774228f
C4359 S48_4 VSS_1 0.00463149f
C4360 S48_5 S49 0.00887582f
C4361 S48_5 S49_5 0.00516827f
C4362 S48_5 S49_6 0.0112298f
C4363 S48_5 S50 8.64503e-05f
C4364 S48_5 S50_5 5.03388e-05f
C4365 S48_5 S50_6 0.000109378f
C4366 S48_5 VDD 0.00444101f
C4367 S48_5 VSS_0 0.00774228f
C4368 S48_5 VSS_1 0.00463149f
C4369 S48_6 S4_1 3.79717e-05f
C4370 S48_6 S4_2 8.57273e-05f
C4371 S48_6 S4_3 9.87221e-05f
C4372 S48_6 S4_4 3.8963e-05f
C4373 S48_6 S4_5 3.8963e-05f
C4374 S48_6 S4_6 8.46605e-05f
C4375 S48_6 S4_7 8.46605e-05f
C4376 S48_6 S5 3.73016e-05f
C4377 S48_6 S5_1 2.11676e-05f
C4378 S48_6 S5_2 4.77893e-05f
C4379 S48_6 S5_3 5.50334e-05f
C4380 S48_6 S5_4 2.17202e-05f
C4381 S48_6 S5_5 2.17202e-05f
C4382 S48_6 S5_6 4.71946e-05f
C4383 S48_6 S5_7 4.71946e-05f
C4384 S48_6 S6 2.0957e-05f
C4385 S48_6 S6_1 1.18925e-05f
C4386 S48_6 S6_2 2.68492e-05f
C4387 S48_6 S6_3 3.09191e-05f
C4388 S48_6 S6_4 1.2203e-05f
C4389 S48_6 S6_5 1.2203e-05f
C4390 S48_6 S6_6 2.65151e-05f
C4391 S48_6 S6_7 2.65151e-05f
C4392 S48_6 VDD 0.00964963f
C4393 S48_6 VSS_0 0.0168228f
C4394 S48_6 VSS_1 0.0100635f
C4395 S48_7 VDD 0.00964963f
C4396 S48_7 VSS_0 0.0168228f
C4397 S48_7 VSS_1 0.0100635f
C4398 S49 VDD 0.00760393f
C4399 S49 VSS_0 0.0134785f
C4400 S49 VSS_1 0.00786532f
C4401 S49_1 S50_1 0.00502896f
C4402 S49_1 S50_2 0.0130747f
C4403 S49_1 S50_3 0.0113537f
C4404 S49_1 VDD 0.00431501f
C4405 S49_1 VSS_0 0.00764865f
C4406 S49_1 VSS_1 0.00446335f
C4407 S49_2 VDD 0.0112185f
C4408 S49_2 VSS_0 0.0198856f
C4409 S49_2 VSS_1 0.0116042f
C4410 S49_3 VDD 0.00974184f
C4411 S49_3 VSS_0 0.0172681f
C4412 S49_3 VSS_1 0.0100767f
C4413 S49_4 S50_4 0.00516025f
C4414 S49_4 S50_7 0.0112124f
C4415 S49_4 VDD 0.00442766f
C4416 S49_4 VSS_0 0.00784833f
C4417 S49_4 VSS_1 0.00457987f
C4418 S49_5 S50 0.00886205f
C4419 S49_5 S50_5 0.00516025f
C4420 S49_5 S50_6 0.0112124f
C4421 S49_5 VDD 0.00442766f
C4422 S49_5 VSS_0 0.00784833f
C4423 S49_5 VSS_1 0.00457987f
C4424 S49_6 S4_1 4.02657e-05f
C4425 S49_6 S4_2 9.09062e-05f
C4426 S49_6 S4_3 0.000104686f
C4427 S49_6 S4_4 4.13169e-05f
C4428 S49_6 S4_5 4.13169e-05f
C4429 S49_6 S4_6 8.9775e-05f
C4430 S49_6 S4_7 8.9775e-05f
C4431 S49_6 S6 1.126e-05f
C4432 S49_6 S6_2 1.44259e-05f
C4433 S49_6 S6_3 1.66126e-05f
C4434 S49_6 S6_6 1.42464e-05f
C4435 S49_6 S6_7 1.42464e-05f
C4436 S49_6 VDD 0.00962062f
C4437 S49_6 VSS_0 0.0170532f
C4438 S49_6 VSS_1 0.00995134f
C4439 S49_7 VDD 0.00962062f
C4440 S49_7 VSS_0 0.0170532f
C4441 S49_7 VSS_1 0.00995134f
C4442 S4_1 S50_6 2.62043e-05f
C4443 S4_1 S5_2 0.00499413f
C4444 S4_1 S6_6 3.28465e-05f
C4445 S4_1 VDD 0.0044663f
C4446 S4_1 VSS_0 0.0119573f
C4447 S4_1 VSS_1 2.21839e-05f
C4448 S4_2 S50_6 5.91603e-05f
C4449 S4_2 S5_6 0.0112751f
C4450 S4_2 S6_6 7.41563e-05f
C4451 S4_2 VDD 0.0100834f
C4452 S4_2 VSS_0 0.0269956f
C4453 S4_2 VSS_1 5.00838e-05f
C4454 S4_3 S50_6 6.81281e-05f
C4455 S4_3 S5_6 0.0129842f
C4456 S4_3 S6_6 8.53971e-05f
C4457 S4_3 VDD 0.0116119f
C4458 S4_3 VSS_0 0.0310877f
C4459 S4_3 VSS_1 5.76756e-05f
C4460 S4_4 S50_6 2.68884e-05f
C4461 S4_4 S5_6 0.00512451f
C4462 S4_4 S6_6 3.3704e-05f
C4463 S4_4 VDD 0.0045829f
C4464 S4_4 VSS_0 0.0122695f
C4465 S4_4 VSS_1 2.27631e-05f
C4466 S4_5 S50_6 2.68884e-05f
C4467 S4_5 S5_7 0.00512451f
C4468 S4_5 S6_7 3.3704e-05f
C4469 S4_5 VDD 0.0045829f
C4470 S4_5 VSS_0 0.0122695f
C4471 S4_5 VSS_1 2.27631e-05f
C4472 S4_6 S50_6 5.84242e-05f
C4473 S4_6 S5_6 0.0111348f
C4474 S4_6 S6_6 7.32335e-05f
C4475 S4_6 VDD 0.00995793f
C4476 S4_6 VSS_0 0.0266597f
C4477 S4_6 VSS_1 4.94605e-05f
C4478 S4_7 S50_6 5.84242e-05f
C4479 S4_7 S5_7 0.0111348f
C4480 S4_7 S6_7 7.32335e-05f
C4481 S4_7 VDD 0.00995793f
C4482 S4_7 VSS_0 0.0266597f
C4483 S4_7 VSS_1 4.94605e-05f
C4484 S5 S6_7 0.00867698f
C4485 S5 S7_7 6.18085e-05f
C4486 S5 S8_7 1.36758e-05f
C4487 S5 VDD 0.00796574f
C4488 S5 VSS_0 0.0207638f
C4489 S5 VSS_1 9.79678e-05f
C4490 S50 VDD 0.00777955f
C4491 S50 VSS_0 0.0132233f
C4492 S50 VSS_1 0.00788035f
C4493 S50_1 VDD 0.00441467f
C4494 S50_1 VSS_0 0.00750383f
C4495 S50_1 VSS_1 0.00447188f
C4496 S50_2 VDD 0.0114777f
C4497 S50_2 VSS_0 0.0195091f
C4498 S50_2 VSS_1 0.0116264f
C4499 S50_3 VDD 0.00996684f
C4500 S50_3 VSS_0 0.0169411f
C4501 S50_3 VSS_1 0.010096f
C4502 S50_4 VDD 0.00452993f
C4503 S50_4 VSS_0 0.00769973f
C4504 S50_4 VSS_1 0.00458862f
C4505 S50_5 VDD 0.00452993f
C4506 S50_5 VSS_0 0.00769973f
C4507 S50_5 VSS_1 0.00458862f
C4508 S50_6 S6 1.12645e-05f
C4509 S50_6 S6_2 1.44317e-05f
C4510 S50_6 S6_3 1.66193e-05f
C4511 S50_6 S6_6 1.42521e-05f
C4512 S50_6 S6_7 1.42521e-05f
C4513 S50_6 VDD 0.00984282f
C4514 S50_6 VSS_0 0.0167303f
C4515 S50_6 VSS_1 0.00997036f
C4516 S50_7 VDD 0.00984282f
C4517 S50_7 VSS_0 0.0167303f
C4518 S50_7 VSS_1 0.00997036f
C4519 S5_1 S6_2 0.00492394f
C4520 S5_1 S7_6 3.50746e-05f
C4521 S5_1 VDD 0.00452033f
C4522 S5_1 VSS_0 0.0117829f
C4523 S5_1 VSS_1 5.5594e-05f
C4524 S5_2 S6_6 0.0111166f
C4525 S5_2 S7_6 7.91865e-05f
C4526 S5_2 S8_6 1.75209e-05f
C4527 S5_2 VDD 0.0102054f
C4528 S5_2 VSS_0 0.0266018f
C4529 S5_2 VSS_1 0.000125512f
C4530 S5_3 S6_6 0.0128017f
C4531 S5_3 S7_6 9.11899e-05f
C4532 S5_3 S8_6 2.01768e-05f
C4533 S5_3 VDD 0.0117524f
C4534 S5_3 VSS_0 0.0306342f
C4535 S5_3 VSS_1 0.000144538f
C4536 S5_4 S6_6 0.00505249f
C4537 S5_4 S7_6 3.59903e-05f
C4538 S5_4 VDD 0.00463835f
C4539 S5_4 VSS_0 0.0120905f
C4540 S5_4 VSS_1 5.70453e-05f
C4541 S5_5 S6_7 0.00505249f
C4542 S5_5 S7_7 3.59903e-05f
C4543 S5_5 VDD 0.00463835f
C4544 S5_5 VSS_0 0.0120905f
C4545 S5_5 VSS_1 5.70453e-05f
C4546 S5_6 S6_6 0.0109783f
C4547 S5_6 S7_6 7.82012e-05f
C4548 S5_6 S8_6 1.73029e-05f
C4549 S5_6 VDD 0.0100784f
C4550 S5_6 VSS_0 0.0262707f
C4551 S5_6 VSS_1 0.000123951f
C4552 S5_7 S6_7 0.0109783f
C4553 S5_7 S7_7 7.82012e-05f
C4554 S5_7 S8_7 1.73029e-05f
C4555 S5_7 VDD 0.0100784f
C4556 S5_7 VSS_0 0.0262707f
C4557 S5_7 VSS_1 0.000123951f
C4558 S6 S7_7 0.00890148f
C4559 S6 S8_7 4.33985e-05f
C4560 S6 S9_7 2.5004e-05f
C4561 S6 VDD 0.00777871f
C4562 S6 VSS_0 0.0205195f
C4563 S6_1 S7_2 0.00505134f
C4564 S6_1 S8_6 2.46275e-05f
C4565 S6_1 S9_6 1.41891e-05f
C4566 S6_1 VDD 0.0044142f
C4567 S6_1 VSS_0 0.0116442f
C4568 S6_2 S7_6 0.0114042f
C4569 S6_2 S8_6 5.56005e-05f
C4570 S6_2 S9_6 3.20341e-05f
C4571 S6_2 VDD 0.00996577f
C4572 S6_2 VSS_0 0.0262887f
C4573 S6_3 S7_6 0.0131329f
C4574 S6_3 S8_6 6.40286e-05f
C4575 S6_3 S9_6 3.68899e-05f
C4576 S6_3 VDD 0.0114764f
C4577 S6_3 VSS_0 0.0302737f
C4578 S6_4 S7_6 0.00518321f
C4579 S6_4 S8_6 2.52704e-05f
C4580 S6_4 S9_6 1.45595e-05f
C4581 S6_4 VDD 0.00452944f
C4582 S6_4 VSS_0 0.0119482f
C4583 S6_5 S7_7 0.00518321f
C4584 S6_5 S8_7 2.52704e-05f
C4585 S6_5 S9_7 1.45595e-05f
C4586 S6_5 VDD 0.00452944f
C4587 S6_5 VSS_0 0.0119482f
C4588 S6_6 S7_6 0.0112623f
C4589 S6_6 S8_6 5.49086e-05f
C4590 S6_6 S9_6 3.16355e-05f
C4591 S6_6 VDD 0.00984176f
C4592 S6_6 VSS_0 0.0259616f
C4593 S6_7 S7_7 0.0112623f
C4594 S6_7 S8_7 5.49086e-05f
C4595 S6_7 S9_7 3.16355e-05f
C4596 S6_7 VDD 0.00984176f
C4597 S6_7 VSS_0 0.0259616f
C4598 S7 S8_7 0.00878308f
C4599 S7 S9_7 7.57887e-05f
C4600 S7 VDD 0.00797322f
C4601 S7 VSS_0 0.020724f
C4602 S7 VSS_1 8.78557e-05f
C4603 S7_1 S8_2 0.00498415f
C4604 S7_1 S9_6 4.3008e-05f
C4605 S7_1 VDD 0.00452458f
C4606 S7_1 VSS_0 0.0117603f
C4607 S7_1 VSS_1 4.98556e-05f
C4608 S7_2 S8_6 0.0112525f
C4609 S7_2 S9_6 9.70975e-05f
C4610 S7_2 VDD 0.010215f
C4611 S7_2 VSS_0 0.0265508f
C4612 S7_2 VSS_1 0.000112557f
C4613 S7_3 S8_6 0.0129582f
C4614 S7_3 S9_6 0.000111816f
C4615 S7_3 VDD 0.0117634f
C4616 S7_3 VSS_0 0.0305755f
C4617 S7_3 VSS_1 0.000129619f
C4618 S7_4 S8_6 0.00511427f
C4619 S7_4 S9_6 4.41308e-05f
C4620 S7_4 VDD 0.0046427f
C4621 S7_4 VSS_0 0.0120673f
C4622 S7_4 VSS_1 5.11572e-05f
C4623 S7_5 S8_7 0.00511427f
C4624 S7_5 S9_7 4.41308e-05f
C4625 S7_5 VDD 0.0046427f
C4626 S7_5 VSS_0 0.0120673f
C4627 S7_5 VSS_1 5.11572e-05f
C4628 S7_6 S8_6 0.0111125f
C4629 S7_6 S9_6 9.58892e-05f
C4630 S7_6 VDD 0.0100879f
C4631 S7_6 VSS_0 0.0262204f
C4632 S7_6 VSS_1 0.000111157f
C4633 S7_7 S8_7 0.0111125f
C4634 S7_7 S9_7 9.58892e-05f
C4635 S7_7 VDD 0.0100879f
C4636 S7_7 VSS_0 0.0262204f
C4637 S7_7 VSS_1 0.000111157f
C4638 S8 S9_7 0.00876826f
C4639 S8 VDD 0.00785151f
C4640 S8 VSS_0 0.021249f
C4641 S8 VSS_1 3.3828e-05f
C4642 S8_1 S9_2 0.00497574f
C4643 S8_1 VDD 0.00445551f
C4644 S8_1 VSS_0 0.0120582f
C4645 S8_1 VSS_1 1.91964e-05f
C4646 S8_2 S9_6 0.0112335f
C4647 S8_2 VDD 0.010059f
C4648 S8_2 VSS_0 0.0272234f
C4649 S8_2 VSS_1 4.3339e-05f
C4650 S8_3 S9_6 0.0129364f
C4651 S8_3 VDD 0.0115838f
C4652 S8_3 VSS_0 0.03135f
C4653 S8_3 VSS_1 4.99085e-05f
C4654 S8_4 S9_6 0.00510564f
C4655 S8_4 VDD 0.00457183f
C4656 S8_4 VSS_0 0.012373f
C4657 S8_4 VSS_1 1.96976e-05f
C4658 S8_5 S9_7 0.00510564f
C4659 S8_5 VDD 0.00457183f
C4660 S8_5 VSS_0 0.012373f
C4661 S8_5 VSS_1 1.96976e-05f
C4662 S8_6 S9_6 0.0110938f
C4663 S8_6 VDD 0.00993387f
C4664 S8_6 VSS_0 0.0268846f
C4665 S8_6 VSS_1 4.27997e-05f
C4666 S8_7 S9_7 0.0110938f
C4667 S8_7 VDD 0.00993387f
C4668 S8_7 VSS_0 0.0268846f
C4669 S8_7 VSS_1 4.27997e-05f
C4670 S9 VDD 0.00765001f
C4671 S9 VSS_0 0.0213823f
C4672 S9_1 VDD 0.00434117f
C4673 S9_1 VSS_0 0.0121338f
C4674 S9_2 VDD 0.00980088f
C4675 S9_2 VSS_0 0.0273941f
C4676 S9_3 VDD 0.0112865f
C4677 S9_3 VSS_0 0.0315466f
C4678 S9_4 VDD 0.0044545f
C4679 S9_4 VSS_0 0.0124506f
C4680 S9_5 VDD 0.0044545f
C4681 S9_5 VSS_0 0.0124506f
C4682 S9_6 VDD 0.00967893f
C4683 S9_6 VSS_0 0.0270532f
C4684 S9_7 VDD 0.00967893f
C4685 S9_7 VSS_0 0.0270532f
C4686 VDD VSS_0 1.66619f
C4687 VDD VSS_1 0.0205133f
C4688 VSS_0 VSS_1 1.03819f
.ends
