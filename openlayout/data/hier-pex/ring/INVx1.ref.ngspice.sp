* INVx1 reference extraction (xAct3D) for ngspice, via tests/pex/bench/bench.py xact_spice
.subckt PMX_INVREF_A vss 22 10 16 9 3
c1 1 vss 0.00931856f
c2 3 vss 0.0887847f
c3 4 vss 0.00717846f
c4 5 vss 0.00115785f
c5 6 vss 0.00717846f
c6 7 vss 0.00713519f
c7 8 vss 0.00713519f
c8 9 vss 0.00205968f
r1 6 8 10.3626
r2 4 7 10.3626
r3 5 9 2.14265
r4 5 7 10.3626
r5 5 8 10.3626
r6 23 24 2.97317
r7 22 23 0.991056
r8 22 9 1.34084
r9 20 24 19.3796
r10 1 18 2.6116
r11 1 20 4.98695
r12 16 15 14.6259
r13 14 15 2.7211
r14 13 14 5.79936
r15 13 18 6.27904
r16 12 13 5.79936
r17 11 12 2.7211
r18 10 11 14.6259
r19 10 3 14.6259
.ends
.subckt PMX_INVREF_Y vss 17 13 25 11 8 7
c1 1 vss 0.00868151f
c2 2 vss 0.00868152f
c3 7 vss 0.0388431f
c4 8 vss 0.038846f
c5 9 vss 0.00593248f
c6 10 vss 0.0059601f
c7 11 vss 0.00585736f
r1 8 2 0.154321
r2 25 8 0.0308642
r3 2 22 19.3796
r4 22 23 3.14806
r5 10 20 10.3626
r6 10 23 1.96775
r7 19 20 11.5429
r8 18 19 3.38125
r9 17 18 1.39914
r10 17 11 8.16164
r11 11 16 8.96345
r12 15 16 1.96775
r13 14 15 3.14806
r14 9 14 2.68168
r15 1 14 19.3796
r16 7 1 0.154321
r17 13 7 0.0308642
.ends
.subckt INVREF VSS VDD A Y
NM0 N_M0_d N_M0_g VSS VSS nmos_rvt l=2e-08 nfin=3
NM1 N_M1_d N_M1_g VDD VDD pmos_rvt l=2e-08 nfin=3
x_PMX_INVREF_A vss A N_M0_g N_M1_g N_A_9 N_A_3 PMX_INVREF_A
x_PMX_INVREF_Y vss Y N_M0_d N_M1_d N_Y_11 N_Y_8 N_Y_7 PMX_INVREF_Y
cc_1 N_Y_11 N_A_9 0.00251825f
cc_2 N_Y_8 N_A_3 0.0149941f
cc_3 N_Y_7 N_A_3 0.0621639f
.ends
